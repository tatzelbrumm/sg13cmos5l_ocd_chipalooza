* NGSPICE file created from user_id_programming.ext - technology: ihp-sg13cmos5l

.subckt sg13cmos5l_tielo L_LO VDD VSS
X0 L_LO a_223_58# VSS VSS sg13_lv_nmos ad=0.2992p pd=2.44u as=0.60422p ps=3.6u w=0.88u l=0.13u
X1 VDD a_59_418# a_59_418# VDD sg13_lv_pmos ad=0.62572p pd=3.785u as=0.102p ps=1.28u w=0.3u l=0.13u
X2 a_223_58# a_59_195# VDD VDD sg13_lv_pmos ad=0.3553p pd=2.77u as=0.62572p ps=3.785u w=1.045u l=0.13u
X3 VSS a_59_418# a_59_195# VSS sg13_lv_nmos ad=0.60422p pd=3.6u as=0.1309p ps=1.45u w=0.385u l=0.13u
.ends

.subckt sg13cmos5l_decap_4 VDD VSS
X0 VDD VSS VDD VDD sg13_lv_pmos ad=0.34p pd=2.68u as=0 ps=0 w=1u l=1u
X1 VSS VDD VSS VSS sg13_lv_nmos ad=0.1428p pd=1.52u as=0 ps=0 w=0.42u l=1u
.ends

.subckt sg13cmos5l_tiehi L_HI VDD VSS
X0 L_HI a_222_366# VDD VDD sg13_lv_pmos ad=0.3927p pd=2.99u as=0.76727p ps=3.885u w=1.155u l=0.13u
X1 VDD a_23_195# a_23_429# VDD sg13_lv_pmos ad=0.76727p pd=3.885u as=0.2442p ps=2.06u w=0.66u l=0.13u
X2 a_222_366# a_23_429# VSS VSS sg13_lv_nmos ad=0.27427p pd=2.28u as=0.49637p ps=3.565u w=0.795u l=0.13u
X3 VSS a_23_195# a_23_195# VSS sg13_lv_nmos ad=0.49637p pd=3.565u as=0.111p ps=1.34u w=0.3u l=0.13u
.ends

.subckt user_id_programming mask_rev[0] mask_rev[1] mask_rev[2] mask_rev[3] mask_rev[4]
+ mask_rev[5] mask_rev[6] mask_rev[7] mask_rev[8] mask_rev[9] mask_rev[10] mask_rev[11]
+ mask_rev[12] mask_rev[13] mask_rev[14] mask_rev[15] mask_rev[16] mask_rev[17] mask_rev[18]
+ mask_rev[19] mask_rev[20] mask_rev[21] mask_rev[22] mask_rev[23] mask_rev[24] mask_rev[25]
+ mask_rev[26] mask_rev[27] mask_rev[28] mask_rev[29] mask_rev[30] mask_rev[31]
Xsg13cmos5l_tielo_24 mask_rev[15] sg13cmos5l_tielo_9/VDD sub sg13cmos5l_tielo
Xsg13cmos5l_tielo_13 mask_rev[26] sg13cmos5l_tielo_9/VDD sub sg13cmos5l_tielo
Xsg13cmos5l_tielo_25 mask_rev[13] sg13cmos5l_tielo_9/VDD sub sg13cmos5l_tielo
Xsg13cmos5l_tielo_14 mask_rev[28] sg13cmos5l_tielo_9/VDD sub sg13cmos5l_tielo
Xsg13cmos5l_decap_4_30 sg13cmos5l_tielo_9/VDD sub sg13cmos5l_decap_4
Xsg13cmos5l_tiehi_30 sg13cmos5l_tiehi_30/L_HI sg13cmos5l_tielo_9/VDD sub sg13cmos5l_tiehi
Xsg13cmos5l_tielo_26 mask_rev[11] sg13cmos5l_tielo_9/VDD sub sg13cmos5l_tielo
Xsg13cmos5l_tielo_15 mask_rev[30] sg13cmos5l_tielo_9/VDD sub sg13cmos5l_tielo
Xsg13cmos5l_decap_4_31 sg13cmos5l_tielo_9/VDD sub sg13cmos5l_decap_4
Xsg13cmos5l_tiehi_31 sg13cmos5l_tiehi_31/L_HI sg13cmos5l_tielo_9/VDD sub sg13cmos5l_tiehi
Xsg13cmos5l_tielo_27 mask_rev[9] sg13cmos5l_tielo_9/VDD sub sg13cmos5l_tielo
Xsg13cmos5l_tiehi_20 sg13cmos5l_tiehi_20/L_HI sg13cmos5l_tielo_9/VDD sub sg13cmos5l_tiehi
Xsg13cmos5l_tielo_16 mask_rev[31] sg13cmos5l_tielo_9/VDD sub sg13cmos5l_tielo
Xsg13cmos5l_decap_4_21 sg13cmos5l_tielo_9/VDD sub sg13cmos5l_decap_4
Xsg13cmos5l_decap_4_32 sg13cmos5l_tielo_9/VDD sub sg13cmos5l_decap_4
Xsg13cmos5l_decap_4_10 sg13cmos5l_tielo_9/VDD sub sg13cmos5l_decap_4
Xsg13cmos5l_tiehi_21 sg13cmos5l_tiehi_21/L_HI sg13cmos5l_tielo_9/VDD sub sg13cmos5l_tiehi
Xsg13cmos5l_tiehi_10 sg13cmos5l_tiehi_10/L_HI sg13cmos5l_tielo_9/VDD sub sg13cmos5l_tiehi
Xsg13cmos5l_tielo_28 mask_rev[7] sg13cmos5l_tielo_9/VDD sub sg13cmos5l_tielo
Xsg13cmos5l_tielo_17 mask_rev[29] sg13cmos5l_tielo_9/VDD sub sg13cmos5l_tielo
Xsg13cmos5l_decap_4_22 sg13cmos5l_tielo_9/VDD sub sg13cmos5l_decap_4
Xsg13cmos5l_decap_4_33 sg13cmos5l_tielo_9/VDD sub sg13cmos5l_decap_4
Xsg13cmos5l_decap_4_11 sg13cmos5l_tielo_9/VDD sub sg13cmos5l_decap_4
Xsg13cmos5l_tielo_29 mask_rev[5] sg13cmos5l_tielo_9/VDD sub sg13cmos5l_tielo
Xsg13cmos5l_tiehi_22 sg13cmos5l_tiehi_22/L_HI sg13cmos5l_tielo_9/VDD sub sg13cmos5l_tiehi
Xsg13cmos5l_tiehi_11 sg13cmos5l_tiehi_11/L_HI sg13cmos5l_tielo_9/VDD sub sg13cmos5l_tiehi
Xsg13cmos5l_tielo_18 mask_rev[27] sg13cmos5l_tielo_9/VDD sub sg13cmos5l_tielo
Xsg13cmos5l_decap_4_34 sg13cmos5l_tielo_9/VDD sub sg13cmos5l_decap_4
Xsg13cmos5l_decap_4_12 sg13cmos5l_tielo_9/VDD sub sg13cmos5l_decap_4
Xsg13cmos5l_decap_4_23 sg13cmos5l_tielo_9/VDD sub sg13cmos5l_decap_4
Xsg13cmos5l_tiehi_23 sg13cmos5l_tiehi_23/L_HI sg13cmos5l_tielo_9/VDD sub sg13cmos5l_tiehi
Xsg13cmos5l_tiehi_12 sg13cmos5l_tiehi_12/L_HI sg13cmos5l_tielo_9/VDD sub sg13cmos5l_tiehi
Xsg13cmos5l_tielo_19 mask_rev[25] sg13cmos5l_tielo_9/VDD sub sg13cmos5l_tielo
Xsg13cmos5l_decap_4_35 sg13cmos5l_tielo_9/VDD sub sg13cmos5l_decap_4
Xsg13cmos5l_decap_4_13 sg13cmos5l_tielo_9/VDD sub sg13cmos5l_decap_4
Xsg13cmos5l_decap_4_24 sg13cmos5l_tielo_9/VDD sub sg13cmos5l_decap_4
Xsg13cmos5l_tiehi_24 sg13cmos5l_tiehi_24/L_HI sg13cmos5l_tielo_9/VDD sub sg13cmos5l_tiehi
Xsg13cmos5l_tiehi_13 sg13cmos5l_tiehi_13/L_HI sg13cmos5l_tielo_9/VDD sub sg13cmos5l_tiehi
Xsg13cmos5l_decap_4_36 sg13cmos5l_tielo_9/VDD sub sg13cmos5l_decap_4
Xsg13cmos5l_tiehi_25 sg13cmos5l_tiehi_25/L_HI sg13cmos5l_tielo_9/VDD sub sg13cmos5l_tiehi
Xsg13cmos5l_decap_4_25 sg13cmos5l_tielo_9/VDD sub sg13cmos5l_decap_4
Xsg13cmos5l_decap_4_14 sg13cmos5l_tielo_9/VDD sub sg13cmos5l_decap_4
Xsg13cmos5l_tiehi_14 sg13cmos5l_tiehi_14/L_HI sg13cmos5l_tielo_9/VDD sub sg13cmos5l_tiehi
Xsg13cmos5l_decap_4_37 sg13cmos5l_tielo_9/VDD sub sg13cmos5l_decap_4
Xsg13cmos5l_decap_4_26 sg13cmos5l_tielo_9/VDD sub sg13cmos5l_decap_4
Xsg13cmos5l_decap_4_15 sg13cmos5l_tielo_9/VDD sub sg13cmos5l_decap_4
Xsg13cmos5l_tiehi_15 sg13cmos5l_tiehi_15/L_HI sg13cmos5l_tielo_9/VDD sub sg13cmos5l_tiehi
Xsg13cmos5l_tiehi_26 sg13cmos5l_tiehi_26/L_HI sg13cmos5l_tielo_9/VDD sub sg13cmos5l_tiehi
Xsg13cmos5l_tiehi_16 sg13cmos5l_tiehi_16/L_HI sg13cmos5l_tielo_9/VDD sub sg13cmos5l_tiehi
Xsg13cmos5l_decap_4_38 sg13cmos5l_tielo_9/VDD sub sg13cmos5l_decap_4
Xsg13cmos5l_tiehi_27 sg13cmos5l_tiehi_27/L_HI sg13cmos5l_tielo_9/VDD sub sg13cmos5l_tiehi
Xsg13cmos5l_decap_4_27 sg13cmos5l_tielo_9/VDD sub sg13cmos5l_decap_4
Xsg13cmos5l_decap_4_16 sg13cmos5l_tielo_9/VDD sub sg13cmos5l_decap_4
Xsg13cmos5l_decap_4_17 sg13cmos5l_tielo_9/VDD sub sg13cmos5l_decap_4
Xsg13cmos5l_decap_4_39 sg13cmos5l_tielo_9/VDD sub sg13cmos5l_decap_4
Xsg13cmos5l_decap_4_28 sg13cmos5l_tielo_9/VDD sub sg13cmos5l_decap_4
Xsg13cmos5l_tiehi_28 sg13cmos5l_tiehi_28/L_HI sg13cmos5l_tielo_9/VDD sub sg13cmos5l_tiehi
Xsg13cmos5l_tiehi_17 sg13cmos5l_tiehi_17/L_HI sg13cmos5l_tielo_9/VDD sub sg13cmos5l_tiehi
Xsg13cmos5l_decap_4_18 sg13cmos5l_tielo_9/VDD sub sg13cmos5l_decap_4
Xsg13cmos5l_tiehi_29 sg13cmos5l_tiehi_29/L_HI sg13cmos5l_tielo_9/VDD sub sg13cmos5l_tiehi
Xsg13cmos5l_decap_4_29 sg13cmos5l_tielo_9/VDD sub sg13cmos5l_decap_4
Xsg13cmos5l_tiehi_18 sg13cmos5l_tiehi_18/L_HI sg13cmos5l_tielo_9/VDD sub sg13cmos5l_tiehi
Xsg13cmos5l_tiehi_19 sg13cmos5l_tiehi_19/L_HI sg13cmos5l_tielo_9/VDD sub sg13cmos5l_tiehi
Xsg13cmos5l_tiehi_0 sg13cmos5l_tiehi_0/L_HI sg13cmos5l_tielo_9/VDD sub sg13cmos5l_tiehi
Xsg13cmos5l_tiehi_1 sg13cmos5l_tiehi_1/L_HI sg13cmos5l_tielo_9/VDD sub sg13cmos5l_tiehi
Xsg13cmos5l_tiehi_2 sg13cmos5l_tiehi_2/L_HI sg13cmos5l_tielo_9/VDD sub sg13cmos5l_tiehi
Xsg13cmos5l_tiehi_3 sg13cmos5l_tiehi_3/L_HI sg13cmos5l_tielo_9/VDD sub sg13cmos5l_tiehi
Xsg13cmos5l_tielo_0 mask_rev[0] sg13cmos5l_tielo_9/VDD sub sg13cmos5l_tielo
Xsg13cmos5l_tiehi_4 sg13cmos5l_tiehi_4/L_HI sg13cmos5l_tielo_9/VDD sub sg13cmos5l_tiehi
Xsg13cmos5l_tielo_1 mask_rev[2] sg13cmos5l_tielo_9/VDD sub sg13cmos5l_tielo
Xsg13cmos5l_tiehi_5 sg13cmos5l_tiehi_5/L_HI sg13cmos5l_tielo_9/VDD sub sg13cmos5l_tiehi
Xsg13cmos5l_decap_4_0 sg13cmos5l_tielo_9/VDD sub sg13cmos5l_decap_4
Xsg13cmos5l_tielo_2 mask_rev[4] sg13cmos5l_tielo_9/VDD sub sg13cmos5l_tielo
Xsg13cmos5l_tiehi_6 sg13cmos5l_tiehi_6/L_HI sg13cmos5l_tielo_9/VDD sub sg13cmos5l_tiehi
Xsg13cmos5l_decap_4_1 sg13cmos5l_tielo_9/VDD sub sg13cmos5l_decap_4
Xsg13cmos5l_tielo_3 mask_rev[6] sg13cmos5l_tielo_9/VDD sub sg13cmos5l_tielo
Xsg13cmos5l_tiehi_7 sg13cmos5l_tiehi_7/L_HI sg13cmos5l_tielo_9/VDD sub sg13cmos5l_tiehi
Xsg13cmos5l_decap_4_2 sg13cmos5l_tielo_9/VDD sub sg13cmos5l_decap_4
Xsg13cmos5l_tielo_4 mask_rev[8] sg13cmos5l_tielo_9/VDD sub sg13cmos5l_tielo
Xsg13cmos5l_tiehi_8 sg13cmos5l_tiehi_8/L_HI sg13cmos5l_tielo_9/VDD sub sg13cmos5l_tiehi
Xsg13cmos5l_decap_4_3 sg13cmos5l_tielo_9/VDD sub sg13cmos5l_decap_4
Xsg13cmos5l_tielo_5 mask_rev[10] sg13cmos5l_tielo_9/VDD sub sg13cmos5l_tielo
Xsg13cmos5l_tiehi_9 sg13cmos5l_tiehi_9/L_HI sg13cmos5l_tielo_9/VDD sub sg13cmos5l_tiehi
Xsg13cmos5l_decap_4_4 sg13cmos5l_tielo_9/VDD sub sg13cmos5l_decap_4
Xsg13cmos5l_tielo_6 mask_rev[12] sg13cmos5l_tielo_9/VDD sub sg13cmos5l_tielo
Xsg13cmos5l_decap_4_5 sg13cmos5l_tielo_9/VDD sub sg13cmos5l_decap_4
Xsg13cmos5l_tielo_7 mask_rev[14] sg13cmos5l_tielo_9/VDD sub sg13cmos5l_tielo
Xsg13cmos5l_decap_4_6 sg13cmos5l_tielo_9/VDD sub sg13cmos5l_decap_4
Xsg13cmos5l_tielo_8 mask_rev[16] sg13cmos5l_tielo_9/VDD sub sg13cmos5l_tielo
Xsg13cmos5l_tielo_30 mask_rev[3] sg13cmos5l_tielo_9/VDD sub sg13cmos5l_tielo
Xsg13cmos5l_decap_4_7 sg13cmos5l_tielo_9/VDD sub sg13cmos5l_decap_4
Xsg13cmos5l_tielo_9 mask_rev[18] sg13cmos5l_tielo_9/VDD sub sg13cmos5l_tielo
Xsg13cmos5l_tielo_31 mask_rev[1] sg13cmos5l_tielo_9/VDD sub sg13cmos5l_tielo
Xsg13cmos5l_decap_4_8 sg13cmos5l_tielo_9/VDD sub sg13cmos5l_decap_4
Xsg13cmos5l_tielo_20 mask_rev[23] sg13cmos5l_tielo_9/VDD sub sg13cmos5l_tielo
Xsg13cmos5l_decap_4_9 sg13cmos5l_tielo_9/VDD sub sg13cmos5l_decap_4
Xsg13cmos5l_tielo_21 mask_rev[21] sg13cmos5l_tielo_9/VDD sub sg13cmos5l_tielo
Xsg13cmos5l_tielo_10 mask_rev[20] sg13cmos5l_tielo_9/VDD sub sg13cmos5l_tielo
Xsg13cmos5l_tielo_22 mask_rev[19] sg13cmos5l_tielo_9/VDD sub sg13cmos5l_tielo
Xsg13cmos5l_tielo_11 mask_rev[22] sg13cmos5l_tielo_9/VDD sub sg13cmos5l_tielo
Xsg13cmos5l_tielo_23 mask_rev[17] sg13cmos5l_tielo_9/VDD sub sg13cmos5l_tielo
Xsg13cmos5l_tielo_12 mask_rev[24] sg13cmos5l_tielo_9/VDD sub sg13cmos5l_tielo
.ends
