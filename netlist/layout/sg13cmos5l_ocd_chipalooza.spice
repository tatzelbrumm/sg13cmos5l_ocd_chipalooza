* NGSPICE file created from sg13cmos5l_ocd_chipalooza.ext - technology: ihp-sg13cmos5l

.subckt sg13cmos5l_SecondaryProtection core pad iovss iovdd
X0 core iovdd dpantenna l=0.64u w=4.98u
X1 core pad iovss rppd l=2u w=1u
X2 iovss core dantenna l=3.1u w=0.64u
.ends

.subckt sg13cmos5l_DCPDiode anode cathode guard anode_uq0
X0 anode_uq0 cathode dpantenna l=1.26u w=27.78u
X1 anode cathode dpantenna l=1.26u w=27.78u
.ends

.subckt sg13cmos5l_Clamp_P20N0D iovdd iovss pad pad_uq0 pad_uq1 pad_uq2 pad_uq3 pad_uq4
+ pad_uq5 pad_uq6 pad_uq7 pad_uq8
X0 iovdd a_5044_476# pad_uq3 iovdd sg13_hv_pmos ad=2.1312p pd=7.3u as=3.9294p ps=7.84u w=6.66u l=0.6u
X1 pad_uq5 a_5044_476# iovdd iovdd sg13_hv_pmos ad=3.9294p pd=7.84u as=2.1312p ps=7.3u w=6.66u l=0.6u
X2 iovdd a_5044_476# pad_uq1 iovdd sg13_hv_pmos ad=2.1312p pd=7.3u as=3.9294p ps=7.84u w=6.66u l=0.6u
X3 pad_uq7 a_5044_476# iovdd iovdd sg13_hv_pmos ad=3.9294p pd=7.84u as=2.1312p ps=7.3u w=6.66u l=0.6u
X4 pad_uq6 a_5044_476# iovdd iovdd sg13_hv_pmos ad=3.9294p pd=7.84u as=2.1312p ps=7.3u w=6.66u l=0.6u
X5 iovdd a_5044_476# pad_uq2 iovdd sg13_hv_pmos ad=2.1312p pd=7.3u as=3.9294p ps=7.84u w=6.66u l=0.6u
X6 a_5044_476# iovdd iovdd rppd l=12.9u w=0.5u
X7 pad_uq6 a_5044_476# iovdd iovdd sg13_hv_pmos ad=3.9294p pd=7.84u as=2.1312p ps=7.3u w=6.66u l=0.6u
X8 iovdd a_5044_476# pad_uq6 iovdd sg13_hv_pmos ad=2.1312p pd=7.3u as=3.9294p ps=7.84u w=6.66u l=0.6u
X9 pad_uq2 a_5044_476# iovdd iovdd sg13_hv_pmos ad=3.9294p pd=7.84u as=2.1312p ps=7.3u w=6.66u l=0.6u
X10 iovdd a_5044_476# pad iovdd sg13_hv_pmos ad=2.1312p pd=7.3u as=3.9294p ps=7.84u w=6.66u l=0.6u
X11 iovdd a_5044_476# pad_uq6 iovdd sg13_hv_pmos ad=2.1312p pd=7.3u as=3.9294p ps=7.84u w=6.66u l=0.6u
X12 pad_uq2 a_5044_476# iovdd iovdd sg13_hv_pmos ad=3.9294p pd=7.84u as=2.1312p ps=7.3u w=6.66u l=0.6u
X13 iovdd a_5044_476# pad_uq5 iovdd sg13_hv_pmos ad=2.1312p pd=7.3u as=3.9294p ps=7.84u w=6.66u l=0.6u
X14 iovdd a_5044_476# pad_uq1 iovdd sg13_hv_pmos ad=2.1312p pd=7.3u as=3.9294p ps=7.84u w=6.66u l=0.6u
X15 pad_uq3 a_5044_476# iovdd iovdd sg13_hv_pmos ad=3.9294p pd=7.84u as=2.1312p ps=7.3u w=6.66u l=0.6u
X16 pad_uq1 a_5044_476# iovdd iovdd sg13_hv_pmos ad=3.9294p pd=7.84u as=2.1312p ps=7.3u w=6.66u l=0.6u
X17 iovdd a_5044_476# pad_uq7 iovdd sg13_hv_pmos ad=2.1312p pd=7.3u as=3.9294p ps=7.84u w=6.66u l=0.6u
X18 pad_uq0 a_5044_476# iovdd iovdd sg13_hv_pmos ad=3.9294p pd=7.84u as=2.1312p ps=7.3u w=6.66u l=0.6u
X19 iovdd a_5044_476# pad_uq3 iovdd sg13_hv_pmos ad=2.1312p pd=7.3u as=3.9294p ps=7.84u w=6.66u l=0.6u
X20 pad_uq7 a_5044_476# iovdd iovdd sg13_hv_pmos ad=3.9294p pd=7.84u as=2.1312p ps=7.3u w=6.66u l=0.6u
X21 iovdd a_5044_476# pad_uq0 iovdd sg13_hv_pmos ad=3.1302p pd=14.26u as=3.9294p ps=7.84u w=6.66u l=0.6u
X22 pad_uq8 a_5044_476# iovdd iovdd sg13_hv_pmos ad=3.9294p pd=7.84u as=3.1302p ps=14.26u w=6.66u l=0.6u
X23 pad_uq8 a_5044_476# iovdd iovdd sg13_hv_pmos ad=3.9294p pd=7.84u as=3.1302p ps=14.26u w=6.66u l=0.6u
X24 iovdd a_5044_476# pad iovdd sg13_hv_pmos ad=2.1312p pd=7.3u as=3.9294p ps=7.84u w=6.66u l=0.6u
X25 pad_uq4 a_5044_476# iovdd iovdd sg13_hv_pmos ad=3.9294p pd=7.84u as=2.1312p ps=7.3u w=6.66u l=0.6u
X26 iovdd a_5044_476# pad_uq7 iovdd sg13_hv_pmos ad=2.1312p pd=7.3u as=3.9294p ps=7.84u w=6.66u l=0.6u
X27 pad_uq3 a_5044_476# iovdd iovdd sg13_hv_pmos ad=3.9294p pd=7.84u as=2.1312p ps=7.3u w=6.66u l=0.6u
X28 iovdd a_5044_476# pad_uq8 iovdd sg13_hv_pmos ad=2.1312p pd=7.3u as=3.9294p ps=7.84u w=6.66u l=0.6u
X29 pad_uq5 a_5044_476# iovdd iovdd sg13_hv_pmos ad=3.9294p pd=7.84u as=2.1312p ps=7.3u w=6.66u l=0.6u
X30 pad_uq0 a_5044_476# iovdd iovdd sg13_hv_pmos ad=3.9294p pd=7.84u as=2.1312p ps=7.3u w=6.66u l=0.6u
X31 iovdd a_5044_476# pad_uq0 iovdd sg13_hv_pmos ad=3.1302p pd=14.26u as=3.9294p ps=7.84u w=6.66u l=0.6u
X32 pad a_5044_476# iovdd iovdd sg13_hv_pmos ad=3.9294p pd=7.84u as=2.1312p ps=7.3u w=6.66u l=0.6u
X33 iovdd a_5044_476# pad_uq8 iovdd sg13_hv_pmos ad=2.1312p pd=7.3u as=3.9294p ps=7.84u w=6.66u l=0.6u
X34 iovdd a_5044_476# pad_uq4 iovdd sg13_hv_pmos ad=2.1312p pd=7.3u as=3.9294p ps=7.84u w=6.66u l=0.6u
X35 iovdd a_5044_476# pad_uq2 iovdd sg13_hv_pmos ad=2.1312p pd=7.3u as=3.9294p ps=7.84u w=6.66u l=0.6u
X36 iovdd a_5044_476# pad_uq4 iovdd sg13_hv_pmos ad=2.1312p pd=7.3u as=3.9294p ps=7.84u w=6.66u l=0.6u
X37 pad_uq4 a_5044_476# iovdd iovdd sg13_hv_pmos ad=3.9294p pd=7.84u as=2.1312p ps=7.3u w=6.66u l=0.6u
X38 pad a_5044_476# iovdd iovdd sg13_hv_pmos ad=3.9294p pd=7.84u as=2.1312p ps=7.3u w=6.66u l=0.6u
X39 iovdd a_5044_476# pad_uq5 iovdd sg13_hv_pmos ad=2.1312p pd=7.3u as=3.9294p ps=7.84u w=6.66u l=0.6u
X40 pad_uq1 a_5044_476# iovdd iovdd sg13_hv_pmos ad=3.9294p pd=7.84u as=2.1312p ps=7.3u w=6.66u l=0.6u
.ends

.subckt sg13cmos5l_DCNDiode anode cathode guard cathode_uq0
X0 anode cathode_uq0 dantenna l=1.26u w=27.78u
X1 anode cathode dantenna l=1.26u w=27.78u
.ends

.subckt sg13cmos5l_Clamp_N20N0D iovss pad pad_uq0 pad_uq1 pad_uq2 pad_uq3 pad_uq4
+ pad_uq5 pad_uq6 pad_uq7 pad_uq8 w_n124_n124#
X0 pad_uq5 a_5044_476# iovss iovss sg13_hv_nmos ad=2.596p pd=5.58u as=1.408p ps=5.04u w=4.4u l=0.6u
X1 iovss a_5044_476# pad_uq1 iovss sg13_hv_nmos ad=1.408p pd=5.04u as=2.596p ps=5.58u w=4.4u l=0.6u
X2 pad_uq6 a_5044_476# iovss iovss sg13_hv_nmos ad=2.596p pd=5.58u as=1.408p ps=5.04u w=4.4u l=0.6u
X3 iovss a_5044_476# pad_uq2 iovss sg13_hv_nmos ad=1.408p pd=5.04u as=2.596p ps=5.58u w=4.4u l=0.6u
X4 a_5044_476# iovss iovss rppd l=3.54u w=0.5u
X5 iovss a_5044_476# pad_uq6 iovss sg13_hv_nmos ad=1.408p pd=5.04u as=2.596p ps=5.58u w=4.4u l=0.6u
X6 pad_uq2 a_5044_476# iovss iovss sg13_hv_nmos ad=2.596p pd=5.58u as=1.408p ps=5.04u w=4.4u l=0.6u
X7 pad_uq3 a_5044_476# iovss iovss sg13_hv_nmos ad=2.596p pd=5.58u as=1.408p ps=5.04u w=4.4u l=0.6u
X8 iovss a_5044_476# pad_uq7 iovss sg13_hv_nmos ad=1.408p pd=5.04u as=2.596p ps=5.58u w=4.4u l=0.6u
X9 pad_uq0 a_5044_476# iovss iovss sg13_hv_nmos ad=2.596p pd=5.58u as=1.408p ps=5.04u w=4.4u l=0.6u
X10 iovss a_5044_476# pad_uq3 iovss sg13_hv_nmos ad=1.408p pd=5.04u as=2.596p ps=5.58u w=4.4u l=0.6u
X11 pad_uq7 a_5044_476# iovss iovss sg13_hv_nmos ad=2.596p pd=5.58u as=1.408p ps=5.04u w=4.4u l=0.6u
X12 iovss a_5044_476# pad_uq0 iovss sg13_hv_nmos ad=2.068p pd=9.74u as=2.596p ps=5.58u w=4.4u l=0.6u
X13 pad_uq8 a_5044_476# iovss iovss sg13_hv_nmos ad=2.596p pd=5.58u as=2.068p ps=9.74u w=4.4u l=0.6u
X14 iovss a_5044_476# pad iovss sg13_hv_nmos ad=1.408p pd=5.04u as=2.596p ps=5.58u w=4.4u l=0.6u
X15 pad_uq4 a_5044_476# iovss iovss sg13_hv_nmos ad=2.596p pd=5.58u as=1.408p ps=5.04u w=4.4u l=0.6u
X16 iovss a_5044_476# pad_uq8 iovss sg13_hv_nmos ad=1.408p pd=5.04u as=2.596p ps=5.58u w=4.4u l=0.6u
X17 pad a_5044_476# iovss iovss sg13_hv_nmos ad=2.596p pd=5.58u as=1.408p ps=5.04u w=4.4u l=0.6u
X18 iovss a_5044_476# pad_uq4 iovss sg13_hv_nmos ad=1.408p pd=5.04u as=2.596p ps=5.58u w=4.4u l=0.6u
X19 iovss a_5044_476# pad_uq5 iovss sg13_hv_nmos ad=1.408p pd=5.04u as=2.596p ps=5.58u w=4.4u l=0.6u
X20 pad_uq1 a_5044_476# iovss iovss sg13_hv_nmos ad=2.596p pd=5.58u as=1.408p ps=5.04u w=4.4u l=0.6u
.ends

.subckt sg13cmos5l_IOPadAnalog pad padres vdd iovdd iovss iovdd_uq0 sg13cmos5l_DCNDiode_0/guard
+ vss
Xsg13cmos5l_SecondaryProtection_0 padres pad vss iovdd sg13cmos5l_SecondaryProtection
Xsg13cmos5l_DCPDiode_0 pad iovdd_uq0 vss pad sg13cmos5l_DCPDiode
Xsg13cmos5l_Clamp_P20N0D_0 iovdd_uq0 vss pad pad pad pad pad pad pad pad pad pad sg13cmos5l_Clamp_P20N0D
Xsg13cmos5l_DCNDiode_0 vss pad sg13cmos5l_DCNDiode_0/guard pad sg13cmos5l_DCNDiode
Xsg13cmos5l_Clamp_N20N0D_0 vss pad pad pad pad pad pad pad pad pad pad sg13cmos5l_DCNDiode_0/guard
+ sg13cmos5l_Clamp_N20N0D
.ends

.subckt sg13cmos5l_IOPadVss vdd vss iovdd sg13cmos5l_DCNDiode_0/guard
Xsg13cmos5l_DCPDiode_0 vss iovdd vss vss sg13cmos5l_DCPDiode
Xsg13cmos5l_DCNDiode_0 vss vss sg13cmos5l_DCNDiode_0/guard vss sg13cmos5l_DCNDiode
.ends

.subckt sg13cmos5l_Clamp_P8N8D gate iovdd iovss pad pad_uq0 pad_uq1 pad_uq2
X0 iovdd gate pad iovdd sg13_hv_pmos ad=2.1312p pd=7.3u as=3.9294p ps=7.84u w=6.66u l=0.6u
X1 pad_uq2 gate iovdd iovdd sg13_hv_pmos ad=3.9294p pd=7.84u as=3.1302p ps=14.26u w=6.66u l=0.6u
X2 iovdd gate pad_uq0 iovdd sg13_hv_pmos ad=3.1302p pd=14.26u as=3.9294p ps=7.84u w=6.66u l=0.6u
X3 gate iovdd dpantenna l=0.48u w=0.48u
X4 pad_uq0 gate iovdd iovdd sg13_hv_pmos ad=3.9294p pd=7.84u as=2.1312p ps=7.3u w=6.66u l=0.6u
X5 pad_uq0 gate iovdd iovdd sg13_hv_pmos ad=3.9294p pd=7.84u as=2.1312p ps=7.3u w=6.66u l=0.6u
X6 iovdd gate pad_uq2 iovdd sg13_hv_pmos ad=2.1312p pd=7.3u as=3.9294p ps=7.84u w=6.66u l=0.6u
X7 pad gate iovdd iovdd sg13_hv_pmos ad=3.9294p pd=7.84u as=2.1312p ps=7.3u w=6.66u l=0.6u
X8 iovdd gate pad iovdd sg13_hv_pmos ad=2.1312p pd=7.3u as=3.9294p ps=7.84u w=6.66u l=0.6u
X9 pad_uq1 gate iovdd iovdd sg13_hv_pmos ad=3.9294p pd=7.84u as=2.1312p ps=7.3u w=6.66u l=0.6u
X10 pad gate iovdd iovdd sg13_hv_pmos ad=3.9294p pd=7.84u as=2.1312p ps=7.3u w=6.66u l=0.6u
X11 pad_uq2 gate iovdd iovdd sg13_hv_pmos ad=3.9294p pd=7.84u as=3.1302p ps=14.26u w=6.66u l=0.6u
X12 iovdd gate pad_uq1 iovdd sg13_hv_pmos ad=2.1312p pd=7.3u as=3.9294p ps=7.84u w=6.66u l=0.6u
X13 iovdd gate pad_uq0 iovdd sg13_hv_pmos ad=3.1302p pd=14.26u as=3.9294p ps=7.84u w=6.66u l=0.6u
X14 iovdd gate pad_uq1 iovdd sg13_hv_pmos ad=2.1312p pd=7.3u as=3.9294p ps=7.84u w=6.66u l=0.6u
X15 pad_uq1 gate iovdd iovdd sg13_hv_pmos ad=3.9294p pd=7.84u as=2.1312p ps=7.3u w=6.66u l=0.6u
X16 iovdd gate pad_uq2 iovdd sg13_hv_pmos ad=2.1312p pd=7.3u as=3.9294p ps=7.84u w=6.66u l=0.6u
.ends

.subckt sg13cmos5l_Clamp_N8N8D gate iovss pad pad_uq0 pad_uq1 pad_uq2 w_n124_n124#
X0 pad_uq2 gate iovss iovss sg13_hv_nmos ad=2.596p pd=5.58u as=2.068p ps=9.74u w=4.4u l=0.6u
X1 iovss gate pad_uq0 iovss sg13_hv_nmos ad=2.068p pd=9.74u as=2.596p ps=5.58u w=4.4u l=0.6u
X2 iovss gate dantenna l=0.78u w=0.78u
X3 pad_uq0 gate iovss iovss sg13_hv_nmos ad=2.596p pd=5.58u as=1.408p ps=5.04u w=4.4u l=0.6u
X4 pad gate iovss iovss sg13_hv_nmos ad=2.596p pd=5.58u as=1.408p ps=5.04u w=4.4u l=0.6u
X5 iovss gate pad iovss sg13_hv_nmos ad=1.408p pd=5.04u as=2.596p ps=5.58u w=4.4u l=0.6u
X6 pad_uq1 gate iovss iovss sg13_hv_nmos ad=2.596p pd=5.58u as=1.408p ps=5.04u w=4.4u l=0.6u
X7 iovss gate pad_uq1 iovss sg13_hv_nmos ad=1.408p pd=5.04u as=2.596p ps=5.58u w=4.4u l=0.6u
X8 iovss gate pad_uq2 iovss sg13_hv_nmos ad=1.408p pd=5.04u as=2.596p ps=5.58u w=4.4u l=0.6u
.ends

.subckt sg13g2_SecondaryProtection plus minus core pad
X0 core plus dpantenna l=0.64u w=4.98u
X1 core pad minus rppd l=2u w=1u
X2 minus core dantenna l=3.1u w=0.64u
.ends

.subckt sg13cmos5l_LevelDown core pad vdd a_1826_n1666# vss iovdd
Xsg13g2_SecondaryProtection_0 iovdd vss sg13g2_SecondaryProtection_0/core pad sg13g2_SecondaryProtection
X0 vss sg13g2_SecondaryProtection_0/core a_525_1768# vss sg13_hv_nmos ad=0.247p pd=1.68u as=0.442p ps=3.28u w=1.3u l=0.45u
X1 a_359_1768# a_525_1768# iovdd iovdd sg13_hv_pmos ad=0.437p pd=2.68u as=0.437p ps=2.68u w=2.3u l=0.45u
X2 a_525_1768# sg13g2_SecondaryProtection_0/core iovdd iovdd sg13_hv_pmos ad=0.437p pd=2.68u as=0.782p ps=5.28u w=2.3u l=0.45u
X3 vdd a_89_1790# core vdd sg13_lv_pmos ad=1.615p pd=10.18u as=1.615p ps=10.18u w=4.75u l=0.13u
X4 a_89_1790# a_359_1768# vss vss sg13_hv_nmos ad=0.5035p pd=3.03u as=0.901p ps=5.98u w=2.65u l=0.45u
X5 vss a_89_1790# core vss sg13_lv_nmos ad=0.935p pd=6.18u as=0.935p ps=6.18u w=2.75u l=0.13u
X6 iovdd sg13g2_SecondaryProtection_0/core a_525_1768# iovdd sg13_hv_pmos ad=0.437p pd=2.68u as=0.437p ps=2.68u w=2.3u l=0.45u
X7 iovdd a_525_1768# a_359_1768# iovdd sg13_hv_pmos ad=0.782p pd=5.28u as=0.437p ps=2.68u w=2.3u l=0.45u
X8 a_359_1768# a_525_1768# vss vss sg13_hv_nmos ad=0.442p pd=3.28u as=0.247p ps=1.68u w=1.3u l=0.45u
X9 vdd a_525_1768# a_89_1790# vss sg13_hv_nmos ad=0.901p pd=5.98u as=0.5035p ps=3.03u w=2.65u l=0.45u
X10 vdd vdd vdd vdd sg13_hv_pmos ad=1.581p pd=9.98u as=0 ps=0 w=4.65u l=0.45u
.ends

.subckt sg13cmos5l_io_inv_x1 nq i vdd vss
X0 nq i vss vss sg13_lv_nmos ad=1.3362p pd=8.54u as=1.3362p ps=8.54u w=3.93u l=0.13u
X1 nq i vdd vdd sg13_lv_pmos ad=1.4994p pd=9.5u as=1.4994p ps=9.5u w=4.41u l=0.13u
.ends

.subckt sg13cmos5l_LevelUp o i iovdd vdd vss
X0 a_89_470# i vss vss sg13_hv_nmos ad=0.646p pd=4.48u as=0.361p ps=2.28u w=1.9u l=0.45u
X1 iovdd a_89_470# a_21_506# iovdd sg13_hv_pmos ad=57f pd=0.68u as=0.102p ps=1.28u w=0.3u l=0.45u
X2 vdd i a_21_1826# vdd sg13_lv_pmos ad=1.615p pd=10.18u as=1.615p ps=10.18u w=4.75u l=0.13u
X3 a_89_470# a_21_506# iovdd iovdd sg13_hv_pmos ad=0.102p pd=1.28u as=57f ps=0.68u w=0.3u l=0.45u
X4 vss i a_21_1826# vss sg13_lv_nmos ad=0.935p pd=6.18u as=0.935p ps=6.18u w=2.75u l=0.13u
X5 vss a_21_1826# a_21_506# vss sg13_hv_nmos ad=0.361p pd=2.28u as=0.646p ps=4.48u w=1.9u l=0.45u
X6 o a_89_470# vss vss sg13_hv_nmos ad=0.646p pd=4.48u as=0.646p ps=4.48u w=1.9u l=0.45u
X7 o a_89_470# iovdd iovdd sg13_hv_pmos ad=1.326p pd=8.48u as=1.326p ps=8.48u w=3.9u l=0.45u
.ends

.subckt sg13cmos5l_io_nor2_x1 nq i0 i1 vdd vss
X0 vss i1 nq vss sg13_lv_nmos ad=1.4148p pd=8.58u as=0.7467p ps=4.31u w=3.93u l=0.13u
X1 nq i0 vss vss sg13_lv_nmos ad=0.7467p pd=4.31u as=1.3362p ps=8.54u w=3.93u l=0.13u
X2 nq i1 a_115_1276# vdd sg13_lv_pmos ad=1.5876p pd=9.54u as=0.8379p ps=4.79u w=4.41u l=0.13u
X3 a_115_1276# i0 vdd vdd sg13_lv_pmos ad=0.8379p pd=4.79u as=1.4994p ps=9.5u w=4.41u l=0.13u
.ends

.subckt sg13cmos5l_io_nand2_x1 nq i0 i1 vdd vss
X0 nq i1 a_115_242# vss sg13_lv_nmos ad=1.4148p pd=8.58u as=0.7467p ps=4.31u w=3.93u l=0.13u
X1 a_115_242# i0 vss vss sg13_lv_nmos ad=0.7467p pd=4.31u as=1.3362p ps=8.54u w=3.93u l=0.13u
X2 vdd i1 nq vdd sg13_lv_pmos ad=1.5876p pd=9.54u as=0.8379p ps=4.79u w=4.41u l=0.13u
X3 nq i0 vdd vdd sg13_lv_pmos ad=0.8379p pd=4.79u as=1.4994p ps=9.5u w=4.41u l=0.13u
.ends

.subckt sg13cmos5l_GateDecode ngate pgate core en iovdd vdd vss
Xsg13cmos5l_io_inv_x1_0 sg13cmos5l_io_inv_x1_0/nq en vdd vss sg13cmos5l_io_inv_x1
Xsg13cmos5l_LevelUp_0 pgate sg13cmos5l_LevelUp_0/i iovdd vdd vss sg13cmos5l_LevelUp
Xsg13cmos5l_LevelUp_1 ngate sg13cmos5l_LevelUp_1/i iovdd vdd vss sg13cmos5l_LevelUp
Xsg13cmos5l_io_nor2_x1_0 sg13cmos5l_LevelUp_1/i core sg13cmos5l_io_inv_x1_0/nq vdd
+ vss sg13cmos5l_io_nor2_x1
Xsg13cmos5l_io_nand2_x1_0 sg13cmos5l_LevelUp_0/i core en vdd vss sg13cmos5l_io_nand2_x1
.ends

.subckt sg13cmos5l_IOPadInOut16mA pad p2c vdd iovdd iovss iovdd_uq0 c2p_en c2p sg13cmos5l_DCNDiode_0/guard
+ vss
Xsg13cmos5l_DCPDiode_0 pad iovdd_uq0 vss pad sg13cmos5l_DCPDiode
Xsg13cmos5l_Clamp_P8N8D_0 sg13cmos5l_GateDecode_0/pgate iovdd_uq0 vss pad pad pad
+ pad sg13cmos5l_Clamp_P8N8D
Xsg13cmos5l_Clamp_N8N8D_0 sg13cmos5l_GateDecode_0/ngate vss pad pad pad pad sg13cmos5l_DCNDiode_0/guard
+ sg13cmos5l_Clamp_N8N8D
Xsg13cmos5l_LevelDown_0 p2c pad vdd vss vss iovdd sg13cmos5l_LevelDown
Xsg13cmos5l_GateDecode_0 sg13cmos5l_GateDecode_0/ngate sg13cmos5l_GateDecode_0/pgate
+ c2p c2p_en iovdd vdd vss sg13cmos5l_GateDecode
Xsg13cmos5l_DCNDiode_0 vss pad sg13cmos5l_DCNDiode_0/guard pad sg13cmos5l_DCNDiode
.ends

.subckt sg13cmos5l_LevelUpInv o i iovdd vdd vss
X0 a_89_470# a_21_1826# vss vss sg13_hv_nmos ad=0.646p pd=4.48u as=0.361p ps=2.28u w=1.9u l=0.45u
X1 iovdd a_89_470# a_21_506# iovdd sg13_hv_pmos ad=57f pd=0.68u as=0.102p ps=1.28u w=0.3u l=0.45u
X2 vdd i a_21_1826# vdd sg13_lv_pmos ad=1.615p pd=10.18u as=1.615p ps=10.18u w=4.75u l=0.13u
X3 a_89_470# a_21_506# iovdd iovdd sg13_hv_pmos ad=0.102p pd=1.28u as=57f ps=0.68u w=0.3u l=0.45u
X4 vss i a_21_1826# vss sg13_lv_nmos ad=0.935p pd=6.18u as=0.935p ps=6.18u w=2.75u l=0.13u
X5 vss i a_21_506# vss sg13_hv_nmos ad=0.361p pd=2.28u as=0.646p ps=4.48u w=1.9u l=0.45u
X6 o a_89_470# vss vss sg13_hv_nmos ad=0.646p pd=4.48u as=0.646p ps=4.48u w=1.9u l=0.45u
X7 o a_89_470# iovdd iovdd sg13_hv_pmos ad=1.326p pd=8.48u as=1.326p ps=8.48u w=3.9u l=0.45u
.ends

.subckt sg13cmos5l_GateLevelUpInv ngate pgate iovdd core vdd vss
Xsg13cmos5l_LevelUpInv_0 pgate core iovdd vdd vss sg13cmos5l_LevelUpInv
Xsg13cmos5l_LevelUpInv_1 ngate core iovdd vdd vss sg13cmos5l_LevelUpInv
.ends

.subckt sg13cmos5l_IOPadOut16mA pad c2p vdd iovdd iovss vss iovdd_uq0 sg13cmos5l_DCNDiode_0/guard
Xsg13cmos5l_DCPDiode_0 pad iovdd_uq0 vss pad sg13cmos5l_DCPDiode
Xsg13cmos5l_Clamp_P8N8D_0 sg13cmos5l_Clamp_P8N8D_0/gate iovdd_uq0 vss pad pad pad
+ pad sg13cmos5l_Clamp_P8N8D
Xsg13cmos5l_Clamp_N8N8D_0 sg13cmos5l_Clamp_N8N8D_0/gate vss pad pad pad pad sg13cmos5l_DCNDiode_0/guard
+ sg13cmos5l_Clamp_N8N8D
Xsg13cmos5l_GateLevelUpInv_0 sg13cmos5l_Clamp_N8N8D_0/gate sg13cmos5l_Clamp_P8N8D_0/gate
+ iovdd c2p vdd vss sg13cmos5l_GateLevelUpInv
Xsg13cmos5l_DCNDiode_0 vss pad sg13cmos5l_DCNDiode_0/guard pad sg13cmos5l_DCNDiode
.ends

.subckt sg13cmos5l_Clamp_N43N43D4R gate iovss pad pad_uq0 pad_uq1 pad_uq2 pad_uq3
+ pad_uq4 pad_uq5 pad_uq6 pad_uq7 pad_uq8 pad_uq9 pad_uq10 pad_uq11 pad_uq12 pad_uq13
+ pad_uq14 pad_uq15 pad_uq16 pad_uq17 pad_uq18 pad_uq19 pad_uq20 w_n124_n124#
X0 iovss gate pad_uq1 iovss sg13_hv_nmos ad=1.408p pd=5.04u as=2.596p ps=5.58u w=4.4u l=0.6u
X1 iovss gate pad_uq19 iovss sg13_hv_nmos ad=1.408p pd=5.04u as=2.596p ps=5.58u w=4.4u l=0.6u
X2 iovss gate pad_uq15 iovss sg13_hv_nmos ad=1.408p pd=5.04u as=2.596p ps=5.58u w=4.4u l=0.6u
X3 iovss gate pad_uq13 iovss sg13_hv_nmos ad=1.408p pd=5.04u as=2.596p ps=5.58u w=4.4u l=0.6u
X4 pad_uq17 gate iovss iovss sg13_hv_nmos ad=2.596p pd=5.58u as=1.408p ps=5.04u w=4.4u l=0.6u
X5 pad_uq15 gate iovss iovss sg13_hv_nmos ad=2.596p pd=5.58u as=1.408p ps=5.04u w=4.4u l=0.6u
X6 pad_uq0 gate iovss iovss sg13_hv_nmos ad=3.256p pd=10.28u as=1.408p ps=5.04u w=4.4u l=0.6u
X7 pad_uq12 gate iovss iovss sg13_hv_nmos ad=2.596p pd=5.58u as=1.408p ps=5.04u w=4.4u l=0.6u
X8 pad_uq5 gate iovss iovss sg13_hv_nmos ad=2.596p pd=5.58u as=1.408p ps=5.04u w=4.4u l=0.6u
X9 iovss gate pad_uq16 iovss sg13_hv_nmos ad=1.408p pd=5.04u as=2.596p ps=5.58u w=4.4u l=0.6u
X10 iovss gate pad_uq12 iovss sg13_hv_nmos ad=1.408p pd=5.04u as=2.596p ps=5.58u w=4.4u l=0.6u
X11 iovss gate pad_uq3 iovss sg13_hv_nmos ad=1.408p pd=5.04u as=2.596p ps=5.58u w=4.4u l=0.6u
X12 iovss gate pad_uq18 iovss sg13_hv_nmos ad=1.408p pd=5.04u as=2.596p ps=5.58u w=4.4u l=0.6u
X13 pad_uq6 gate iovss iovss sg13_hv_nmos ad=2.596p pd=5.58u as=1.408p ps=5.04u w=4.4u l=0.6u
X14 pad gate iovss iovss sg13_hv_nmos ad=2.596p pd=5.58u as=1.408p ps=5.04u w=4.4u l=0.6u
X15 iovss gate pad_uq5 iovss sg13_hv_nmos ad=1.408p pd=5.04u as=2.596p ps=5.58u w=4.4u l=0.6u
X16 iovss gate pad_uq20 iovss sg13_hv_nmos ad=1.408p pd=5.04u as=2.596p ps=5.58u w=4.4u l=0.6u
X17 pad_uq14 gate iovss iovss sg13_hv_nmos ad=2.596p pd=5.58u as=1.408p ps=5.04u w=4.4u l=0.6u
X18 pad_uq20 gate iovss iovss sg13_hv_nmos ad=2.596p pd=5.58u as=2.068p ps=9.74u w=4.4u l=0.6u
X19 pad_uq10 gate iovss iovss sg13_hv_nmos ad=2.596p pd=5.58u as=1.408p ps=5.04u w=4.4u l=0.6u
X20 iovss gate pad_uq9 iovss sg13_hv_nmos ad=1.408p pd=5.04u as=2.596p ps=5.58u w=4.4u l=0.6u
X21 pad_uq16 gate iovss iovss sg13_hv_nmos ad=2.596p pd=5.58u as=1.408p ps=5.04u w=4.4u l=0.6u
X22 iovss gate pad_uq8 iovss sg13_hv_nmos ad=1.408p pd=5.04u as=2.596p ps=5.58u w=4.4u l=0.6u
X23 iovss gate pad_uq6 iovss sg13_hv_nmos ad=1.408p pd=5.04u as=2.596p ps=5.58u w=4.4u l=0.6u
X24 iovss gate pad_uq14 iovss sg13_hv_nmos ad=1.408p pd=5.04u as=2.596p ps=5.58u w=4.4u l=0.6u
X25 pad_uq11 gate iovss iovss sg13_hv_nmos ad=2.596p pd=5.58u as=1.408p ps=5.04u w=4.4u l=0.6u
X26 iovss gate pad_uq2 iovss sg13_hv_nmos ad=1.408p pd=5.04u as=2.596p ps=5.58u w=4.4u l=0.6u
X27 iovss gate pad_uq10 iovss sg13_hv_nmos ad=1.408p pd=5.04u as=2.596p ps=5.58u w=4.4u l=0.6u
X28 pad_uq13 gate iovss iovss sg13_hv_nmos ad=2.596p pd=5.58u as=1.408p ps=5.04u w=4.4u l=0.6u
X29 pad_uq8 gate iovss iovss sg13_hv_nmos ad=2.596p pd=5.58u as=1.408p ps=5.04u w=4.4u l=0.6u
X30 pad gate iovss iovss sg13_hv_nmos ad=2.596p pd=5.58u as=1.408p ps=5.04u w=4.4u l=0.6u
X31 iovss gate pad_uq17 iovss sg13_hv_nmos ad=1.408p pd=5.04u as=2.596p ps=5.58u w=4.4u l=0.6u
X32 iovss gate pad_uq11 iovss sg13_hv_nmos ad=1.408p pd=5.04u as=2.596p ps=5.58u w=4.4u l=0.6u
X33 iovss gate pad_uq13 iovss sg13_hv_nmos ad=1.408p pd=5.04u as=2.596p ps=5.58u w=4.4u l=0.6u
X34 iovss gate pad_uq7 iovss sg13_hv_nmos ad=1.408p pd=5.04u as=2.596p ps=5.58u w=4.4u l=0.6u
X35 pad_uq1 gate iovss iovss sg13_hv_nmos ad=2.596p pd=5.58u as=1.408p ps=5.04u w=4.4u l=0.6u
X36 pad_uq1 gate iovss iovss sg13_hv_nmos ad=2.596p pd=5.58u as=1.408p ps=5.04u w=4.4u l=0.6u
X37 iovss gate pad_uq4 iovss sg13_hv_nmos ad=1.408p pd=5.04u as=2.596p ps=5.58u w=4.4u l=0.6u
X38 iovss gate pad_uq19 iovss sg13_hv_nmos ad=1.408p pd=5.04u as=2.596p ps=5.58u w=4.4u l=0.6u
X39 iovss gate pad_uq5 iovss sg13_hv_nmos ad=1.408p pd=5.04u as=2.596p ps=5.58u w=4.4u l=0.6u
X40 iovss gate pad_uq15 iovss sg13_hv_nmos ad=1.408p pd=5.04u as=2.596p ps=5.58u w=4.4u l=0.6u
X41 pad_uq3 gate iovss iovss sg13_hv_nmos ad=2.596p pd=5.58u as=1.408p ps=5.04u w=4.4u l=0.6u
X42 pad_uq15 gate iovss iovss sg13_hv_nmos ad=2.596p pd=5.58u as=1.408p ps=5.04u w=4.4u l=0.6u
X43 pad_uq14 gate iovss iovss sg13_hv_nmos ad=2.596p pd=5.58u as=1.408p ps=5.04u w=4.4u l=0.6u
X44 pad_uq9 gate iovss iovss sg13_hv_nmos ad=2.596p pd=5.58u as=1.408p ps=5.04u w=4.4u l=0.6u
X45 iovss gate pad_uq18 iovss sg13_hv_nmos ad=1.408p pd=5.04u as=2.596p ps=5.58u w=4.4u l=0.6u
X46 pad_uq4 gate iovss iovss sg13_hv_nmos ad=2.596p pd=5.58u as=1.408p ps=5.04u w=4.4u l=0.6u
X47 iovss gate pad_uq3 iovss sg13_hv_nmos ad=1.408p pd=5.04u as=2.596p ps=5.58u w=4.4u l=0.6u
X48 iovss gate pad_uq9 iovss sg13_hv_nmos ad=1.408p pd=5.04u as=2.596p ps=5.58u w=4.4u l=0.6u
X49 pad_uq6 gate iovss iovss sg13_hv_nmos ad=2.596p pd=5.58u as=1.408p ps=5.04u w=4.4u l=0.6u
X50 pad_uq18 gate iovss iovss sg13_hv_nmos ad=2.596p pd=5.58u as=1.408p ps=5.04u w=4.4u l=0.6u
X51 pad_uq12 gate iovss iovss sg13_hv_nmos ad=2.596p pd=5.58u as=1.408p ps=5.04u w=4.4u l=0.6u
X52 pad_uq8 gate iovss iovss sg13_hv_nmos ad=2.596p pd=5.58u as=1.408p ps=5.04u w=4.4u l=0.6u
X53 iovss gate pad_uq5 iovss sg13_hv_nmos ad=1.408p pd=5.04u as=2.596p ps=5.58u w=4.4u l=0.6u
X54 iovss gate pad_uq6 iovss sg13_hv_nmos ad=1.408p pd=5.04u as=2.596p ps=5.58u w=4.4u l=0.6u
X55 iovss gate pad iovss sg13_hv_nmos ad=1.408p pd=5.04u as=2.596p ps=5.58u w=4.4u l=0.6u
X56 iovss gate pad_uq1 iovss sg13_hv_nmos ad=1.408p pd=5.04u as=2.596p ps=5.58u w=4.4u l=0.6u
X57 pad_uq19 gate iovss iovss sg13_hv_nmos ad=2.596p pd=5.58u as=1.408p ps=5.04u w=4.4u l=0.6u
X58 pad_uq5 gate iovss iovss sg13_hv_nmos ad=2.596p pd=5.58u as=1.408p ps=5.04u w=4.4u l=0.6u
X59 pad_uq9 gate iovss iovss sg13_hv_nmos ad=2.596p pd=5.58u as=1.408p ps=5.04u w=4.4u l=0.6u
X60 iovss gate pad_uq8 iovss sg13_hv_nmos ad=1.408p pd=5.04u as=2.596p ps=5.58u w=4.4u l=0.6u
X61 pad_uq11 gate iovss iovss sg13_hv_nmos ad=2.596p pd=5.58u as=1.408p ps=5.04u w=4.4u l=0.6u
X62 iovss gate pad_uq14 iovss sg13_hv_nmos ad=1.408p pd=5.04u as=2.596p ps=5.58u w=4.4u l=0.6u
X63 pad_uq2 gate iovss iovss sg13_hv_nmos ad=2.596p pd=5.58u as=1.408p ps=5.04u w=4.4u l=0.6u
X64 iovss gate pad_uq10 iovss sg13_hv_nmos ad=1.408p pd=5.04u as=2.596p ps=5.58u w=4.4u l=0.6u
X65 iovss gate pad_uq14 iovss sg13_hv_nmos ad=1.408p pd=5.04u as=2.596p ps=5.58u w=4.4u l=0.6u
X66 iovss gate pad_uq17 iovss sg13_hv_nmos ad=1.408p pd=5.04u as=2.596p ps=5.58u w=4.4u l=0.6u
X67 pad_uq17 gate iovss iovss sg13_hv_nmos ad=2.596p pd=5.58u as=1.408p ps=5.04u w=4.4u l=0.6u
X68 pad_uq0 gate iovss iovss sg13_hv_nmos ad=3.256p pd=10.28u as=1.408p ps=5.04u w=4.4u l=0.6u
X69 pad_uq7 gate iovss iovss sg13_hv_nmos ad=2.596p pd=5.58u as=1.408p ps=5.04u w=4.4u l=0.6u
X70 pad_uq18 gate iovss iovss sg13_hv_nmos ad=2.596p pd=5.58u as=1.408p ps=5.04u w=4.4u l=0.6u
X71 pad_uq5 gate iovss iovss sg13_hv_nmos ad=2.596p pd=5.58u as=1.408p ps=5.04u w=4.4u l=0.6u
X72 iovss gate pad_uq4 iovss sg13_hv_nmos ad=1.408p pd=5.04u as=2.596p ps=5.58u w=4.4u l=0.6u
X73 pad_uq1 gate iovss iovss sg13_hv_nmos ad=2.596p pd=5.58u as=1.408p ps=5.04u w=4.4u l=0.6u
X74 pad_uq13 gate iovss iovss sg13_hv_nmos ad=2.596p pd=5.58u as=1.408p ps=5.04u w=4.4u l=0.6u
X75 iovss gate pad_uq18 iovss sg13_hv_nmos ad=1.408p pd=5.04u as=2.596p ps=5.58u w=4.4u l=0.6u
X76 pad_uq3 gate iovss iovss sg13_hv_nmos ad=2.596p pd=5.58u as=1.408p ps=5.04u w=4.4u l=0.6u
X77 iovss gate pad_uq2 iovss sg13_hv_nmos ad=1.408p pd=5.04u as=2.596p ps=5.58u w=4.4u l=0.6u
X78 pad_uq14 gate iovss iovss sg13_hv_nmos ad=2.596p pd=5.58u as=1.408p ps=5.04u w=4.4u l=0.6u
X79 pad_uq6 gate iovss iovss sg13_hv_nmos ad=2.596p pd=5.58u as=1.408p ps=5.04u w=4.4u l=0.6u
X80 iovss gate pad_uq20 iovss sg13_hv_nmos ad=1.408p pd=5.04u as=2.596p ps=5.58u w=4.4u l=0.6u
X81 iovss gate pad_uq1 iovss sg13_hv_nmos ad=1.408p pd=5.04u as=2.596p ps=5.58u w=4.4u l=0.6u
X82 pad_uq20 gate iovss iovss sg13_hv_nmos ad=2.596p pd=5.58u as=2.068p ps=9.74u w=4.4u l=0.6u
X83 pad_uq10 gate iovss iovss sg13_hv_nmos ad=2.596p pd=5.58u as=1.408p ps=5.04u w=4.4u l=0.6u
X84 iovss gate pad_uq9 iovss sg13_hv_nmos ad=1.408p pd=5.04u as=2.596p ps=5.58u w=4.4u l=0.6u
X85 pad_uq16 gate iovss iovss sg13_hv_nmos ad=2.596p pd=5.58u as=1.408p ps=5.04u w=4.4u l=0.6u
X86 pad_uq12 gate iovss iovss sg13_hv_nmos ad=2.596p pd=5.58u as=1.408p ps=5.04u w=4.4u l=0.6u
X87 pad_uq19 gate iovss iovss sg13_hv_nmos ad=2.596p pd=5.58u as=1.408p ps=5.04u w=4.4u l=0.6u
X88 pad_uq18 gate iovss iovss sg13_hv_nmos ad=2.596p pd=5.58u as=1.408p ps=5.04u w=4.4u l=0.6u
X89 iovss gate pad_uq10 iovss sg13_hv_nmos ad=1.408p pd=5.04u as=2.596p ps=5.58u w=4.4u l=0.6u
X90 pad_uq8 gate iovss iovss sg13_hv_nmos ad=2.596p pd=5.58u as=1.408p ps=5.04u w=4.4u l=0.6u
X91 iovss gate pad_uq16 iovss sg13_hv_nmos ad=1.408p pd=5.04u as=2.596p ps=5.58u w=4.4u l=0.6u
X92 iovss gate pad iovss sg13_hv_nmos ad=1.408p pd=5.04u as=2.596p ps=5.58u w=4.4u l=0.6u
X93 iovss gate pad_uq12 iovss sg13_hv_nmos ad=1.408p pd=5.04u as=2.596p ps=5.58u w=4.4u l=0.6u
X94 iovss gate pad_uq3 iovss sg13_hv_nmos ad=1.408p pd=5.04u as=2.596p ps=5.58u w=4.4u l=0.6u
X95 pad_uq2 gate iovss iovss sg13_hv_nmos ad=2.596p pd=5.58u as=1.408p ps=5.04u w=4.4u l=0.6u
X96 pad gate iovss iovss sg13_hv_nmos ad=2.596p pd=5.58u as=1.408p ps=5.04u w=4.4u l=0.6u
X97 pad_uq2 gate iovss iovss sg13_hv_nmos ad=2.596p pd=5.58u as=1.408p ps=5.04u w=4.4u l=0.6u
X98 iovss gate pad_uq13 iovss sg13_hv_nmos ad=1.408p pd=5.04u as=2.596p ps=5.58u w=4.4u l=0.6u
X99 iovss gate pad_uq11 iovss sg13_hv_nmos ad=1.408p pd=5.04u as=2.596p ps=5.58u w=4.4u l=0.6u
X100 iovss gate pad_uq19 iovss sg13_hv_nmos ad=1.408p pd=5.04u as=2.596p ps=5.58u w=4.4u l=0.6u
X101 iovss gate pad_uq6 iovss sg13_hv_nmos ad=1.408p pd=5.04u as=2.596p ps=5.58u w=4.4u l=0.6u
X102 pad_uq15 gate iovss iovss sg13_hv_nmos ad=2.596p pd=5.58u as=1.408p ps=5.04u w=4.4u l=0.6u
X103 iovss gate pad_uq15 iovss sg13_hv_nmos ad=1.408p pd=5.04u as=2.596p ps=5.58u w=4.4u l=0.6u
X104 iovss gate pad_uq2 iovss sg13_hv_nmos ad=1.408p pd=5.04u as=2.596p ps=5.58u w=4.4u l=0.6u
X105 iovss gate pad_uq17 iovss sg13_hv_nmos ad=1.408p pd=5.04u as=2.596p ps=5.58u w=4.4u l=0.6u
X106 pad_uq10 gate iovss iovss sg13_hv_nmos ad=2.596p pd=5.58u as=1.408p ps=5.04u w=4.4u l=0.6u
X107 pad_uq15 gate iovss iovss sg13_hv_nmos ad=2.596p pd=5.58u as=1.408p ps=5.04u w=4.4u l=0.6u
X108 iovss gate pad_uq19 iovss sg13_hv_nmos ad=1.408p pd=5.04u as=2.596p ps=5.58u w=4.4u l=0.6u
X109 pad_uq17 gate iovss iovss sg13_hv_nmos ad=2.596p pd=5.58u as=1.408p ps=5.04u w=4.4u l=0.6u
X110 pad_uq13 gate iovss iovss sg13_hv_nmos ad=2.596p pd=5.58u as=1.408p ps=5.04u w=4.4u l=0.6u
X111 pad_uq7 gate iovss iovss sg13_hv_nmos ad=2.596p pd=5.58u as=1.408p ps=5.04u w=4.4u l=0.6u
X112 iovss gate pad_uq3 iovss sg13_hv_nmos ad=1.408p pd=5.04u as=2.596p ps=5.58u w=4.4u l=0.6u
X113 iovss gate pad_uq11 iovss sg13_hv_nmos ad=1.408p pd=5.04u as=2.596p ps=5.58u w=4.4u l=0.6u
X114 pad_uq6 gate iovss iovss sg13_hv_nmos ad=2.596p pd=5.58u as=1.408p ps=5.04u w=4.4u l=0.6u
X115 iovss gate dantenna l=0.48u w=0.48u
X116 iovss gate pad_uq7 iovss sg13_hv_nmos ad=1.408p pd=5.04u as=2.596p ps=5.58u w=4.4u l=0.6u
X117 iovss gate pad_uq5 iovss sg13_hv_nmos ad=1.408p pd=5.04u as=2.596p ps=5.58u w=4.4u l=0.6u
X118 iovss gate pad_uq1 iovss sg13_hv_nmos ad=1.408p pd=5.04u as=2.596p ps=5.58u w=4.4u l=0.6u
X119 iovss gate pad_uq8 iovss sg13_hv_nmos ad=1.408p pd=5.04u as=2.596p ps=5.58u w=4.4u l=0.6u
X120 pad_uq11 gate iovss iovss sg13_hv_nmos ad=2.596p pd=5.58u as=1.408p ps=5.04u w=4.4u l=0.6u
X121 iovss gate pad_uq14 iovss sg13_hv_nmos ad=1.408p pd=5.04u as=2.596p ps=5.58u w=4.4u l=0.6u
X122 iovss gate pad_uq7 iovss sg13_hv_nmos ad=1.408p pd=5.04u as=2.596p ps=5.58u w=4.4u l=0.6u
X123 iovss gate pad_uq16 iovss sg13_hv_nmos ad=1.408p pd=5.04u as=2.596p ps=5.58u w=4.4u l=0.6u
X124 pad_uq4 gate iovss iovss sg13_hv_nmos ad=2.596p pd=5.58u as=1.408p ps=5.04u w=4.4u l=0.6u
X125 iovss gate pad_uq10 iovss sg13_hv_nmos ad=1.408p pd=5.04u as=2.596p ps=5.58u w=4.4u l=0.6u
X126 pad_uq11 gate iovss iovss sg13_hv_nmos ad=2.596p pd=5.58u as=1.408p ps=5.04u w=4.4u l=0.6u
X127 iovss gate pad_uq12 iovss sg13_hv_nmos ad=1.408p pd=5.04u as=2.596p ps=5.58u w=4.4u l=0.6u
X128 iovss gate pad_uq15 iovss sg13_hv_nmos ad=1.408p pd=5.04u as=2.596p ps=5.58u w=4.4u l=0.6u
X129 pad_uq0 gate iovss iovss sg13_hv_nmos ad=3.256p pd=10.28u as=1.408p ps=5.04u w=4.4u l=0.6u
X130 pad_uq1 gate iovss iovss sg13_hv_nmos ad=2.596p pd=5.58u as=1.408p ps=5.04u w=4.4u l=0.6u
X131 pad_uq19 gate iovss iovss sg13_hv_nmos ad=2.596p pd=5.58u as=1.408p ps=5.04u w=4.4u l=0.6u
X132 iovss gate pad_uq4 iovss sg13_hv_nmos ad=1.408p pd=5.04u as=2.596p ps=5.58u w=4.4u l=0.6u
X133 pad_uq9 gate iovss iovss sg13_hv_nmos ad=2.596p pd=5.58u as=1.408p ps=5.04u w=4.4u l=0.6u
X134 iovss gate pad_uq6 iovss sg13_hv_nmos ad=1.408p pd=5.04u as=2.596p ps=5.58u w=4.4u l=0.6u
X135 iovss gate pad_uq8 iovss sg13_hv_nmos ad=1.408p pd=5.04u as=2.596p ps=5.58u w=4.4u l=0.6u
X136 pad_uq3 gate iovss iovss sg13_hv_nmos ad=2.596p pd=5.58u as=1.408p ps=5.04u w=4.4u l=0.6u
X137 iovss gate pad_uq2 iovss sg13_hv_nmos ad=1.408p pd=5.04u as=2.596p ps=5.58u w=4.4u l=0.6u
X138 pad_uq7 gate iovss iovss sg13_hv_nmos ad=2.596p pd=5.58u as=1.408p ps=5.04u w=4.4u l=0.6u
X139 iovss gate pad_uq16 iovss sg13_hv_nmos ad=1.408p pd=5.04u as=2.596p ps=5.58u w=4.4u l=0.6u
X140 pad_uq20 gate iovss iovss sg13_hv_nmos ad=2.596p pd=5.58u as=2.068p ps=9.74u w=4.4u l=0.6u
X141 iovss gate pad_uq9 iovss sg13_hv_nmos ad=1.408p pd=5.04u as=2.596p ps=5.58u w=4.4u l=0.6u
X142 pad_uq12 gate iovss iovss sg13_hv_nmos ad=2.596p pd=5.58u as=1.408p ps=5.04u w=4.4u l=0.6u
X143 pad_uq18 gate iovss iovss sg13_hv_nmos ad=2.596p pd=5.58u as=1.408p ps=5.04u w=4.4u l=0.6u
X144 iovss gate pad_uq11 iovss sg13_hv_nmos ad=1.408p pd=5.04u as=2.596p ps=5.58u w=4.4u l=0.6u
X145 pad_uq8 gate iovss iovss sg13_hv_nmos ad=2.596p pd=5.58u as=1.408p ps=5.04u w=4.4u l=0.6u
X146 pad_uq0 gate iovss iovss sg13_hv_nmos ad=3.256p pd=10.28u as=1.408p ps=5.04u w=4.4u l=0.6u
X147 iovss gate pad_uq7 iovss sg13_hv_nmos ad=1.408p pd=5.04u as=2.596p ps=5.58u w=4.4u l=0.6u
X148 pad_uq5 gate iovss iovss sg13_hv_nmos ad=2.596p pd=5.58u as=1.408p ps=5.04u w=4.4u l=0.6u
X149 iovss gate pad_uq4 iovss sg13_hv_nmos ad=1.408p pd=5.04u as=2.596p ps=5.58u w=4.4u l=0.6u
X150 iovss gate pad iovss sg13_hv_nmos ad=1.408p pd=5.04u as=2.596p ps=5.58u w=4.4u l=0.6u
X151 iovss gate pad_uq18 iovss sg13_hv_nmos ad=1.408p pd=5.04u as=2.596p ps=5.58u w=4.4u l=0.6u
X152 iovss gate pad_uq20 iovss sg13_hv_nmos ad=1.408p pd=5.04u as=2.596p ps=5.58u w=4.4u l=0.6u
X153 pad_uq14 gate iovss iovss sg13_hv_nmos ad=2.596p pd=5.58u as=1.408p ps=5.04u w=4.4u l=0.6u
X154 pad_uq2 gate iovss iovss sg13_hv_nmos ad=2.596p pd=5.58u as=1.408p ps=5.04u w=4.4u l=0.6u
X155 pad_uq20 gate iovss iovss sg13_hv_nmos ad=2.596p pd=5.58u as=2.068p ps=9.74u w=4.4u l=0.6u
X156 pad_uq10 gate iovss iovss sg13_hv_nmos ad=2.596p pd=5.58u as=1.408p ps=5.04u w=4.4u l=0.6u
X157 pad_uq3 gate iovss iovss sg13_hv_nmos ad=2.596p pd=5.58u as=1.408p ps=5.04u w=4.4u l=0.6u
X158 pad_uq4 gate iovss iovss sg13_hv_nmos ad=2.596p pd=5.58u as=1.408p ps=5.04u w=4.4u l=0.6u
X159 pad_uq16 gate iovss iovss sg13_hv_nmos ad=2.596p pd=5.58u as=1.408p ps=5.04u w=4.4u l=0.6u
X160 iovss gate pad_uq12 iovss sg13_hv_nmos ad=1.408p pd=5.04u as=2.596p ps=5.58u w=4.4u l=0.6u
X161 iovss gate pad_uq17 iovss sg13_hv_nmos ad=1.408p pd=5.04u as=2.596p ps=5.58u w=4.4u l=0.6u
X162 pad_uq16 gate iovss iovss sg13_hv_nmos ad=2.596p pd=5.58u as=1.408p ps=5.04u w=4.4u l=0.6u
X163 pad_uq17 gate iovss iovss sg13_hv_nmos ad=2.596p pd=5.58u as=1.408p ps=5.04u w=4.4u l=0.6u
X164 pad_uq7 gate iovss iovss sg13_hv_nmos ad=2.596p pd=5.58u as=1.408p ps=5.04u w=4.4u l=0.6u
X165 pad_uq19 gate iovss iovss sg13_hv_nmos ad=2.596p pd=5.58u as=1.408p ps=5.04u w=4.4u l=0.6u
X166 iovss gate pad_uq20 iovss sg13_hv_nmos ad=1.408p pd=5.04u as=2.596p ps=5.58u w=4.4u l=0.6u
X167 pad_uq13 gate iovss iovss sg13_hv_nmos ad=2.596p pd=5.58u as=1.408p ps=5.04u w=4.4u l=0.6u
X168 pad_uq9 gate iovss iovss sg13_hv_nmos ad=2.596p pd=5.58u as=1.408p ps=5.04u w=4.4u l=0.6u
X169 pad gate iovss iovss sg13_hv_nmos ad=2.596p pd=5.58u as=1.408p ps=5.04u w=4.4u l=0.6u
X170 iovss gate pad iovss sg13_hv_nmos ad=1.408p pd=5.04u as=2.596p ps=5.58u w=4.4u l=0.6u
X171 pad_uq4 gate iovss iovss sg13_hv_nmos ad=2.596p pd=5.58u as=1.408p ps=5.04u w=4.4u l=0.6u
X172 iovss gate pad_uq13 iovss sg13_hv_nmos ad=1.408p pd=5.04u as=2.596p ps=5.58u w=4.4u l=0.6u
.ends

.subckt sg13cmos5l_RCClampInverter out in iovss supply
X0 iovss in iovss iovss sg13_hv_nmos ad=1.71p pd=9.38u as=0 ps=0 w=9u l=9.5u
X1 out in supply supply sg13_hv_pmos ad=1.33p pd=7.38u as=1.33p ps=7.38u w=7u l=0.5u
X2 iovss in out iovss sg13_hv_nmos ad=1.71p pd=9.38u as=1.71p ps=9.38u w=9u l=0.5u
X3 out in supply supply sg13_hv_pmos ad=1.33p pd=7.38u as=2.38p ps=14.68u w=7u l=0.5u
X4 out in supply supply sg13_hv_pmos ad=1.33p pd=7.38u as=1.33p ps=7.38u w=7u l=0.5u
X5 supply in out supply sg13_hv_pmos ad=1.33p pd=7.38u as=1.33p ps=7.38u w=7u l=0.5u
X6 supply in out supply sg13_hv_pmos ad=1.33p pd=7.38u as=1.33p ps=7.38u w=7u l=0.5u
X7 out in iovss iovss sg13_hv_nmos ad=1.71p pd=9.38u as=1.71p ps=9.38u w=9u l=0.5u
X8 supply in out supply sg13_hv_pmos ad=1.33p pd=7.38u as=1.33p ps=7.38u w=7u l=0.5u
X9 supply in out supply sg13_hv_pmos ad=1.33p pd=7.38u as=1.33p ps=7.38u w=7u l=0.5u
X10 supply in out supply sg13_hv_pmos ad=1.33p pd=7.38u as=1.33p ps=7.38u w=7u l=0.5u
X11 out in supply supply sg13_hv_pmos ad=1.33p pd=7.38u as=1.33p ps=7.38u w=7u l=0.5u
X12 out in supply supply sg13_hv_pmos ad=1.33p pd=7.38u as=1.33p ps=7.38u w=7u l=0.5u
X13 supply in out supply sg13_hv_pmos ad=1.33p pd=7.38u as=1.33p ps=7.38u w=7u l=0.5u
X14 supply in out supply sg13_hv_pmos ad=1.33p pd=7.38u as=1.33p ps=7.38u w=7u l=0.5u
X15 iovss in iovss iovss sg13_hv_nmos ad=3.06p pd=18.68u as=0 ps=0 w=9u l=9.5u
X16 out in iovss iovss sg13_hv_nmos ad=1.71p pd=9.38u as=1.71p ps=9.38u w=9u l=0.5u
X17 iovss in out iovss sg13_hv_nmos ad=3.06p pd=18.68u as=1.71p ps=9.38u w=9u l=0.5u
X18 iovss in iovss iovss sg13_hv_nmos ad=1.71p pd=9.38u as=0 ps=0 w=9u l=9.5u
X19 iovss in iovss iovss sg13_hv_nmos ad=3.06p pd=18.68u as=0 ps=0 w=9u l=9.5u
X20 iovss in iovss iovss sg13_hv_nmos ad=1.71p pd=9.38u as=0 ps=0 w=9u l=9.5u
X21 iovss in iovss iovss sg13_hv_nmos ad=1.71p pd=9.38u as=0 ps=0 w=9u l=9.5u
X22 supply in out supply sg13_hv_pmos ad=1.33p pd=7.38u as=1.33p ps=7.38u w=7u l=0.5u
X23 out in supply supply sg13_hv_pmos ad=1.33p pd=7.38u as=1.33p ps=7.38u w=7u l=0.5u
X24 out in supply supply sg13_hv_pmos ad=1.33p pd=7.38u as=1.33p ps=7.38u w=7u l=0.5u
X25 iovss in iovss iovss sg13_hv_nmos ad=1.71p pd=9.38u as=0 ps=0 w=9u l=9.5u
X26 out in supply supply sg13_hv_pmos ad=1.33p pd=7.38u as=1.33p ps=7.38u w=7u l=0.5u
X27 iovss in out iovss sg13_hv_nmos ad=1.71p pd=9.38u as=1.71p ps=9.38u w=9u l=0.5u
X28 out in supply supply sg13_hv_pmos ad=1.33p pd=7.38u as=1.33p ps=7.38u w=7u l=0.5u
X29 supply in out supply sg13_hv_pmos ad=1.33p pd=7.38u as=1.33p ps=7.38u w=7u l=0.5u
X30 out in supply supply sg13_hv_pmos ad=1.33p pd=7.38u as=1.33p ps=7.38u w=7u l=0.5u
X31 iovss in iovss iovss sg13_hv_nmos ad=1.71p pd=9.38u as=0 ps=0 w=9u l=9.5u
X32 out in supply supply sg13_hv_pmos ad=1.33p pd=7.38u as=1.33p ps=7.38u w=7u l=0.5u
X33 supply in out supply sg13_hv_pmos ad=1.33p pd=7.38u as=1.33p ps=7.38u w=7u l=0.5u
X34 out in iovss iovss sg13_hv_nmos ad=1.71p pd=9.38u as=1.71p ps=9.38u w=9u l=0.5u
X35 supply in out supply sg13_hv_pmos ad=1.33p pd=7.38u as=1.33p ps=7.38u w=7u l=0.5u
X36 out in supply supply sg13_hv_pmos ad=1.33p pd=7.38u as=1.33p ps=7.38u w=7u l=0.5u
X37 out in supply supply sg13_hv_pmos ad=1.33p pd=7.38u as=1.33p ps=7.38u w=7u l=0.5u
X38 out in supply supply sg13_hv_pmos ad=1.33p pd=7.38u as=1.33p ps=7.38u w=7u l=0.5u
X39 supply in out supply sg13_hv_pmos ad=1.33p pd=7.38u as=1.33p ps=7.38u w=7u l=0.5u
X40 out in supply supply sg13_hv_pmos ad=1.33p pd=7.38u as=1.33p ps=7.38u w=7u l=0.5u
X41 supply in out supply sg13_hv_pmos ad=1.33p pd=7.38u as=1.33p ps=7.38u w=7u l=0.5u
X42 iovss in iovss iovss sg13_hv_nmos ad=1.71p pd=9.38u as=0 ps=0 w=9u l=9.5u
X43 supply in out supply sg13_hv_pmos ad=1.33p pd=7.38u as=1.33p ps=7.38u w=7u l=0.5u
X44 out in supply supply sg13_hv_pmos ad=1.33p pd=7.38u as=1.33p ps=7.38u w=7u l=0.5u
X45 iovss in out iovss sg13_hv_nmos ad=1.71p pd=9.38u as=1.71p ps=9.38u w=9u l=0.5u
X46 iovss in iovss iovss sg13_hv_nmos ad=1.71p pd=9.38u as=0 ps=0 w=9u l=9.5u
X47 out in supply supply sg13_hv_pmos ad=1.33p pd=7.38u as=1.33p ps=7.38u w=7u l=0.5u
X48 supply in out supply sg13_hv_pmos ad=2.38p pd=14.68u as=1.33p ps=7.38u w=7u l=0.5u
X49 out in iovss iovss sg13_hv_nmos ad=1.71p pd=9.38u as=1.71p ps=9.38u w=9u l=0.5u
X50 supply in out supply sg13_hv_pmos ad=1.33p pd=7.38u as=1.33p ps=7.38u w=7u l=0.5u
X51 out in supply supply sg13_hv_pmos ad=1.33p pd=7.38u as=1.33p ps=7.38u w=7u l=0.5u
X52 out in supply supply sg13_hv_pmos ad=1.33p pd=7.38u as=1.33p ps=7.38u w=7u l=0.5u
X53 supply in out supply sg13_hv_pmos ad=1.33p pd=7.38u as=1.33p ps=7.38u w=7u l=0.5u
X54 iovss in iovss iovss sg13_hv_nmos ad=1.71p pd=9.38u as=0 ps=0 w=9u l=9.5u
X55 out in supply supply sg13_hv_pmos ad=1.33p pd=7.38u as=1.33p ps=7.38u w=7u l=0.5u
X56 supply in out supply sg13_hv_pmos ad=1.33p pd=7.38u as=1.33p ps=7.38u w=7u l=0.5u
X57 supply in out supply sg13_hv_pmos ad=1.33p pd=7.38u as=1.33p ps=7.38u w=7u l=0.5u
X58 supply in out supply sg13_hv_pmos ad=1.33p pd=7.38u as=1.33p ps=7.38u w=7u l=0.5u
X59 out in supply supply sg13_hv_pmos ad=1.33p pd=7.38u as=1.33p ps=7.38u w=7u l=0.5u
X60 supply in out supply sg13_hv_pmos ad=1.33p pd=7.38u as=1.33p ps=7.38u w=7u l=0.5u
X61 out in iovss iovss sg13_hv_nmos ad=1.71p pd=9.38u as=1.71p ps=9.38u w=9u l=0.5u
X62 out in supply supply sg13_hv_pmos ad=1.33p pd=7.38u as=1.33p ps=7.38u w=7u l=0.5u
X63 iovss in out iovss sg13_hv_nmos ad=1.71p pd=9.38u as=1.71p ps=9.38u w=9u l=0.5u
X64 supply in out supply sg13_hv_pmos ad=1.33p pd=7.38u as=1.33p ps=7.38u w=7u l=0.5u
X65 supply in out supply sg13_hv_pmos ad=1.33p pd=7.38u as=1.33p ps=7.38u w=7u l=0.5u
X66 out in supply supply sg13_hv_pmos ad=1.33p pd=7.38u as=1.33p ps=7.38u w=7u l=0.5u
X67 out in supply supply sg13_hv_pmos ad=1.33p pd=7.38u as=1.33p ps=7.38u w=7u l=0.5u
X68 iovss in iovss iovss sg13_hv_nmos ad=1.71p pd=9.38u as=0 ps=0 w=9u l=9.5u
X69 out in supply supply sg13_hv_pmos ad=1.33p pd=7.38u as=1.33p ps=7.38u w=7u l=0.5u
X70 supply in out supply sg13_hv_pmos ad=1.33p pd=7.38u as=1.33p ps=7.38u w=7u l=0.5u
X71 supply in out supply sg13_hv_pmos ad=1.33p pd=7.38u as=1.33p ps=7.38u w=7u l=0.5u
X72 iovss in out iovss sg13_hv_nmos ad=3.06p pd=18.68u as=1.71p ps=9.38u w=9u l=0.5u
X73 iovss in iovss iovss sg13_hv_nmos ad=1.71p pd=9.38u as=0 ps=0 w=9u l=9.5u
X74 iovss in iovss iovss sg13_hv_nmos ad=1.71p pd=9.38u as=0 ps=0 w=9u l=9.5u
X75 out in iovss iovss sg13_hv_nmos ad=1.71p pd=9.38u as=1.71p ps=9.38u w=9u l=0.5u
.ends

.subckt sg13cmos5l_RCClampResistor pin1 pin2 sub
X0 a_2640_4086# a_2970_0# sub rppd l=20u w=1u
X1 a_3300_4086# a_2970_0# sub rppd l=20u w=1u
X2 a_4620_4086# a_4950_0# sub rppd l=20u w=1u
X3 a_5280_4086# a_4950_0# sub rppd l=20u w=1u
X4 a_6600_4086# a_6930_0# sub rppd l=20u w=1u
X5 a_7260_4086# a_6930_0# sub rppd l=20u w=1u
X6 a_2640_4086# a_2310_0# sub rppd l=20u w=1u
X7 a_4620_4086# a_4290_0# sub rppd l=20u w=1u
X8 a_660_4086# a_990_0# sub rppd l=20u w=1u
X9 a_6600_4086# a_6270_0# sub rppd l=20u w=1u
X10 a_1980_4086# a_1650_0# sub rppd l=20u w=1u
X11 a_1980_4086# a_2310_0# sub rppd l=20u w=1u
X12 a_660_4086# a_330_0# sub rppd l=20u w=1u
X13 a_3960_4086# a_3630_0# sub rppd l=20u w=1u
X14 a_3960_4086# a_4290_0# sub rppd l=20u w=1u
X15 a_5940_4086# a_5610_0# sub rppd l=20u w=1u
X16 a_5940_4086# a_6270_0# sub rppd l=20u w=1u
X17 a_7920_4086# a_7590_0# sub rppd l=20u w=1u
X18 a_7920_4086# pin2 sub rppd l=20u w=1u
X19 a_0_4086# pin1 sub rppd l=20u w=1u
X20 a_1320_4086# a_1650_0# sub rppd l=20u w=1u
X21 a_3300_4086# a_3630_0# sub rppd l=20u w=1u
X22 a_0_4086# a_330_0# sub rppd l=20u w=1u
X23 a_5280_4086# a_5610_0# sub rppd l=20u w=1u
X24 a_7260_4086# a_7590_0# sub rppd l=20u w=1u
X25 a_1320_4086# a_990_0# sub rppd l=20u w=1u
.ends

.subckt sg13cmos5l_IOPadIOVdd vdd iovdd iovss vss
Xsg13cmos5l_Clamp_N43N43D4R_0 sg13cmos5l_RCClampInverter_0/out vss iovdd iovdd iovdd
+ iovdd iovdd iovdd iovdd iovdd iovdd iovdd iovdd iovdd iovdd iovdd iovdd iovdd iovdd
+ iovdd iovdd iovdd iovdd iovdd iovdd sg13cmos5l_Clamp_N43N43D4R
Xsg13cmos5l_RCClampInverter_0 sg13cmos5l_RCClampInverter_0/out sg13cmos5l_RCClampInverter_0/in
+ vss iovdd sg13cmos5l_RCClampInverter
Xsg13cmos5l_RCClampResistor_0 iovdd sg13cmos5l_RCClampInverter_0/in vss sg13cmos5l_RCClampResistor
.ends

.subckt sg13cmos5l_IOPadVdd vdd iovdd iovss iovdd_uq0 vss w_n124_1076#
Xsg13cmos5l_Clamp_N43N43D4R_0 sg13cmos5l_RCClampInverter_0/out vss vdd vdd vdd vdd
+ vdd vdd vdd vdd vdd vdd vdd vdd vdd vdd vdd vdd vdd vdd vdd vdd vdd vdd w_n124_1076#
+ sg13cmos5l_Clamp_N43N43D4R
Xsg13cmos5l_RCClampInverter_0 sg13cmos5l_RCClampInverter_0/out sg13cmos5l_RCClampInverter_0/in
+ vss vdd sg13cmos5l_RCClampInverter
Xsg13cmos5l_RCClampResistor_0 vdd sg13cmos5l_RCClampInverter_0/in vss sg13cmos5l_RCClampResistor
.ends

.subckt sg13cmos5l_tielo L_LO VDD VSS
X0 L_LO a_223_58# VSS VSS sg13_lv_nmos ad=0.2992p pd=2.44u as=0.60422p ps=3.6u w=0.88u l=0.13u
X1 VDD a_59_418# a_59_418# VDD sg13_lv_pmos ad=0.62572p pd=3.785u as=0.102p ps=1.28u w=0.3u l=0.13u
X2 a_223_58# a_59_195# VDD VDD sg13_lv_pmos ad=0.3553p pd=2.77u as=0.62572p ps=3.785u w=1.045u l=0.13u
X3 VSS a_59_418# a_59_195# VSS sg13_lv_nmos ad=0.60422p pd=3.6u as=0.1309p ps=1.45u w=0.385u l=0.13u
.ends

.subckt sg13cmos5l_decap_4 VDD VSS
X0 VDD VSS VDD VDD sg13_lv_pmos ad=0.34p pd=2.68u as=0 ps=0 w=1u l=1u
X1 VSS VDD VSS VSS sg13_lv_nmos ad=0.1428p pd=1.52u as=0 ps=0 w=0.42u l=1u
.ends

.subckt sg13cmos5l_tiehi L_HI VDD VSS
X0 L_HI a_222_366# VDD VDD sg13_lv_pmos ad=0.3927p pd=2.99u as=0.76727p ps=3.885u w=1.155u l=0.13u
X1 VDD a_23_195# a_23_429# VDD sg13_lv_pmos ad=0.76727p pd=3.885u as=0.2442p ps=2.06u w=0.66u l=0.13u
X2 a_222_366# a_23_429# VSS VSS sg13_lv_nmos ad=0.27427p pd=2.28u as=0.49637p ps=3.565u w=0.795u l=0.13u
X3 VSS a_23_195# a_23_195# VSS sg13_lv_nmos ad=0.49637p pd=3.565u as=0.111p ps=1.34u w=0.3u l=0.13u
.ends

.subckt user_id_programming mask_rev[0] mask_rev[1] mask_rev[2] mask_rev[3] mask_rev[4]
+ mask_rev[5] mask_rev[6] mask_rev[7] mask_rev[8] mask_rev[9] mask_rev[10] mask_rev[11]
+ mask_rev[12] mask_rev[13] mask_rev[14] mask_rev[15] mask_rev[16] mask_rev[17] mask_rev[18]
+ mask_rev[19] mask_rev[20] mask_rev[21] mask_rev[22] mask_rev[23] mask_rev[24] mask_rev[25]
+ mask_rev[26] mask_rev[27] mask_rev[28] mask_rev[29] mask_rev[30] mask_rev[31] VDD
+ VSS
Xsg13cmos5l_tielo_13 mask_rev[26] VDD VSS sg13cmos5l_tielo
Xsg13cmos5l_tielo_24 mask_rev[15] VDD VSS sg13cmos5l_tielo
Xsg13cmos5l_tielo_14 mask_rev[28] VDD VSS sg13cmos5l_tielo
Xsg13cmos5l_tielo_25 mask_rev[13] VDD VSS sg13cmos5l_tielo
Xsg13cmos5l_decap_4_30 VDD VSS sg13cmos5l_decap_4
Xsg13cmos5l_tielo_15 mask_rev[30] VDD VSS sg13cmos5l_tielo
Xsg13cmos5l_tielo_26 sg13cmos5l_tielo_26/L_LO VDD VSS sg13cmos5l_tielo
Xsg13cmos5l_tiehi_30 mask_rev[3] VDD VSS sg13cmos5l_tiehi
Xsg13cmos5l_decap_4_31 VDD VSS sg13cmos5l_decap_4
Xsg13cmos5l_tielo_16 mask_rev[31] VDD VSS sg13cmos5l_tielo
Xsg13cmos5l_tielo_27 mask_rev[9] VDD VSS sg13cmos5l_tielo
Xsg13cmos5l_tiehi_20 sg13cmos5l_tiehi_20/L_HI VDD VSS sg13cmos5l_tiehi
Xsg13cmos5l_tiehi_31 sg13cmos5l_tiehi_31/L_HI VDD VSS sg13cmos5l_tiehi
Xsg13cmos5l_decap_4_10 VDD VSS sg13cmos5l_decap_4
Xsg13cmos5l_decap_4_21 VDD VSS sg13cmos5l_decap_4
Xsg13cmos5l_decap_4_32 VDD VSS sg13cmos5l_decap_4
Xsg13cmos5l_tiehi_10 sg13cmos5l_tiehi_10/L_HI VDD VSS sg13cmos5l_tiehi
Xsg13cmos5l_tiehi_21 mask_rev[21] VDD VSS sg13cmos5l_tiehi
Xsg13cmos5l_tielo_17 sg13cmos5l_tielo_17/L_LO VDD VSS sg13cmos5l_tielo
Xsg13cmos5l_tielo_28 mask_rev[7] VDD VSS sg13cmos5l_tielo
Xsg13cmos5l_decap_4_11 VDD VSS sg13cmos5l_decap_4
Xsg13cmos5l_decap_4_22 VDD VSS sg13cmos5l_decap_4
Xsg13cmos5l_decap_4_33 VDD VSS sg13cmos5l_decap_4
Xsg13cmos5l_tielo_18 mask_rev[27] VDD VSS sg13cmos5l_tielo
Xsg13cmos5l_tielo_29 mask_rev[5] VDD VSS sg13cmos5l_tielo
Xsg13cmos5l_tiehi_11 sg13cmos5l_tiehi_11/L_HI VDD VSS sg13cmos5l_tiehi
Xsg13cmos5l_tiehi_22 sg13cmos5l_tiehi_22/L_HI VDD VSS sg13cmos5l_tiehi
Xsg13cmos5l_decap_4_34 VDD VSS sg13cmos5l_decap_4
Xsg13cmos5l_decap_4_12 VDD VSS sg13cmos5l_decap_4
Xsg13cmos5l_decap_4_23 VDD VSS sg13cmos5l_decap_4
Xsg13cmos5l_tiehi_12 sg13cmos5l_tiehi_12/L_HI VDD VSS sg13cmos5l_tiehi
Xsg13cmos5l_tiehi_23 mask_rev[17] VDD VSS sg13cmos5l_tiehi
Xsg13cmos5l_tielo_19 mask_rev[25] VDD VSS sg13cmos5l_tielo
Xsg13cmos5l_decap_4_35 VDD VSS sg13cmos5l_decap_4
Xsg13cmos5l_decap_4_13 VDD VSS sg13cmos5l_decap_4
Xsg13cmos5l_decap_4_24 VDD VSS sg13cmos5l_decap_4
Xsg13cmos5l_tiehi_13 sg13cmos5l_tiehi_13/L_HI VDD VSS sg13cmos5l_tiehi
Xsg13cmos5l_tiehi_24 sg13cmos5l_tiehi_24/L_HI VDD VSS sg13cmos5l_tiehi
Xsg13cmos5l_decap_4_36 VDD VSS sg13cmos5l_decap_4
Xsg13cmos5l_tiehi_14 sg13cmos5l_tiehi_14/L_HI VDD VSS sg13cmos5l_tiehi
Xsg13cmos5l_tiehi_25 sg13cmos5l_tiehi_25/L_HI VDD VSS sg13cmos5l_tiehi
Xsg13cmos5l_decap_4_14 VDD VSS sg13cmos5l_decap_4
Xsg13cmos5l_decap_4_25 VDD VSS sg13cmos5l_decap_4
Xsg13cmos5l_decap_4_37 VDD VSS sg13cmos5l_decap_4
Xsg13cmos5l_decap_4_15 VDD VSS sg13cmos5l_decap_4
Xsg13cmos5l_decap_4_26 VDD VSS sg13cmos5l_decap_4
Xsg13cmos5l_tiehi_15 sg13cmos5l_tiehi_15/L_HI VDD VSS sg13cmos5l_tiehi
Xsg13cmos5l_tiehi_26 mask_rev[11] VDD VSS sg13cmos5l_tiehi
Xsg13cmos5l_decap_4_38 VDD VSS sg13cmos5l_decap_4
Xsg13cmos5l_tiehi_16 sg13cmos5l_tiehi_16/L_HI VDD VSS sg13cmos5l_tiehi
Xsg13cmos5l_tiehi_27 sg13cmos5l_tiehi_27/L_HI VDD VSS sg13cmos5l_tiehi
Xsg13cmos5l_decap_4_16 VDD VSS sg13cmos5l_decap_4
Xsg13cmos5l_decap_4_27 VDD VSS sg13cmos5l_decap_4
Xsg13cmos5l_decap_4_39 VDD VSS sg13cmos5l_decap_4
Xsg13cmos5l_decap_4_17 VDD VSS sg13cmos5l_decap_4
Xsg13cmos5l_decap_4_28 VDD VSS sg13cmos5l_decap_4
Xsg13cmos5l_tiehi_17 mask_rev[29] VDD VSS sg13cmos5l_tiehi
Xsg13cmos5l_tiehi_28 sg13cmos5l_tiehi_28/L_HI VDD VSS sg13cmos5l_tiehi
Xsg13cmos5l_tiehi_18 sg13cmos5l_tiehi_18/L_HI VDD VSS sg13cmos5l_tiehi
Xsg13cmos5l_tiehi_29 sg13cmos5l_tiehi_29/L_HI VDD VSS sg13cmos5l_tiehi
Xsg13cmos5l_decap_4_18 VDD VSS sg13cmos5l_decap_4
Xsg13cmos5l_decap_4_29 VDD VSS sg13cmos5l_decap_4
Xsg13cmos5l_tiehi_19 sg13cmos5l_tiehi_19/L_HI VDD VSS sg13cmos5l_tiehi
Xsg13cmos5l_tiehi_0 sg13cmos5l_tiehi_0/L_HI VDD VSS sg13cmos5l_tiehi
Xsg13cmos5l_tiehi_1 sg13cmos5l_tiehi_1/L_HI VDD VSS sg13cmos5l_tiehi
Xsg13cmos5l_tiehi_2 sg13cmos5l_tiehi_2/L_HI VDD VSS sg13cmos5l_tiehi
Xsg13cmos5l_tiehi_3 sg13cmos5l_tiehi_3/L_HI VDD VSS sg13cmos5l_tiehi
Xsg13cmos5l_tielo_0 mask_rev[0] VDD VSS sg13cmos5l_tielo
Xsg13cmos5l_tiehi_4 mask_rev[8] VDD VSS sg13cmos5l_tiehi
Xsg13cmos5l_tielo_1 mask_rev[2] VDD VSS sg13cmos5l_tielo
Xsg13cmos5l_tiehi_5 sg13cmos5l_tiehi_5/L_HI VDD VSS sg13cmos5l_tiehi
Xsg13cmos5l_tielo_2 mask_rev[4] VDD VSS sg13cmos5l_tielo
Xsg13cmos5l_decap_4_0 VDD VSS sg13cmos5l_decap_4
Xsg13cmos5l_tiehi_6 sg13cmos5l_tiehi_6/L_HI VDD VSS sg13cmos5l_tiehi
Xsg13cmos5l_decap_4_1 VDD VSS sg13cmos5l_decap_4
Xsg13cmos5l_tielo_3 mask_rev[6] VDD VSS sg13cmos5l_tielo
Xsg13cmos5l_tiehi_7 sg13cmos5l_tiehi_7/L_HI VDD VSS sg13cmos5l_tiehi
Xsg13cmos5l_tielo_4 sg13cmos5l_tielo_4/L_LO VDD VSS sg13cmos5l_tielo
Xsg13cmos5l_decap_4_2 VDD VSS sg13cmos5l_decap_4
Xsg13cmos5l_tiehi_8 sg13cmos5l_tiehi_8/L_HI VDD VSS sg13cmos5l_tiehi
Xsg13cmos5l_tielo_5 mask_rev[10] VDD VSS sg13cmos5l_tielo
Xsg13cmos5l_decap_4_3 VDD VSS sg13cmos5l_decap_4
Xsg13cmos5l_tiehi_9 mask_rev[18] VDD VSS sg13cmos5l_tiehi
Xsg13cmos5l_tielo_6 mask_rev[12] VDD VSS sg13cmos5l_tielo
Xsg13cmos5l_decap_4_4 VDD VSS sg13cmos5l_decap_4
Xsg13cmos5l_tielo_7 mask_rev[14] VDD VSS sg13cmos5l_tielo
Xsg13cmos5l_decap_4_5 VDD VSS sg13cmos5l_decap_4
Xsg13cmos5l_tielo_8 mask_rev[16] VDD VSS sg13cmos5l_tielo
Xsg13cmos5l_decap_4_6 VDD VSS sg13cmos5l_decap_4
Xsg13cmos5l_tielo_9 sg13cmos5l_tielo_9/L_LO VDD VSS sg13cmos5l_tielo
Xsg13cmos5l_tielo_30 sg13cmos5l_tielo_30/L_LO VDD VSS sg13cmos5l_tielo
Xsg13cmos5l_decap_4_7 VDD VSS sg13cmos5l_decap_4
Xsg13cmos5l_tielo_20 mask_rev[23] VDD VSS sg13cmos5l_tielo
Xsg13cmos5l_tielo_31 mask_rev[1] VDD VSS sg13cmos5l_tielo
Xsg13cmos5l_decap_4_8 VDD VSS sg13cmos5l_decap_4
Xsg13cmos5l_tielo_10 mask_rev[20] VDD VSS sg13cmos5l_tielo
Xsg13cmos5l_tielo_21 sg13cmos5l_tielo_21/L_LO VDD VSS sg13cmos5l_tielo
Xsg13cmos5l_decap_4_9 VDD VSS sg13cmos5l_decap_4
Xsg13cmos5l_tielo_11 mask_rev[22] VDD VSS sg13cmos5l_tielo
Xsg13cmos5l_tielo_22 mask_rev[19] VDD VSS sg13cmos5l_tielo
Xsg13cmos5l_tielo_12 mask_rev[24] VDD VSS sg13cmos5l_tielo
Xsg13cmos5l_tielo_23 sg13cmos5l_tielo_23/L_LO VDD VSS sg13cmos5l_tielo
.ends

.subckt user_id_routing mask_rev[0] mask_rev[1] mask_rev[2] mask_rev[3] mask_rev[4]
+ mask_rev[5] mask_rev[6] mask_rev[7] mask_rev[8] mask_rev[9] mask_rev[10] mask_rev[11]
+ mask_rev[12] mask_rev[14] mask_rev[15] mask_rev[16] mask_rev[17] mask_rev[18] mask_rev[19]
+ mask_rev[20] mask_rev[21] mask_rev[22] mask_rev[23] mask_rev[24] mask_rev[25] mask_rev[26]
+ mask_rev[27] mask_rev[28] mask_rev[29] mask_rev[30] mask_rev[31] vdd mask_rev[13]
+ vss
Xuser_id_programming_0 mask_rev[0] mask_rev[1] mask_rev[2] mask_rev[3] mask_rev[4]
+ mask_rev[5] mask_rev[6] mask_rev[7] mask_rev[8] mask_rev[9] mask_rev[10] mask_rev[11]
+ mask_rev[12] mask_rev[13] mask_rev[14] mask_rev[15] mask_rev[16] mask_rev[17] mask_rev[18]
+ mask_rev[19] mask_rev[20] mask_rev[21] mask_rev[22] mask_rev[23] mask_rev[24] mask_rev[25]
+ mask_rev[26] mask_rev[27] mask_rev[28] mask_rev[29] mask_rev[30] mask_rev[31] vdd
+ vss user_id_programming
.ends

.subckt sg13cmos5l_IOPadIn pad p2c vdd vss iovdd sg13cmos5l_DCNDiode_0/guard
Xsg13cmos5l_DCPDiode_0 pad iovdd vss pad sg13cmos5l_DCPDiode
Xsg13cmos5l_LevelDown_0 p2c pad vdd vss vss iovdd sg13cmos5l_LevelDown
Xsg13cmos5l_DCNDiode_0 vss pad sg13cmos5l_DCNDiode_0/guard pad sg13cmos5l_DCNDiode
.ends

.subckt sg13cmos5l_IOPadSingle2Diff iovdd iovss vdd pad outp outn vcm vref iref en_3v3
+ en_3v3_b a_50_31370#
X0 iovdd s2d_block_0.s2d_tails_hi_f_0.vbp iovdd iovdd sg13_hv_pmos ad=1.7p pd=10.68u as=0 ps=0 w=5u l=6u
X1 iovss iovss iovss rhigh l=12.65u w=0.5u
X2 s2d_block_0.s2d_loads_f_0.ln s2d_block_0.s2d_loads_f_0.vcmfb iovdd iovdd sg13_hv_pmos ad=2.04p pd=12.68u as=2.04p ps=12.68u w=6u l=4u
X3 s2d_block_0.s2d_loads_f_0.ln s2d_block_0.s2d_casc_p_f_0.vbpc outn iovdd sg13_hv_pmos ad=5.1p pd=30.68u as=5.1p ps=30.68u w=15u l=3u
X4 s2d_block_0.s2d_tails_hi_f_0.sa_A2 a_14374_25646# iovss rhigh l=12.65u w=0.5u
X5 s2d_block_0.s2d_casc_n_f_0.xc s2d_block_0.sinks_6x6_s2d_c3_core_0.vbn iovss iovss sg13_hv_nmos ad=2.04p pd=12.68u as=2.04p ps=12.68u w=6u l=6u
X6 iovdd s2d_block_0.s2d_casc_n_f_0.vbnc s2d_block_0.s2d_casc_n_f_0.yc iovss sg13_hv_nmos ad=5.1p pd=30.68u as=5.1p ps=30.68u w=15u l=3u
X7 Clamp_P_M1_0.gate iovdd iovss rppd l=12.9u w=0.5u
X8 s2d_block_0.s2d_loads_f_0.ln s2d_block_0.s2d_loads_f_0.vcmfb iovdd iovdd sg13_hv_pmos ad=2.04p pd=12.68u as=2.04p ps=12.68u w=6u l=4u
X9 s2d_block_0.s2d_casc_p_f_0.vbpc s2d_block_0.bias_tree_noab_n_c3_0.ni iovss iovss sg13_hv_nmos ad=0.816p pd=5.48u as=0.816p ps=5.48u w=2.4u l=6u
X10 a_11758_27006# a_14374_25510# iovss rhigh l=12.65u w=0.5u
X11 s2d_block_0.s2d_tails_lo_f_0.sa_F1 vcm s2d_block_0.s2d_casc_n_f_0.y s2d_block_0.s2d_tails_lo_f_0.sa_F1 sg13_hv_pmos ad=3.4p pd=20.68u as=1.9p ps=10.38u w=10u l=1u
X12 iovss s2d_block_0.sinks_6x6_s2d_c3_core_0.vbn iovss iovss sg13_hv_nmos ad=0.68p pd=4.68u as=0 ps=0 w=2u l=6u
X13 iovdd Clamp_P_M1_0.gate pad iovdd sg13_hv_pmos ad=2.1312p pd=7.3u as=3.9294p ps=7.84u w=6.66u l=0.6u
X14 iovss s2d_block_0.sinks_6x6_s2d_c3_core_0.vbn s2d_block_0.s2d_casc_n_f_0.xc iovss sg13_hv_nmos ad=2.04p pd=12.68u as=2.04p ps=12.68u w=6u l=6u
X15 s2d_block_0.bias_tree_noab_n_c3_0.ni en_3v3_b iovss iovss sg13_hv_nmos ad=0.34p pd=2.68u as=0.34p ps=2.68u w=1u l=0.45u
X16 iovdd Clamp_P_M1_0.gate pad iovdd sg13_hv_pmos ad=2.1312p pd=7.3u as=3.9294p ps=7.84u w=6.66u l=0.6u
X17 iovss s2d_block_0.sinks_6x6_s2d_c3_core_0.vbn iovss iovss sg13_hv_nmos ad=2.04p pd=12.68u as=0 ps=0 w=6u l=6u
X18 s2d_block_0.s2d_casc_n_f_0.x s2d_block_0.s2d_casc_n_f_0.vbnc outp iovss sg13_hv_nmos ad=5.1p pd=30.68u as=5.1p ps=30.68u w=15u l=3u
X19 s2d_block_0.s2d_casc_n_f_0.x vref s2d_block_0.s2d_tails_lo_f_0.sb_A2 s2d_block_0.s2d_tails_lo_f_0.sb_A2 sg13_hv_pmos ad=1.9p pd=10.38u as=3.4p ps=20.68u w=10u l=1u
X20 iovdd Clamp_P_M1_0.gate pad iovdd sg13_hv_pmos ad=2.1312p pd=7.3u as=3.9294p ps=7.84u w=6.66u l=0.6u
X21 s2d_block_0.s2d_tails_hi_f_0.sb_F1 outp s2d_block_0.s2d_casc_n_f_0.x s2d_block_0.s2d_tails_hi_f_0.sb_F1 sg13_hv_pmos ad=3.4p pd=20.68u as=1.9p ps=10.38u w=10u l=1u
X22 iovdd iovdd iovdd iovdd sg13_hv_pmos ad=1.9p pd=10.38u as=0 ps=0 w=10u l=1u
X23 iovdd s2d_block_0.s2d_tails_hi_f_0.vbp iovdd iovdd sg13_hv_pmos ad=1.7p pd=10.68u as=0 ps=0 w=5u l=6u
X24 s2d_block_0.s2d_casc_n_f_0.y s2d_block_0.sinks_6x6_s2d_c3_core_0.vbn iovss iovss sg13_hv_nmos ad=2.04p pd=12.68u as=2.04p ps=12.68u w=6u l=6u
X25 s2d_block_0.s2d_tails_lo_f_0.sb_A2 a_14374_27278# iovss rhigh l=12.65u w=0.5u
X26 iovdd s2d_block_0.s2d_loads_f_0.vcmfb s2d_block_0.s2d_loads_f_0.dd iovdd sg13_hv_pmos ad=2.04p pd=12.68u as=2.04p ps=12.68u w=6u l=4u
X27 pad Clamp_N_M1_0.gate iovss iovss sg13_hv_nmos ad=2.596p pd=5.58u as=1.408p ps=5.04u w=4.4u l=0.6u
X28 pad Clamp_N_M1_0.gate iovss iovss sg13_hv_nmos ad=2.596p pd=5.58u as=2.068p ps=9.74u w=4.4u l=0.6u
X29 iovdd s2d_block_0.s2d_loads_f_0.vcmfb s2d_block_0.s2d_loads_f_0.lp iovdd sg13_hv_pmos ad=2.04p pd=12.68u as=2.04p ps=12.68u w=6u l=4u
X30 pad Clamp_N_M1_0.gate iovss iovss sg13_hv_nmos ad=2.596p pd=5.58u as=1.408p ps=5.04u w=4.4u l=0.6u
X31 vcm en_3v3_b outp iovss sg13_hv_nmos ad=0.19p pd=1.38u as=0.34p ps=2.68u w=1u l=0.45u
X32 s2d_block_0.s2d_tails_lo_f_0.sa_F1 a_14374_25782# iovss rhigh l=12.65u w=0.5u
X33 a_11758_27006# a_14374_27142# iovss rhigh l=12.65u w=0.5u
X34 iovdd iovdd iovdd iovdd sg13_hv_pmos ad=3.4p pd=20.68u as=0 ps=0 w=10u l=1u
X35 pad Clamp_P_M1_0.gate iovdd iovdd sg13_hv_pmos ad=3.9294p pd=7.84u as=2.1312p ps=7.3u w=6.66u l=0.6u
X36 s2d_block_0.s2d_loads_f_0.lp s2d_block_0.s2d_casc_p_f_0.vbpc outp iovdd sg13_hv_pmos ad=5.1p pd=30.68u as=5.1p ps=30.68u w=15u l=3u
X37 iovdd s2d_block_0.s2d_tails_hi_f_0.vbp s2d_block_0.s2d_tails_hi_f_0.sa_M1 iovdd sg13_hv_pmos ad=1.7p pd=10.68u as=1.7p ps=10.68u w=5u l=6u
X38 s2d_block_0.s2d_casc_n_f_0.y s2d_block_0.sinks_6x6_s2d_c3_core_0.vbn iovss iovss sg13_hv_nmos ad=2.04p pd=12.68u as=2.04p ps=12.68u w=6u l=6u
X39 iovdd Clamp_P_M1_0.gate pad iovdd sg13_hv_pmos ad=2.1312p pd=7.3u as=3.9294p ps=7.84u w=6.66u l=0.6u
X40 iovdd Clamp_P_M1_0.gate pad iovdd sg13_hv_pmos ad=2.1312p pd=7.3u as=3.9294p ps=7.84u w=6.66u l=0.6u
X41 iref en_3v3 s2d_block_0.bias_tree_noab_n_c3_0.ni iovss sg13_hv_nmos ad=0.34p pd=2.68u as=0.34p ps=2.68u w=1u l=0.45u
X42 iovdd Clamp_P_M1_0.gate pad iovdd sg13_hv_pmos ad=2.1312p pd=7.3u as=3.9294p ps=7.84u w=6.66u l=0.6u
X43 pad iovdd dpantenna l=1.26u w=27.78u
X44 pad Clamp_P_M1_0.gate iovdd iovdd sg13_hv_pmos ad=3.9294p pd=7.84u as=2.1312p ps=7.3u w=6.66u l=0.6u
X45 s2d_block_0.s2d_casc_n_f_0.x vcm s2d_block_0.s2d_tails_hi_f_0.sb_F2 s2d_block_0.s2d_tails_hi_f_0.sb_F2 sg13_hv_pmos ad=1.9p pd=10.38u as=3.4p ps=20.68u w=10u l=1u
X46 s2d_block_0.s2d_tails_hi_f_0.sa_A1 a_14374_25510# iovss rhigh l=12.65u w=0.5u
X47 iovss s2d_block_0.sinks_6x6_s2d_c3_core_0.vbn s2d_block_0.s2d_casc_n_f_0.y iovss sg13_hv_nmos ad=2.04p pd=12.68u as=2.04p ps=12.68u w=6u l=6u
X48 s2d_block_0.s2d_tails_hi_f_0.sb_F1 a_14374_27414# iovss rhigh l=12.65u w=0.5u
X49 s2d_block_0.s2d_tails_lo_f_0.sa_F2 outn s2d_block_0.s2d_casc_n_f_0.y s2d_block_0.s2d_tails_lo_f_0.sa_F2 sg13_hv_pmos ad=3.4p pd=20.68u as=1.9p ps=10.38u w=10u l=1u
X50 iovss s2d_block_0.bias_tree_noab_n_c3_0.ni iovss iovss sg13_hv_nmos ad=0.816p pd=5.48u as=0 ps=0 w=2.4u l=6u
X51 s2d_block_0.s2d_casc_n_f_0.y s2d_block_0.s2d_casc_n_f_0.vbnc outn iovss sg13_hv_nmos ad=5.1p pd=30.68u as=5.1p ps=30.68u w=15u l=3u
X52 pad Clamp_N_M1_0.gate iovss iovss sg13_hv_nmos ad=2.596p pd=5.58u as=1.408p ps=5.04u w=4.4u l=0.6u
X53 iovss s2d_block_0.s2d_casc_n_f_0.vbnc iovss iovss sg13_hv_nmos ad=0.68p pd=4.68u as=0 ps=0 w=2u l=3u
X54 iovss pad dantenna l=1.26u w=27.78u
X55 pad Clamp_N_M1_0.gate iovss iovss sg13_hv_nmos ad=2.596p pd=5.58u as=1.408p ps=5.04u w=4.4u l=0.6u
X56 vcm en_3v3 outp iovdd sg13_hv_pmos ad=0.19p pd=1.38u as=0.34p ps=2.68u w=1u l=0.45u
X57 outn en_3v3 vcm iovdd sg13_hv_pmos ad=0.34p pd=2.68u as=0.19p ps=1.38u w=1u l=0.45u
X58 iovdd s2d_block_0.s2d_tails_hi_f_0.vbp s2d_block_0.s2d_tails_hi_f_0.sb_M2 iovdd sg13_hv_pmos ad=1.7p pd=10.68u as=1.7p ps=10.68u w=5u l=6u
X59 iovss s2d_block_0.sinks_6x6_s2d_c3_core_0.vbn s2d_block_0.s2d_casc_n_f_0.y iovss sg13_hv_nmos ad=2.04p pd=12.68u as=2.04p ps=12.68u w=6u l=6u
X60 pad Clamp_P_M1_0.gate iovdd iovdd sg13_hv_pmos ad=3.9294p pd=7.84u as=2.1312p ps=7.3u w=6.66u l=0.6u
X61 iovdd s2d_block_0.s2d_tails_hi_f_0.vbp s2d_block_0.s2d_tails_hi_f_0.sb_F1 iovdd sg13_hv_pmos ad=1.7p pd=10.68u as=1.7p ps=10.68u w=5u l=6u
X62 iovdd s2d_block_0.s2d_loads_f_0.vcmfb s2d_block_0.s2d_loads_f_0.lp iovdd sg13_hv_pmos ad=2.04p pd=12.68u as=2.04p ps=12.68u w=6u l=4u
X63 iovdd Clamp_P_M1_0.gate pad iovdd sg13_hv_pmos ad=2.1312p pd=7.3u as=3.9294p ps=7.84u w=6.66u l=0.6u
X64 a_11758_26734# a_14374_25782# iovss rhigh l=12.65u w=0.5u
X65 pad Clamp_P_M1_0.gate iovdd iovdd sg13_hv_pmos ad=3.9294p pd=7.84u as=2.1312p ps=7.3u w=6.66u l=0.6u
X66 pad Clamp_P_M1_0.gate iovdd iovdd sg13_hv_pmos ad=3.9294p pd=7.84u as=2.1312p ps=7.3u w=6.66u l=0.6u
X67 pad Clamp_P_M1_0.gate iovdd iovdd sg13_hv_pmos ad=3.9294p pd=7.84u as=2.1312p ps=7.3u w=6.66u l=0.6u
X68 s2d_block_0.s2d_tails_hi_f_0.sb_M2 vcm s2d_block_0.s2d_casc_n_f_0.xc s2d_block_0.s2d_tails_hi_f_0.sb_M2 sg13_hv_pmos ad=3.4p pd=20.68u as=1.9p ps=10.38u w=10u l=1u
X69 pad Clamp_P_M1_0.gate iovdd iovdd sg13_hv_pmos ad=3.9294p pd=7.84u as=2.1312p ps=7.3u w=6.66u l=0.6u
X70 iovss Clamp_N_M1_0.gate pad iovss sg13_hv_nmos ad=1.408p pd=5.04u as=2.596p ps=5.58u w=4.4u l=0.6u
X71 iovss Clamp_N_M1_0.gate pad iovss sg13_hv_nmos ad=1.408p pd=5.04u as=2.596p ps=5.58u w=4.4u l=0.6u
X72 iovss iovss iovss rhigh l=12.65u w=0.5u
X73 s2d_block_0.s2d_casc_n_f_0.yc s2d_block_0.s2d_casc_n_f_0.vbnc iovdd iovss sg13_hv_nmos ad=5.1p pd=30.68u as=5.1p ps=30.68u w=15u l=3u
X74 iovdd s2d_block_0.s2d_casc_p_f_0.vbpc iovdd iovdd sg13_hv_pmos ad=0.34p pd=2.68u as=0 ps=0 w=1u l=4u
X75 s2d_block_0.s2d_casc_n_f_0.yc outp s2d_block_0.s2d_tails_hi_f_0.sa_M1 s2d_block_0.s2d_tails_hi_f_0.sa_M1 sg13_hv_pmos ad=1.9p pd=10.38u as=3.4p ps=20.68u w=10u l=1u
X76 s2d_block_0.s2d_casc_n_f_0.y vcm s2d_block_0.s2d_tails_lo_f_0.sa_F1 s2d_block_0.s2d_tails_lo_f_0.sa_F1 sg13_hv_pmos ad=1.9p pd=10.38u as=3.4p ps=20.68u w=10u l=1u
X77 iovdd s2d_block_0.s2d_tails_hi_f_0.vbp s2d_block_0.s2d_tails_hi_f_0.sa_A2 iovdd sg13_hv_pmos ad=1.7p pd=10.68u as=1.7p ps=10.68u w=5u l=6u
X78 s2d_block_0.s2d_tails_hi_f_0.sa_A2 pad s2d_block_0.s2d_casc_n_f_0.y s2d_block_0.s2d_tails_hi_f_0.sa_A2 sg13_hv_pmos ad=3.4p pd=20.68u as=1.9p ps=10.38u w=10u l=1u
X79 iovss s2d_block_0.sinks_6x6_s2d_c3_core_0.vbn s2d_block_0.s2d_casc_n_f_0.yc iovss sg13_hv_nmos ad=2.04p pd=12.68u as=2.04p ps=12.68u w=6u l=6u
X80 iovss s2d_block_0.sinks_6x6_s2d_c3_core_0.vbn iovss iovss sg13_hv_nmos ad=0.68p pd=4.68u as=0 ps=0 w=2u l=6u
X81 s2d_block_0.s2d_tails_hi_f_0.sb_M2 a_14374_27822# iovss rhigh l=12.65u w=0.5u
X82 s2d_block_0.s2d_casc_n_f_0.yc s2d_block_0.sinks_6x6_s2d_c3_core_0.vbn iovss iovss sg13_hv_nmos ad=2.04p pd=12.68u as=2.04p ps=12.68u w=6u l=6u
X83 iovss s2d_block_0.sinks_6x6_s2d_c3_core_0.vbn s2d_block_0.s2d_casc_n_f_0.y iovss sg13_hv_nmos ad=2.04p pd=12.68u as=2.04p ps=12.68u w=6u l=6u
X84 iovdd s2d_block_0.s2d_tails_hi_f_0.vbp s2d_block_0.s2d_tails_hi_f_0.sa_A1 iovdd sg13_hv_pmos ad=1.7p pd=10.68u as=1.7p ps=10.68u w=5u l=6u
X85 a_11758_26870# a_14374_25646# iovss rhigh l=12.65u w=0.5u
X86 s2d_block_0.s2d_casc_n_f_0.vbnc s2d_block_0.s2d_tails_hi_f_0.vbp iovdd iovdd sg13_hv_pmos ad=0.68p pd=4.68u as=0.68p ps=4.68u w=2u l=6u
X87 s2d_block_0.s2d_tails_hi_f_0.sb_F2 a_14374_27550# iovss rhigh l=12.65u w=0.5u
X88 iovdd s2d_block_0.s2d_tails_hi_f_0.vbp iovdd iovdd sg13_hv_pmos ad=1.7p pd=10.68u as=0 ps=0 w=5u l=6u
X89 pad Clamp_P_M1_0.gate iovdd iovdd sg13_hv_pmos ad=3.9294p pd=7.84u as=2.1312p ps=7.3u w=6.66u l=0.6u
X90 pad Clamp_P_M1_0.gate iovdd iovdd sg13_hv_pmos ad=3.9294p pd=7.84u as=2.1312p ps=7.3u w=6.66u l=0.6u
X91 a_11758_26598# a_14374_25918# iovss rhigh l=12.65u w=0.5u
X92 iovss s2d_block_0.sinks_6x6_s2d_c3_core_0.vbn s2d_block_0.s2d_casc_n_f_0.x iovss sg13_hv_nmos ad=2.04p pd=12.68u as=2.04p ps=12.68u w=6u l=6u
X93 s2d_block_0.s2d_loads_f_0.dd s2d_block_0.s2d_loads_f_0.vcmfb iovdd iovdd sg13_hv_pmos ad=2.04p pd=12.68u as=2.04p ps=12.68u w=6u l=4u
X94 pad Clamp_P_M1_0.gate iovdd iovdd sg13_hv_pmos ad=3.9294p pd=7.84u as=2.1312p ps=7.3u w=6.66u l=0.6u
X95 iovss Clamp_N_M1_0.gate pad iovss sg13_hv_nmos ad=1.408p pd=5.04u as=2.596p ps=5.58u w=4.4u l=0.6u
X96 iovdd s2d_block_0.s2d_loads_f_0.vcmfb iovdd iovdd sg13_hv_pmos ad=0.34p pd=2.68u as=0 ps=0 w=1u l=4u
X97 pad iovdd dpantenna l=1.26u w=27.78u
X98 pad Clamp_P_M1_0.gate iovdd iovdd sg13_hv_pmos ad=3.9294p pd=7.84u as=2.1312p ps=7.3u w=6.66u l=0.6u
X99 iovdd s2d_block_0.s2d_loads_f_0.vcmfb s2d_block_0.s2d_loads_f_0.ln iovdd sg13_hv_pmos ad=2.04p pd=12.68u as=2.04p ps=12.68u w=6u l=4u
X100 iovss Clamp_N_M1_0.gate pad iovss sg13_hv_nmos ad=2.068p pd=9.74u as=2.596p ps=5.58u w=4.4u l=0.6u
X101 s2d_block_0.s2d_loads_f_0.lp s2d_block_0.s2d_loads_f_0.vcmfb iovdd iovdd sg13_hv_pmos ad=2.04p pd=12.68u as=2.04p ps=12.68u w=6u l=4u
X102 iovdd s2d_block_0.s2d_loads_f_0.vcmfb s2d_block_0.s2d_loads_f_0.ln iovdd sg13_hv_pmos ad=2.04p pd=12.68u as=2.04p ps=12.68u w=6u l=4u
X103 iovdd s2d_block_0.s2d_casc_p_f_0.vbpc iovdd iovdd sg13_hv_pmos ad=0.34p pd=2.68u as=0 ps=0 w=1u l=4u
X104 pad Clamp_N_M1_0.gate iovss iovss sg13_hv_nmos ad=2.596p pd=5.58u as=1.408p ps=5.04u w=4.4u l=0.6u
X105 s2d_block_0.s2d_tails_lo_f_0.sa_M2 outn s2d_block_0.s2d_casc_n_f_0.yc s2d_block_0.s2d_tails_lo_f_0.sa_M2 sg13_hv_pmos ad=3.4p pd=20.68u as=1.9p ps=10.38u w=10u l=1u
X106 iovdd s2d_block_0.s2d_casc_p_f_0.vbpc s2d_block_0.s2d_casc_p_f_0.vbpc iovdd sg13_hv_pmos ad=0.34p pd=2.68u as=0.34p ps=2.68u w=1u l=4u
X107 iovdd s2d_block_0.s2d_loads_f_0.vcmfb iovdd iovdd sg13_hv_pmos ad=0.34p pd=2.68u as=0 ps=0 w=1u l=4u
X108 s2d_block_0.s2d_casc_n_f_0.y s2d_block_0.sinks_6x6_s2d_c3_core_0.vbn iovss iovss sg13_hv_nmos ad=2.04p pd=12.68u as=2.04p ps=12.68u w=6u l=6u
X109 iovss outp iovss iovss sg13_hv_nmos ad=4.08p pd=24.68u as=0 ps=0 w=12u l=12u
X110 iovss outn iovss iovss sg13_hv_nmos ad=4.08p pd=24.68u as=0 ps=0 w=12u l=12u
X111 iovdd s2d_block_0.s2d_tails_hi_f_0.vbp s2d_block_0.s2d_tails_hi_f_0.sb_F2 iovdd sg13_hv_pmos ad=1.7p pd=10.68u as=1.7p ps=10.68u w=5u l=6u
X112 s2d_block_0.s2d_casc_n_f_0.x outp s2d_block_0.s2d_tails_hi_f_0.sb_F1 s2d_block_0.s2d_tails_hi_f_0.sb_F1 sg13_hv_pmos ad=1.9p pd=10.38u as=3.4p ps=20.68u w=10u l=1u
X113 s2d_block_0.s2d_casc_n_f_0.xc vcm s2d_block_0.s2d_tails_lo_f_0.sb_M1 s2d_block_0.s2d_tails_lo_f_0.sb_M1 sg13_hv_pmos ad=1.9p pd=10.38u as=3.4p ps=20.68u w=10u l=1u
X114 iovss s2d_block_0.sinks_6x6_s2d_c3_core_0.vbn iovss iovss sg13_hv_nmos ad=0.68p pd=4.68u as=0 ps=0 w=2u l=6u
X115 iovdd s2d_block_0.s2d_casc_p_f_0.vbpc iovdd iovdd sg13_hv_pmos ad=0.34p pd=2.68u as=0 ps=0 w=1u l=4u
X116 a_11758_26326# a_14374_26190# iovss rhigh l=12.65u w=0.5u
X117 s2d_block_0.s2d_tails_lo_f_0.sb_A1 vref s2d_block_0.s2d_casc_n_f_0.x s2d_block_0.s2d_tails_lo_f_0.sb_A1 sg13_hv_pmos ad=3.4p pd=20.68u as=1.9p ps=10.38u w=10u l=1u
X118 s2d_block_0.s2d_casc_n_f_0.x s2d_block_0.sinks_6x6_s2d_c3_core_0.vbn iovss iovss sg13_hv_nmos ad=2.04p pd=12.68u as=2.04p ps=12.68u w=6u l=6u
X119 iovdd Clamp_P_M1_0.gate pad iovdd sg13_hv_pmos ad=2.1312p pd=7.3u as=3.9294p ps=7.84u w=6.66u l=0.6u
X120 s2d_block_0.s2d_tails_lo_f_0.sb_M1 a_14374_27686# iovss rhigh l=12.65u w=0.5u
X121 iovss s2d_block_0.sinks_6x6_s2d_c3_core_0.vbn iovss iovss sg13_hv_nmos ad=0.68p pd=4.68u as=0 ps=0 w=2u l=6u
X122 iovdd Clamp_P_M1_0.gate pad iovdd sg13_hv_pmos ad=2.1312p pd=7.3u as=3.9294p ps=7.84u w=6.66u l=0.6u
X123 s2d_block_0.s2d_tails_hi_f_0.sa_A1 pad s2d_block_0.s2d_casc_n_f_0.y s2d_block_0.s2d_tails_hi_f_0.sa_A1 sg13_hv_pmos ad=3.4p pd=20.68u as=1.9p ps=10.38u w=10u l=1u
X124 s2d_block_0.s2d_tails_lo_f_0.sb_M1 s2d_block_0.s2d_tails_hi_f_0.vbp iovdd iovdd sg13_hv_pmos ad=1.7p pd=10.68u as=1.7p ps=10.68u w=5u l=6u
X125 pad Clamp_P_M1_0.gate iovdd iovdd sg13_hv_pmos ad=3.9294p pd=7.84u as=2.1312p ps=7.3u w=6.66u l=0.6u
X126 iovdd iovdd iovdd iovdd sg13_hv_pmos ad=3.4p pd=20.68u as=0 ps=0 w=10u l=1u
X127 a_11758_26326# a_14374_27822# iovss rhigh l=12.65u w=0.5u
X128 s2d_block_0.s2d_casc_n_f_0.xc s2d_block_0.sinks_6x6_s2d_c3_core_0.vbn iovss iovss sg13_hv_nmos ad=2.04p pd=12.68u as=2.04p ps=12.68u w=6u l=6u
X129 pad Clamp_N_M1_0.gate iovss iovss sg13_hv_nmos ad=2.596p pd=5.58u as=1.408p ps=5.04u w=4.4u l=0.6u
X130 pad Clamp_N_M1_0.gate iovss iovss sg13_hv_nmos ad=2.596p pd=5.58u as=1.408p ps=5.04u w=4.4u l=0.6u
X131 iovdd Clamp_P_M1_0.gate pad iovdd sg13_hv_pmos ad=2.1312p pd=7.3u as=3.9294p ps=7.84u w=6.66u l=0.6u
X132 s2d_block_0.bias_tree_noab_n_c3_0.ni en_3v3_b iref iovdd sg13_hv_pmos ad=0.34p pd=2.68u as=0.34p ps=2.68u w=1u l=0.45u
X133 pad Clamp_P_M1_0.gate iovdd iovdd sg13_hv_pmos ad=3.9294p pd=7.84u as=3.1302p ps=14.26u w=6.66u l=0.6u
X134 pad Clamp_N_M1_0.gate iovss iovss sg13_hv_nmos ad=2.596p pd=5.58u as=1.408p ps=5.04u w=4.4u l=0.6u
X135 a_11758_26462# a_14374_26054# iovss rhigh l=12.65u w=0.5u
X136 s2d_block_0.s2d_loads_f_0.dd s2d_block_0.s2d_loads_f_0.vcmfb iovdd iovdd sg13_hv_pmos ad=2.04p pd=12.68u as=2.04p ps=12.68u w=6u l=4u
X137 iovss s2d_block_0.sinks_6x6_s2d_c3_core_0.vbn iovss iovss sg13_hv_nmos ad=0.68p pd=4.68u as=0 ps=0 w=2u l=6u
X138 iovdd iovdd iovdd iovdd sg13_hv_pmos ad=1.9p pd=10.38u as=0 ps=0 w=10u l=1u
X139 s2d_block_0.s2d_loads_f_0.vcmfb s2d_block_0.s2d_casc_p_f_0.vbpc s2d_block_0.s2d_loads_f_0.dd iovdd sg13_hv_pmos ad=5.1p pd=30.68u as=5.1p ps=30.68u w=15u l=3u
X140 iovdd s2d_block_0.s2d_tails_hi_f_0.vbp s2d_block_0.s2d_tails_hi_f_0.vbp iovdd sg13_hv_pmos ad=1.7p pd=10.68u as=1.7p ps=10.68u w=5u l=6u
X141 s2d_block_0.bias_tree_noab_n_c3_0.ni s2d_block_0.bias_tree_noab_n_c3_0.ni iovss iovss sg13_hv_nmos ad=2.04p pd=12.68u as=2.04p ps=12.68u w=6u l=6u
X142 iovdd Clamp_P_M1_0.gate pad iovdd sg13_hv_pmos ad=2.1312p pd=7.3u as=3.9294p ps=7.84u w=6.66u l=0.6u
X143 s2d_block_0.s2d_tails_lo_f_0.sa_M2 s2d_block_0.s2d_tails_hi_f_0.vbp iovdd iovdd sg13_hv_pmos ad=1.7p pd=10.68u as=1.7p ps=10.68u w=5u l=6u
X144 outn s2d_block_0.s2d_casc_n_f_0.vbnc s2d_block_0.s2d_casc_n_f_0.y iovss sg13_hv_nmos ad=5.1p pd=30.68u as=5.1p ps=30.68u w=15u l=3u
X145 iovdd Clamp_P_M1_0.gate pad iovdd sg13_hv_pmos ad=2.1312p pd=7.3u as=3.9294p ps=7.84u w=6.66u l=0.6u
X146 iovdd Clamp_P_M1_0.gate pad iovdd sg13_hv_pmos ad=2.1312p pd=7.3u as=3.9294p ps=7.84u w=6.66u l=0.6u
X147 s2d_block_0.s2d_casc_n_f_0.yc s2d_block_0.sinks_6x6_s2d_c3_core_0.vbn iovss iovss sg13_hv_nmos ad=2.04p pd=12.68u as=2.04p ps=12.68u w=6u l=6u
X148 s2d_block_0.s2d_casc_n_f_0.xc vcm s2d_block_0.s2d_tails_hi_f_0.sb_M2 s2d_block_0.s2d_tails_hi_f_0.sb_M2 sg13_hv_pmos ad=1.9p pd=10.38u as=3.4p ps=20.68u w=10u l=1u
X149 s2d_block_0.s2d_casc_n_f_0.y outn s2d_block_0.s2d_tails_lo_f_0.sa_F2 s2d_block_0.s2d_tails_lo_f_0.sa_F2 sg13_hv_pmos ad=1.9p pd=10.38u as=3.4p ps=20.68u w=10u l=1u
X150 s2d_block_0.s2d_tails_hi_f_0.sa_M1 outp s2d_block_0.s2d_casc_n_f_0.yc s2d_block_0.s2d_tails_hi_f_0.sa_M1 sg13_hv_pmos ad=3.4p pd=20.68u as=1.9p ps=10.38u w=10u l=1u
X151 pad Clamp_P_M1_0.gate iovdd iovdd sg13_hv_pmos ad=3.9294p pd=7.84u as=2.1312p ps=7.3u w=6.66u l=0.6u
X152 s2d_block_0.s2d_tails_lo_f_0.sa_F2 a_14374_25918# iovss rhigh l=12.65u w=0.5u
X153 s2d_block_0.sinks_6x6_s2d_c3_core_0.vbn s2d_block_0.sinks_6x6_s2d_c3_core_0.vbn iovss iovss sg13_hv_nmos ad=2.04p pd=12.68u as=2.04p ps=12.68u w=6u l=6u
X154 iovdd Clamp_P_M1_0.gate pad iovdd sg13_hv_pmos ad=2.1312p pd=7.3u as=3.9294p ps=7.84u w=6.66u l=0.6u
X155 iovss s2d_block_0.s2d_casc_n_f_0.vbnc iovss iovss sg13_hv_nmos ad=0.68p pd=4.68u as=0 ps=0 w=2u l=3u
X156 s2d_block_0.s2d_tails_lo_f_0.sa_F2 s2d_block_0.s2d_tails_hi_f_0.vbp iovdd iovdd sg13_hv_pmos ad=1.7p pd=10.68u as=1.7p ps=10.68u w=5u l=6u
X157 iovss Clamp_N_M1_0.gate pad iovss sg13_hv_nmos ad=1.408p pd=5.04u as=2.596p ps=5.58u w=4.4u l=0.6u
X158 s2d_block_0.s2d_tails_lo_f_0.sb_A2 vref s2d_block_0.s2d_casc_n_f_0.x s2d_block_0.s2d_tails_lo_f_0.sb_A2 sg13_hv_pmos ad=3.4p pd=20.68u as=1.9p ps=10.38u w=10u l=1u
X159 pad Clamp_N_M1_0.gate iovss iovss sg13_hv_nmos ad=2.596p pd=5.58u as=1.408p ps=5.04u w=4.4u l=0.6u
X160 a_11758_26462# a_14374_27686# iovss rhigh l=12.65u w=0.5u
X161 s2d_block_0.s2d_casc_n_f_0.x s2d_block_0.sinks_6x6_s2d_c3_core_0.vbn iovss iovss sg13_hv_nmos ad=2.04p pd=12.68u as=2.04p ps=12.68u w=6u l=6u
X162 iovdd Clamp_P_M1_0.gate pad iovdd sg13_hv_pmos ad=2.1312p pd=7.3u as=3.9294p ps=7.84u w=6.66u l=0.6u
X163 s2d_block_0.s2d_tails_hi_f_0.vbp s2d_block_0.bias_tree_noab_n_c3_0.ni iovss iovss sg13_hv_nmos ad=2.04p pd=12.68u as=2.04p ps=12.68u w=6u l=6u
X164 pad Clamp_P_M1_0.gate iovdd iovdd sg13_hv_pmos ad=3.9294p pd=7.84u as=3.1302p ps=14.26u w=6.66u l=0.6u
X165 iovdd iovdd iovdd iovdd sg13_hv_pmos ad=3.4p pd=20.68u as=0 ps=0 w=10u l=1u
X166 iovss s2d_block_0.sinks_6x6_s2d_c3_core_0.vbn s2d_block_0.s2d_casc_n_f_0.xc iovss sg13_hv_nmos ad=2.04p pd=12.68u as=2.04p ps=12.68u w=6u l=6u
X167 Clamp_N_M1_0.gate iovss iovss rppd l=3.54u w=0.5u
X168 iovdd Clamp_P_M1_0.gate pad iovdd sg13_hv_pmos ad=2.1312p pd=7.3u as=3.9294p ps=7.84u w=6.66u l=0.6u
X169 iovss s2d_block_0.s2d_casc_n_f_0.vbnc iovss iovss sg13_hv_nmos ad=0.68p pd=4.68u as=0 ps=0 w=2u l=3u
X170 iovdd iovdd iovdd iovdd sg13_hv_pmos ad=1.9p pd=10.38u as=0 ps=0 w=10u l=1u
X171 s2d_block_0.s2d_tails_lo_f_0.sb_A1 s2d_block_0.s2d_tails_hi_f_0.vbp iovdd iovdd sg13_hv_pmos ad=1.7p pd=10.68u as=1.7p ps=10.68u w=5u l=6u
X172 pad Clamp_P_M1_0.gate iovdd iovdd sg13_hv_pmos ad=3.9294p pd=7.84u as=2.1312p ps=7.3u w=6.66u l=0.6u
X173 a_11758_26734# a_14374_27414# iovss rhigh l=12.65u w=0.5u
X174 pad Clamp_P_M1_0.gate iovdd iovdd sg13_hv_pmos ad=3.9294p pd=7.84u as=2.1312p ps=7.3u w=6.66u l=0.6u
X175 iovdd Clamp_P_M1_0.gate pad iovdd sg13_hv_pmos ad=2.1312p pd=7.3u as=3.9294p ps=7.84u w=6.66u l=0.6u
X176 iovdd Clamp_P_M1_0.gate pad iovdd sg13_hv_pmos ad=3.1302p pd=14.26u as=3.9294p ps=7.84u w=6.66u l=0.6u
X177 outn s2d_block_0.s2d_casc_p_f_0.vbpc s2d_block_0.s2d_loads_f_0.ln iovdd sg13_hv_pmos ad=5.1p pd=30.68u as=5.1p ps=30.68u w=15u l=3u
X178 s2d_block_0.s2d_casc_n_f_0.y pad s2d_block_0.s2d_tails_hi_f_0.sa_A2 s2d_block_0.s2d_tails_hi_f_0.sa_A2 sg13_hv_pmos ad=1.9p pd=10.38u as=3.4p ps=20.68u w=10u l=1u
X179 pad Clamp_P_M1_0.gate iovdd iovdd sg13_hv_pmos ad=3.9294p pd=7.84u as=2.1312p ps=7.3u w=6.66u l=0.6u
X180 iovss Clamp_N_M1_0.gate pad iovss sg13_hv_nmos ad=1.408p pd=5.04u as=2.596p ps=5.58u w=4.4u l=0.6u
X181 s2d_block_0.s2d_casc_n_f_0.yc outn s2d_block_0.s2d_tails_lo_f_0.sa_M2 s2d_block_0.s2d_tails_lo_f_0.sa_M2 sg13_hv_pmos ad=1.9p pd=10.38u as=3.4p ps=20.68u w=10u l=1u
X182 s2d_block_0.s2d_tails_lo_f_0.sb_A2 s2d_block_0.s2d_tails_hi_f_0.vbp iovdd iovdd sg13_hv_pmos ad=1.7p pd=10.68u as=1.7p ps=10.68u w=5u l=6u
X183 iovss s2d_block_0.sinks_6x6_s2d_c3_core_0.vbn s2d_block_0.s2d_casc_n_f_0.x iovss sg13_hv_nmos ad=2.04p pd=12.68u as=2.04p ps=12.68u w=6u l=6u
X184 iovss Clamp_N_M1_0.gate pad iovss sg13_hv_nmos ad=1.408p pd=5.04u as=2.596p ps=5.58u w=4.4u l=0.6u
X185 s2d_block_0.s2d_loads_f_0.lp s2d_block_0.s2d_loads_f_0.vcmfb iovdd iovdd sg13_hv_pmos ad=2.04p pd=12.68u as=2.04p ps=12.68u w=6u l=4u
X186 s2d_block_0.sinks_6x6_s2d_c3_core_0.vbn s2d_block_0.s2d_tails_hi_f_0.vbp iovdd iovdd sg13_hv_pmos ad=1.7p pd=10.68u as=1.7p ps=10.68u w=5u l=6u
X187 s2d_block_0.s2d_tails_lo_f_0.sb_M1 vcm s2d_block_0.s2d_casc_n_f_0.xc s2d_block_0.s2d_tails_lo_f_0.sb_M1 sg13_hv_pmos ad=3.4p pd=20.68u as=1.9p ps=10.38u w=10u l=1u
X188 outp s2d_block_0.s2d_casc_n_f_0.vbnc s2d_block_0.s2d_casc_n_f_0.x iovss sg13_hv_nmos ad=5.1p pd=30.68u as=5.1p ps=30.68u w=15u l=3u
X189 s2d_block_0.s2d_tails_hi_f_0.sa_M1 a_14374_26054# iovss rhigh l=12.65u w=0.5u
X190 iovss Clamp_N_M1_0.gate pad iovss sg13_hv_nmos ad=1.408p pd=5.04u as=2.596p ps=5.58u w=4.4u l=0.6u
X191 iovss s2d_block_0.s2d_casc_n_f_0.vbnc iovss iovss sg13_hv_nmos ad=0.68p pd=4.68u as=0 ps=0 w=2u l=3u
X192 iovss s2d_block_0.sinks_6x6_s2d_c3_core_0.vbn s2d_block_0.s2d_casc_n_f_0.x iovss sg13_hv_nmos ad=2.04p pd=12.68u as=2.04p ps=12.68u w=6u l=6u
X193 iovss s2d_block_0.sinks_6x6_s2d_c3_core_0.vbn iovss iovss sg13_hv_nmos ad=0.68p pd=4.68u as=0 ps=0 w=2u l=6u
X194 iovdd s2d_block_0.s2d_loads_f_0.vcmfb iovdd iovdd sg13_hv_pmos ad=0.34p pd=2.68u as=0 ps=0 w=1u l=4u
X195 outn en_3v3_b vcm iovss sg13_hv_nmos ad=0.34p pd=2.68u as=0.19p ps=1.38u w=1u l=0.45u
X196 s2d_block_0.s2d_tails_hi_f_0.sb_F2 vcm s2d_block_0.s2d_casc_n_f_0.x s2d_block_0.s2d_tails_hi_f_0.sb_F2 sg13_hv_pmos ad=3.4p pd=20.68u as=1.9p ps=10.38u w=10u l=1u
X197 iovss s2d_block_0.sinks_6x6_s2d_c3_core_0.vbn iovss iovss sg13_hv_nmos ad=0.68p pd=4.68u as=0 ps=0 w=2u l=6u
X198 s2d_block_0.s2d_casc_n_f_0.x s2d_block_0.sinks_6x6_s2d_c3_core_0.vbn iovss iovss sg13_hv_nmos ad=2.04p pd=12.68u as=2.04p ps=12.68u w=6u l=6u
X199 s2d_block_0.s2d_casc_n_f_0.y pad s2d_block_0.s2d_tails_hi_f_0.sa_A1 s2d_block_0.s2d_tails_hi_f_0.sa_A1 sg13_hv_pmos ad=1.9p pd=10.38u as=3.4p ps=20.68u w=10u l=1u
X200 s2d_block_0.s2d_tails_lo_f_0.sb_A1 a_14374_27142# iovss rhigh l=12.65u w=0.5u
X201 iovdd s2d_block_0.s2d_loads_f_0.vcmfb s2d_block_0.s2d_loads_f_0.dd iovdd sg13_hv_pmos ad=2.04p pd=12.68u as=2.04p ps=12.68u w=6u l=4u
X202 iovdd iovdd iovdd iovdd sg13_hv_pmos ad=1.9p pd=10.38u as=0 ps=0 w=10u l=1u
X203 iovdd Clamp_P_M1_0.gate pad iovdd sg13_hv_pmos ad=2.1312p pd=7.3u as=3.9294p ps=7.84u w=6.66u l=0.6u
X204 iovdd s2d_block_0.s2d_loads_f_0.vcmfb iovdd iovdd sg13_hv_pmos ad=0.34p pd=2.68u as=0 ps=0 w=1u l=4u
X205 a_11758_26598# a_14374_27550# iovss rhigh l=12.65u w=0.5u
X206 s2d_block_0.s2d_casc_n_f_0.xc s2d_block_0.s2d_casc_n_f_0.vbnc s2d_block_0.s2d_loads_f_0.vcmfb iovss sg13_hv_nmos ad=5.1p pd=30.68u as=5.1p ps=30.68u w=15u l=3u
X207 pad Clamp_P_M1_0.gate iovdd iovdd sg13_hv_pmos ad=3.9294p pd=7.84u as=2.1312p ps=7.3u w=6.66u l=0.6u
X208 s2d_block_0.s2d_tails_lo_f_0.sa_F1 s2d_block_0.s2d_tails_hi_f_0.vbp iovdd iovdd sg13_hv_pmos ad=1.7p pd=10.68u as=1.7p ps=10.68u w=5u l=6u
X209 iovdd Clamp_P_M1_0.gate pad iovdd sg13_hv_pmos ad=3.1302p pd=14.26u as=3.9294p ps=7.84u w=6.66u l=0.6u
X210 outp s2d_block_0.s2d_casc_p_f_0.vbpc s2d_block_0.s2d_loads_f_0.lp iovdd sg13_hv_pmos ad=5.1p pd=30.68u as=5.1p ps=30.68u w=15u l=3u
X211 iovdd s2d_block_0.s2d_tails_hi_f_0.vbp iovdd iovdd sg13_hv_pmos ad=0.68p pd=4.68u as=0 ps=0 w=2u l=6u
X212 a_11758_26870# a_14374_27278# iovss rhigh l=12.65u w=0.5u
X213 s2d_block_0.s2d_casc_n_f_0.vbnc s2d_block_0.s2d_casc_n_f_0.vbnc iovss iovss sg13_hv_nmos ad=0.34p pd=2.68u as=0.34p ps=2.68u w=1u l=8u
X214 pad Clamp_P_M1_0.gate iovdd iovdd sg13_hv_pmos ad=3.9294p pd=7.84u as=2.1312p ps=7.3u w=6.66u l=0.6u
X215 iovss s2d_block_0.sinks_6x6_s2d_c3_core_0.vbn s2d_block_0.s2d_casc_n_f_0.yc iovss sg13_hv_nmos ad=2.04p pd=12.68u as=2.04p ps=12.68u w=6u l=6u
X216 iovss Clamp_N_M1_0.gate pad iovss sg13_hv_nmos ad=1.408p pd=5.04u as=2.596p ps=5.58u w=4.4u l=0.6u
X217 s2d_block_0.s2d_tails_lo_f_0.sa_M2 a_14374_26190# iovss rhigh l=12.65u w=0.5u
X218 s2d_block_0.s2d_loads_f_0.vcmfb s2d_block_0.s2d_casc_n_f_0.vbnc s2d_block_0.s2d_casc_n_f_0.xc iovss sg13_hv_nmos ad=5.1p pd=30.68u as=5.1p ps=30.68u w=15u l=3u
X219 iovss pad dantenna l=1.26u w=27.78u
X220 s2d_block_0.s2d_loads_f_0.dd s2d_block_0.s2d_casc_p_f_0.vbpc s2d_block_0.s2d_loads_f_0.vcmfb iovdd sg13_hv_pmos ad=5.1p pd=30.68u as=5.1p ps=30.68u w=15u l=3u
X221 iovdd iovdd iovdd iovdd sg13_hv_pmos ad=3.4p pd=20.68u as=0 ps=0 w=10u l=1u
X222 s2d_block_0.s2d_casc_n_f_0.x vref s2d_block_0.s2d_tails_lo_f_0.sb_A1 s2d_block_0.s2d_tails_lo_f_0.sb_A1 sg13_hv_pmos ad=1.9p pd=10.38u as=3.4p ps=20.68u w=10u l=1u
X223 iovss Clamp_N_M1_0.gate pad iovss sg13_hv_nmos ad=1.408p pd=5.04u as=2.596p ps=5.58u w=4.4u l=0.6u
X224 iovss s2d_block_0.sinks_6x6_s2d_c3_core_0.vbn iovss iovss sg13_hv_nmos ad=0.68p pd=4.68u as=0 ps=0 w=2u l=6u
.ends

.subckt sg13cmos5l_IOPadDiff2Single iovdd iovss vdd pad vinp vinn vref iref en_3v3
+ en_3v3_b
X0 iovdd d2s_block_0.bias_tree_n_f2_0.vbpc iovdd iovdd sg13_hv_pmos ad=0.34p pd=2.68u as=0 ps=0 w=1u l=4u
X1 pad d2s_cma_0.a iovdd iovdd sg13_hv_pmos ad=3.9294p pd=7.84u as=2.1312p ps=7.3u w=6.66u l=0.6u
X2 pad Clamp_N_M1_wiring_0.b iovss iovss sg13_hv_nmos ad=2.596p pd=5.58u as=1.408p ps=5.04u w=4.4u l=1u
X3 d2s_block_0.d2s_sp2k_f2_1.core d2s_cma_0.a d2s_block_0.d2s_sp2k_f2_1.core d2s_block_0.d2s_sp2k_f2_1.core sg13_hv_pmos ad=2.7064p pd=16.6u as=0 ps=0 w=7.96u l=32.16u
X4 d2s_block_0.bias_tree_n_f2_0.ni en_3v3_b iref iovdd sg13_hv_pmos ad=0.34p pd=2.68u as=0.34p ps=2.68u w=1u l=0.45u
X5 iovss pad dantenna l=1.26u w=67.6u
X6 pad d2s_cma_0.a iovdd iovdd sg13_hv_pmos ad=3.9294p pd=7.84u as=2.1312p ps=7.3u w=6.66u l=0.6u
X7 d2s_block_0.sinks_6x6_f2_0.vbn d2s_block_0.sinks_6x6_f2_0.vbn d2s_block_0.sinks_6x6_f2_0.vbn iovss sg13_hv_nmos ad=0.68p pd=4.68u as=0 ps=0 w=2u l=6u
X8 iovss en_3v3_b Clamp_N_M1_wiring_0.b iovss sg13_hv_nmos ad=0.34p pd=2.68u as=0.34p ps=2.68u w=1u l=0.45u
X9 d2s_block_0.d2s_sp2k_f2_0.core pad iovss rppd l=7.435u w=1u
X10 iovdd d2s_cma_0.a pad iovdd sg13_hv_pmos ad=2.1312p pd=7.3u as=3.9294p ps=7.84u w=6.66u l=0.6u
X11 iovss Clamp_N_M1_wiring_0.b pad iovss sg13_hv_nmos ad=1.408p pd=5.04u as=2.596p ps=5.58u w=4.4u l=1u
X12 iovss d2s_block_0.sinks_6x6_f2_0.vbn d2s_block_0.d2s_casc_n_f2_0.y iovss sg13_hv_nmos ad=2.04p pd=12.68u as=2.04p ps=12.68u w=6u l=6u
X13 d2s_block_0.d2s_ab_n_f2_0.l1 d2s_block_0.bias_tree_n_f2_0.vabp d2s_block_0.d2s_ab_n_f2_0.l2 iovdd sg13_hv_pmos ad=2.2644p pd=14u as=2.2644p ps=14u w=6.66u l=0.6u
X14 d2s_block_0.d2s_ab_n_f2_0.l1 d2s_block_0.d2s_ab_n_f2_0.vabn d2s_block_0.d2s_ab_n_f2_0.l2 iovss sg13_hv_nmos ad=1.496p pd=9.48u as=1.496p ps=9.48u w=4.4u l=1u
X15 pad d2s_cma_0.a iovdd iovdd sg13_hv_pmos ad=3.9294p pd=7.84u as=2.1312p ps=7.3u w=6.66u l=0.6u
X16 pad Clamp_N_M1_wiring_0.b iovss iovss sg13_hv_nmos ad=2.596p pd=5.58u as=1.408p ps=5.04u w=4.4u l=1u
X17 d2s_block_0.d2s_casc_n_f2_0.y vref d2s_block_0.d2s_rhigh_f2_0.sa_C2 d2s_block_0.d2s_rhigh_f2_0.sa_C2 sg13_hv_pmos ad=1.9p pd=10.38u as=3.4p ps=20.68u w=10u l=1u
X18 iovss d2s_block_0.sinks_6x6_f2_0.vbn d2s_block_0.d2s_casc_n_f2_0.x iovss sg13_hv_nmos ad=2.04p pd=12.68u as=2.04p ps=12.68u w=6u l=6u
X19 iovdd d2s_block_0.d2s_ab_n_f2_0.l2 d2s_block_0.d2s_casc_p_c2_0.pr iovdd sg13_hv_pmos ad=2.04p pd=12.68u as=2.04p ps=12.68u w=6u l=4u
X20 pad d2s_cma_0.a iovdd iovdd sg13_hv_pmos ad=3.9294p pd=7.84u as=2.1312p ps=7.3u w=6.66u l=0.6u
X21 pad iovdd dpantenna l=1.26u w=65.8u
X22 iovss d2s_block_0.d2s_casc_n_f2_0.vbnc d2s_block_0.d2s_casc_n_f2_0.vbnc iovss sg13_hv_nmos ad=0.34p pd=2.68u as=0.34p ps=2.68u w=1u l=8u
X23 pad d2s_cma_0.a iovdd iovdd sg13_hv_pmos ad=4.9284p pd=14.8u as=2.1312p ps=7.3u w=6.66u l=0.6u
X24 d2s_block_0.d2s_casc_n_f2_0.x pad d2s_block_0.d2s_rhigh_f2_0.sb_C2 d2s_block_0.d2s_rhigh_f2_0.sb_C2 sg13_hv_pmos ad=1.9p pd=10.38u as=3.4p ps=20.68u w=10u l=1u
X25 iovss Clamp_N_M1_wiring_0.b pad iovss sg13_hv_nmos ad=1.408p pd=5.04u as=2.596p ps=5.58u w=4.4u l=1u
X26 pad d2s_cma_0.a iovdd iovdd sg13_hv_pmos ad=3.9294p pd=7.84u as=2.1312p ps=7.3u w=6.66u l=0.6u
X27 pad Clamp_N_M1_wiring_0.b iovss iovss sg13_hv_nmos ad=2.596p pd=5.58u as=1.408p ps=5.04u w=4.4u l=1u
X28 pad Clamp_N_M1_wiring_0.b iovss iovss sg13_hv_nmos ad=2.596p pd=5.58u as=1.408p ps=5.04u w=4.4u l=1u
X29 iovdd d2s_cma_0.a pad iovdd sg13_hv_pmos ad=2.1312p pd=7.3u as=3.9294p ps=7.84u w=6.66u l=0.6u
X30 iovdd d2s_cma_0.a pad iovdd sg13_hv_pmos ad=2.1312p pd=7.3u as=3.9294p ps=7.84u w=6.66u l=0.6u
X31 d2s_block_0.d2s_casc_p_c2_0.pr d2s_block_0.bias_tree_n_f2_0.vbpc d2s_cma_0.a iovdd sg13_hv_pmos ad=5.1p pd=30.68u as=5.1p ps=30.68u w=15u l=3u
X32 d2s_block_0.d2s_casc_p_c2_0.pl d2s_block_0.d2s_ab_n_f2_0.l2 iovdd iovdd sg13_hv_pmos ad=2.04p pd=12.68u as=2.04p ps=12.68u w=6u l=4u
X33 iovdd d2s_cma_0.a pad iovdd sg13_hv_pmos ad=2.1312p pd=7.3u as=3.9294p ps=7.84u w=6.66u l=0.6u
X34 iovss Clamp_N_M1_wiring_0.b pad iovss sg13_hv_nmos ad=1.408p pd=5.04u as=2.596p ps=5.58u w=4.4u l=1u
X35 iovss Clamp_N_M1_wiring_0.b pad iovss sg13_hv_nmos ad=1.408p pd=5.04u as=2.596p ps=5.58u w=4.4u l=1u
X36 iovss Clamp_N_M1_wiring_0.b pad iovss sg13_hv_nmos ad=1.408p pd=5.04u as=2.596p ps=5.58u w=4.4u l=1u
X37 iovdd d2s_cma_0.a pad iovdd sg13_hv_pmos ad=2.1312p pd=7.3u as=3.9294p ps=7.84u w=6.66u l=0.6u
X38 pad d2s_cma_0.a iovdd iovdd sg13_hv_pmos ad=3.9294p pd=7.84u as=2.1312p ps=7.3u w=6.66u l=0.6u
X39 pad d2s_cma_0.a iovdd iovdd sg13_hv_pmos ad=3.9294p pd=7.84u as=2.1312p ps=7.3u w=6.66u l=0.6u
X40 pad Clamp_N_M1_wiring_0.b iovss iovss sg13_hv_nmos ad=2.596p pd=5.58u as=1.408p ps=5.04u w=4.4u l=1u
X41 iovdd d2s_block_0.d2s_ab_n_f2_0.l2 d2s_block_0.d2s_casc_p_c2_0.pr iovdd sg13_hv_pmos ad=2.04p pd=12.68u as=2.04p ps=12.68u w=6u l=4u
X42 pad Clamp_N_M1_wiring_0.b iovss iovss sg13_hv_nmos ad=2.596p pd=5.58u as=1.408p ps=5.04u w=4.4u l=1u
X43 iovdd d2s_cma_0.a pad iovdd sg13_hv_pmos ad=2.1312p pd=7.3u as=3.9294p ps=7.84u w=6.66u l=0.6u
X44 iovdd d2s_block_0.bias_tree_n_f2_0.vbp d2s_block_0.d2s_ab_n_f2_0.vabn iovdd sg13_hv_pmos ad=1.7p pd=10.68u as=1.7p ps=10.68u w=5u l=6u
X45 a_10598_32196# a_10462_29580# iovss rhigh l=12.65u w=0.5u
X46 iovdd d2s_block_0.bias_tree_n_f2_0.vbpc d2s_block_0.bias_tree_n_f2_0.vbpc iovdd sg13_hv_pmos ad=0.34p pd=2.68u as=0.34p ps=2.68u w=1u l=4u
X47 pad d2s_cma_0.a iovdd iovdd sg13_hv_pmos ad=3.9294p pd=7.84u as=2.1312p ps=7.3u w=6.66u l=0.6u
X48 iovss Clamp_N_M1_wiring_0.b pad iovss sg13_hv_nmos ad=1.408p pd=5.04u as=2.596p ps=5.58u w=4.4u l=1u
X49 iovss d2s_block_0.bias_tree_n_f2_0.ni d2s_block_0.bias_tree_n_f2_0.vbp iovss sg13_hv_nmos ad=2.04p pd=12.68u as=2.04p ps=12.68u w=6u l=6u
X50 iovss d2s_block_0.bias_tree_n_f2_0.ni d2s_block_0.bias_tree_n_f2_0.ni iovss sg13_hv_nmos ad=2.04p pd=12.68u as=2.04p ps=12.68u w=6u l=6u
X51 pad Clamp_N_M1_wiring_0.b iovss iovss sg13_hv_nmos ad=2.596p pd=5.58u as=1.408p ps=5.04u w=4.4u l=1u
X52 Clamp_N_M1_wiring_0.b d2s_block_0.d2s_sp2k_f2_0.core Clamp_N_M1_wiring_0.b Clamp_N_M1_wiring_0.b sg13_hv_pmos ad=2.7064p pd=16.6u as=0 ps=0 w=7.96u l=32.16u
X53 d2s_block_0.sinks_6x6_f2_0.vbn d2s_block_0.sinks_6x6_f2_0.vbn d2s_block_0.sinks_6x6_f2_0.vbn iovss sg13_hv_nmos ad=0.68p pd=4.68u as=0 ps=0 w=2u l=6u
X54 d2s_block_0.d2s_casc_p_c2_0.pl d2s_block_0.d2s_ab_n_f2_0.l2 iovdd iovdd sg13_hv_pmos ad=2.04p pd=12.68u as=2.04p ps=12.68u w=6u l=4u
X55 iovdd d2s_cma_0.a pad iovdd sg13_hv_pmos ad=2.1312p pd=7.3u as=3.9294p ps=7.84u w=6.66u l=0.6u
X56 pad Clamp_N_M1_wiring_0.b iovss iovss sg13_hv_nmos ad=2.596p pd=5.58u as=1.408p ps=5.04u w=4.4u l=1u
X57 pad d2s_cma_0.a iovdd iovdd sg13_hv_pmos ad=3.9294p pd=7.84u as=2.1312p ps=7.3u w=6.66u l=0.6u
X58 iovdd d2s_cma_0.a pad iovdd sg13_hv_pmos ad=2.1312p pd=7.3u as=3.9294p ps=7.84u w=6.66u l=0.6u
X59 iovss Clamp_N_M1_wiring_0.b pad iovss sg13_hv_nmos ad=1.408p pd=5.04u as=2.596p ps=5.58u w=4.4u l=1u
X60 iovss d2s_block_0.d2s_sp2k_f2_1.core dantenna l=3.1u w=0.64u
X61 d2s_block_0.d2s_rhigh_f2_0.sb_A d2s_block_0.bias_tree_n_f2_0.vbp iovdd iovdd sg13_hv_pmos ad=1.7p pd=10.68u as=1.7p ps=10.68u w=5u l=6u
X62 iovss d2s_block_0.sinks_6x6_f2_0.vbn d2s_block_0.d2s_casc_n_f2_0.y iovss sg13_hv_nmos ad=2.04p pd=12.68u as=2.04p ps=12.68u w=6u l=6u
X63 d2s_block_0.d2s_rhigh_f2_0.sa_B vref d2s_block_0.d2s_casc_n_f2_0.y d2s_block_0.d2s_rhigh_f2_0.sa_B sg13_hv_pmos ad=3.4p pd=20.68u as=1.9p ps=10.38u w=10u l=1u
X64 d2s_block_0.d2s_casc_n_f2_0.y vref d2s_block_0.d2s_rhigh_f2_0.sa_C1 d2s_block_0.d2s_rhigh_f2_0.sa_C1 sg13_hv_pmos ad=1.9p pd=10.38u as=3.4p ps=20.68u w=10u l=1u
X65 d2s_block_0.d2s_casc_n_f2_0.y d2s_block_0.sinks_6x6_f2_0.vbn iovss iovss sg13_hv_nmos ad=2.04p pd=12.68u as=2.04p ps=12.68u w=6u l=6u
X66 iovdd d2s_cma_0.a pad iovdd sg13_hv_pmos ad=2.1312p pd=7.3u as=3.9294p ps=7.84u w=6.66u l=0.6u
X67 pad d2s_cma_0.a iovdd iovdd sg13_hv_pmos ad=3.9294p pd=7.84u as=2.1312p ps=7.3u w=6.66u l=0.6u
X68 iovdd d2s_block_0.bias_tree_n_f2_0.vbp iovdd iovdd sg13_hv_pmos ad=0.68p pd=4.68u as=0 ps=0 w=2u l=6u
X69 d2s_block_0.bias_tree_n_f2_0.ni en_3v3 iref iovss sg13_hv_nmos ad=0.34p pd=2.68u as=0.34p ps=2.68u w=1u l=0.45u
X70 pad Clamp_N_M1_wiring_0.b iovss iovss sg13_hv_nmos ad=2.596p pd=5.58u as=1.408p ps=5.04u w=4.4u l=1u
X71 iovdd en_3v3 d2s_cma_0.a iovdd sg13_hv_pmos ad=0.34p pd=2.68u as=0.34p ps=2.68u w=1u l=0.45u
X72 pad iovdd dpantenna l=1.26u w=65.8u
X73 d2s_block_0.bias_tree_n_f2_0.ni en_3v3_b iovss iovss sg13_hv_nmos ad=0.34p pd=2.68u as=0.34p ps=2.68u w=1u l=0.45u
X74 d2s_block_0.d2s_sp2k_f2_1.core pad iovss rppd l=7.435u w=1u
X75 iovdd d2s_cma_0.a pad iovdd sg13_hv_pmos ad=2.1312p pd=7.3u as=3.9294p ps=7.84u w=6.66u l=0.6u
X76 iovss Clamp_N_M1_wiring_0.b pad iovss sg13_hv_nmos ad=1.408p pd=5.04u as=2.596p ps=5.58u w=4.4u l=1u
X77 iovss Clamp_N_M1_wiring_0.b pad iovss sg13_hv_nmos ad=1.408p pd=5.04u as=2.596p ps=5.58u w=4.4u l=1u
X78 iovdd d2s_cma_0.a pad iovdd sg13_hv_pmos ad=2.1312p pd=7.3u as=3.9294p ps=7.84u w=6.66u l=0.6u
X79 d2s_block_0.d2s_rhigh_f2_0.sb_C1 pad d2s_block_0.d2s_casc_n_f2_0.x d2s_block_0.d2s_rhigh_f2_0.sb_C1 sg13_hv_pmos ad=3.4p pd=20.68u as=1.9p ps=10.38u w=10u l=1u
X80 a_9510_32196# d2s_block_0.d2s_rhigh_f2_0.sa_A iovss rhigh l=12.65u w=0.5u
X81 iovdd iovdd iovdd iovdd sg13_hv_pmos ad=3.4p pd=20.68u as=0 ps=0 w=10u l=1u
X82 iovdd d2s_block_0.bias_tree_n_f2_0.vbp iovdd iovdd sg13_hv_pmos ad=1.7p pd=10.68u as=0 ps=0 w=5u l=6u
X83 iovss Clamp_N_M1_wiring_0.b pad iovss sg13_hv_nmos ad=1.408p pd=5.04u as=2.596p ps=5.58u w=4.4u l=1u
X84 d2s_block_0.d2s_ab_n_f2_0.l2 d2s_block_0.bias_tree_n_f2_0.vbpc d2s_block_0.d2s_casc_p_c2_0.pl iovdd sg13_hv_pmos ad=5.1p pd=30.68u as=5.1p ps=30.68u w=15u l=3u
X85 pad d2s_cma_0.a iovdd iovdd sg13_hv_pmos ad=3.9294p pd=7.84u as=2.1312p ps=7.3u w=6.66u l=0.6u
X86 iovdd d2s_cma_0.a pad iovdd sg13_hv_pmos ad=2.1312p pd=7.3u as=3.9294p ps=7.84u w=6.66u l=0.6u
X87 iovdd iovdd iovdd iovdd sg13_hv_pmos ad=2.2644p pd=14u as=0 ps=0 w=6.66u l=0.6u
X88 iovss Clamp_N_M1_wiring_0.b pad iovss sg13_hv_nmos ad=1.408p pd=5.04u as=2.596p ps=5.58u w=4.4u l=1u
X89 pad Clamp_N_M1_wiring_0.b iovss iovss sg13_hv_nmos ad=2.596p pd=5.58u as=2.068p ps=9.74u w=4.4u l=1u
X90 pad Clamp_N_M1_wiring_0.b iovss iovss sg13_hv_nmos ad=2.596p pd=5.58u as=1.408p ps=5.04u w=4.4u l=1u
X91 iovss d2s_block_0.bias_tree_n_f2_0.ni d2s_block_0.bias_tree_n_f2_0.vbpc iovss sg13_hv_nmos ad=0.816p pd=5.48u as=0.816p ps=5.48u w=2.4u l=6u
X92 a_10734_32196# d2s_block_0.d2s_rhigh_f2_0.sb_B iovss rhigh l=12.65u w=0.5u
X93 Clamp_P_M1_wiring_0.dabp d2s_block_0.bias_tree_n_f2_0.vabp d2s_block_0.bias_tree_n_f2_0.vabp iovdd sg13_hv_pmos ad=2.2644p pd=14u as=2.2644p ps=14u w=6.66u l=0.6u
X94 pad d2s_cma_0.a iovdd iovdd sg13_hv_pmos ad=3.9294p pd=7.84u as=2.1312p ps=7.3u w=6.66u l=0.6u
X95 d2s_block_0.d2s_rhigh_f2_0.sa_C1 d2s_block_0.bias_tree_n_f2_0.vbp iovdd iovdd sg13_hv_pmos ad=1.7p pd=10.68u as=1.7p ps=10.68u w=5u l=6u
X96 a_11006_32196# a_10054_29580# iovss rhigh l=12.65u w=0.5u
X97 pad d2s_cma_0.a iovdd iovdd sg13_hv_pmos ad=3.9294p pd=7.84u as=2.1312p ps=7.3u w=6.66u l=0.6u
X98 iovss Clamp_N_M1_wiring_0.b pad iovss sg13_hv_nmos ad=1.408p pd=5.04u as=2.596p ps=5.58u w=4.4u l=1u
X99 iovss Clamp_N_M1_wiring_0.b pad iovss sg13_hv_nmos ad=1.408p pd=5.04u as=2.596p ps=5.58u w=4.4u l=1u
X100 iovdd d2s_cma_0.a pad iovdd sg13_hv_pmos ad=2.1312p pd=7.3u as=3.9294p ps=7.84u w=6.66u l=0.6u
X101 iovdd d2s_block_0.bias_tree_n_f2_0.vbp d2s_block_0.sinks_6x6_f2_0.vbn iovdd sg13_hv_pmos ad=1.7p pd=10.68u as=1.7p ps=10.68u w=5u l=6u
X102 d2s_block_0.d2s_rhigh_f2_0.sb_A vref d2s_block_0.d2s_casc_n_f2_0.x d2s_block_0.d2s_rhigh_f2_0.sb_A sg13_hv_pmos ad=3.4p pd=20.68u as=1.9p ps=10.38u w=10u l=1u
X103 Clamp_N_M1_wiring_0.b d2s_block_0.d2s_ab_n_f2_0.vabn d2s_cma_0.a iovss sg13_hv_nmos ad=1.496p pd=9.48u as=1.496p ps=9.48u w=4.4u l=1u
X104 pad Clamp_N_M1_wiring_0.b iovss iovss sg13_hv_nmos ad=3.256p pd=10.28u as=1.408p ps=5.04u w=4.4u l=1u
X105 d2s_block_0.d2s_casc_n_f2_0.y vinp d2s_block_0.d2s_rhigh_f2_0.sa_A d2s_block_0.d2s_rhigh_f2_0.sa_A sg13_hv_pmos ad=1.9p pd=10.38u as=3.4p ps=20.68u w=10u l=1u
X106 pad Clamp_N_M1_wiring_0.b iovss iovss sg13_hv_nmos ad=2.596p pd=5.58u as=1.408p ps=5.04u w=4.4u l=1u
X107 d2s_block_0.d2s_casc_n_f2_0.y d2s_block_0.sinks_6x6_f2_0.vbn iovss iovss sg13_hv_nmos ad=2.04p pd=12.68u as=2.04p ps=12.68u w=6u l=6u
X108 iovdd d2s_cma_0.a pad iovdd sg13_hv_pmos ad=2.1312p pd=7.3u as=3.9294p ps=7.84u w=6.66u l=0.6u
X109 d2s_block_0.sinks_6x6_f2_0.vbn d2s_block_0.sinks_6x6_f2_0.vbn d2s_block_0.sinks_6x6_f2_0.vbn iovss sg13_hv_nmos ad=2.04p pd=12.68u as=0 ps=0 w=6u l=6u
X110 d2s_block_0.sinks_6x6_f2_0.vbn d2s_block_0.sinks_6x6_f2_0.vbn d2s_block_0.sinks_6x6_f2_0.vbn iovss sg13_hv_nmos ad=0.68p pd=4.68u as=0 ps=0 w=2u l=6u
X111 iovss Clamp_N_M1_wiring_0.b pad iovss sg13_hv_nmos ad=1.408p pd=5.04u as=2.596p ps=5.58u w=4.4u l=1u
X112 d2s_block_0.d2s_casc_n_f2_0.vbnc d2s_block_0.d2s_casc_n_f2_0.vbnc d2s_block_0.d2s_casc_n_f2_0.vbnc iovss sg13_hv_nmos ad=0.68p pd=4.68u as=0 ps=0 w=2u l=3u
X113 iovss iovss iovss iovss sg13_hv_nmos ad=1.496p pd=9.48u as=0 ps=0 w=4.4u l=1u
X114 d2s_block_0.d2s_sp2k_f2_0.core iovdd dpantenna l=0.64u w=4.98u
X115 iovdd d2s_cma_0.a pad iovdd sg13_hv_pmos ad=2.1312p pd=7.3u as=3.9294p ps=7.84u w=6.66u l=0.6u
X116 iovdd Clamp_P_M1_wiring_0.dabp Clamp_P_M1_wiring_0.dabp iovdd sg13_hv_pmos ad=2.1312p pd=7.3u as=3.9294p ps=7.84u w=6.66u l=0.6u
X117 iovdd d2s_block_0.d2s_ab_n_f2_0.l2 iovdd iovdd sg13_hv_pmos ad=0.34p pd=2.68u as=0 ps=0 w=1u l=4u
X118 pad d2s_cma_0.a iovdd iovdd sg13_hv_pmos ad=3.9294p pd=7.84u as=2.1312p ps=7.3u w=6.66u l=0.6u
X119 iovdd d2s_cma_0.a pad iovdd sg13_hv_pmos ad=2.1312p pd=7.3u as=3.9294p ps=7.84u w=6.66u l=0.6u
X120 d2s_block_0.d2s_rhigh_f2_0.sa_C2 vref d2s_block_0.d2s_casc_n_f2_0.y d2s_block_0.d2s_rhigh_f2_0.sa_C2 sg13_hv_pmos ad=3.4p pd=20.68u as=1.9p ps=10.38u w=10u l=1u
X121 d2s_block_0.d2s_rhigh_f2_0.sa_C2 d2s_block_0.bias_tree_n_f2_0.vbp iovdd iovdd sg13_hv_pmos ad=1.7p pd=10.68u as=1.7p ps=10.68u w=5u l=6u
X122 d2s_block_0.d2s_rhigh_f2_0.sa_A vinp d2s_block_0.d2s_casc_n_f2_0.y d2s_block_0.d2s_rhigh_f2_0.sa_A sg13_hv_pmos ad=3.4p pd=20.68u as=1.9p ps=10.38u w=10u l=1u
X123 Clamp_N_M1_wiring_0.b d2s_block_0.d2s_casc_n_f2_0.vbnc d2s_block_0.d2s_casc_n_f2_0.y iovss sg13_hv_nmos ad=5.1p pd=30.68u as=5.1p ps=30.68u w=15u l=3u
X124 iovss Clamp_N_M1_wiring_0.b pad iovss sg13_hv_nmos ad=1.408p pd=5.04u as=2.596p ps=5.58u w=4.4u l=1u
X125 iovdd iovdd iovdd iovdd sg13_hv_pmos ad=3.4p pd=20.68u as=0 ps=0 w=10u l=1u
X126 iovss d2s_block_0.sinks_6x6_f2_0.vbn d2s_block_0.d2s_casc_n_f2_0.x iovss sg13_hv_nmos ad=2.04p pd=12.68u as=2.04p ps=12.68u w=6u l=6u
X127 pad d2s_cma_0.a iovdd iovdd sg13_hv_pmos ad=3.9294p pd=7.84u as=2.1312p ps=7.3u w=6.66u l=0.6u
X128 pad Clamp_N_M1_wiring_0.b iovss iovss sg13_hv_nmos ad=2.596p pd=5.58u as=1.408p ps=5.04u w=4.4u l=1u
X129 pad Clamp_N_M1_wiring_0.b iovss iovss sg13_hv_nmos ad=2.596p pd=5.58u as=1.408p ps=5.04u w=4.4u l=1u
X130 iovdd d2s_cma_0.a pad iovdd sg13_hv_pmos ad=2.1312p pd=7.3u as=3.9294p ps=7.84u w=6.66u l=0.6u
X131 pad d2s_cma_0.a iovdd iovdd sg13_hv_pmos ad=3.9294p pd=7.84u as=2.1312p ps=7.3u w=6.66u l=0.6u
X132 pad Clamp_N_M1_wiring_0.b iovss iovss sg13_hv_nmos ad=2.596p pd=5.58u as=1.408p ps=5.04u w=4.4u l=1u
X133 a_10598_32196# d2s_block_0.d2s_rhigh_f2_0.sb_A iovss rhigh l=12.65u w=0.5u
X134 iovdd d2s_block_0.d2s_ab_n_f2_0.l2 iovdd iovdd sg13_hv_pmos ad=0.34p pd=2.68u as=0 ps=0 w=1u l=4u
X135 iovdd d2s_cma_0.a pad iovdd sg13_hv_pmos ad=2.1312p pd=7.3u as=3.9294p ps=7.84u w=6.66u l=0.6u
X136 pad d2s_cma_0.a iovdd iovdd sg13_hv_pmos ad=3.9294p pd=7.84u as=3.1302p ps=14.26u w=6.66u l=0.6u
X137 iovdd d2s_block_0.bias_tree_n_f2_0.vbp iovdd iovdd sg13_hv_pmos ad=1.7p pd=10.68u as=0 ps=0 w=5u l=6u
X138 a_11006_32196# d2s_block_0.d2s_rhigh_f2_0.sb_C2 iovss rhigh l=12.65u w=0.5u
X139 iovss Clamp_N_M1_wiring_0.b pad iovss sg13_hv_nmos ad=1.408p pd=5.04u as=2.596p ps=5.58u w=4.4u l=1u
X140 iovss Clamp_N_M1_wiring_0.b pad iovss sg13_hv_nmos ad=1.408p pd=5.04u as=2.596p ps=5.58u w=4.4u l=1u
X141 iovss Clamp_N_M1_wiring_0.b pad iovss sg13_hv_nmos ad=1.408p pd=5.04u as=2.596p ps=5.58u w=4.4u l=1u
X142 pad d2s_cma_0.a iovdd iovdd sg13_hv_pmos ad=3.9294p pd=7.84u as=2.1312p ps=7.3u w=6.66u l=0.6u
X143 pad Clamp_N_M1_wiring_0.b iovss iovss sg13_hv_nmos ad=2.596p pd=5.58u as=1.408p ps=5.04u w=4.4u l=1u
X144 d2s_block_0.d2s_casc_n_f2_0.vbnc d2s_block_0.d2s_casc_n_f2_0.vbnc d2s_block_0.d2s_casc_n_f2_0.vbnc iovss sg13_hv_nmos ad=0.68p pd=4.68u as=0 ps=0 w=2u l=3u
X145 pad Clamp_N_M1_wiring_0.b iovss iovss sg13_hv_nmos ad=2.596p pd=5.58u as=1.408p ps=5.04u w=4.4u l=1u
X146 iovdd iovdd iovdd iovdd sg13_hv_pmos ad=1.9p pd=10.38u as=0 ps=0 w=10u l=1u
X147 iovdd d2s_cma_0.a pad iovdd sg13_hv_pmos ad=2.1312p pd=7.3u as=3.9294p ps=7.84u w=6.66u l=0.6u
X148 d2s_block_0.d2s_casc_n_f2_0.x vinn d2s_block_0.d2s_rhigh_f2_0.sb_B d2s_block_0.d2s_rhigh_f2_0.sb_B sg13_hv_pmos ad=1.9p pd=10.38u as=3.4p ps=20.68u w=10u l=1u
X149 iovdd d2s_block_0.d2s_ab_n_f2_0.l2 d2s_block_0.d2s_casc_p_c2_0.pl iovdd sg13_hv_pmos ad=2.04p pd=12.68u as=2.04p ps=12.68u w=6u l=4u
X150 iovdd d2s_cma_0.a pad iovdd sg13_hv_pmos ad=2.1312p pd=7.3u as=3.9294p ps=7.84u w=6.66u l=0.6u
X151 iovdd Clamp_P_M1_wiring_0.dabp Clamp_P_M1_wiring_0.dabp iovdd sg13_hv_pmos ad=2.1312p pd=7.3u as=3.9294p ps=7.84u w=6.66u l=0.6u
X152 iovss Clamp_N_M1_wiring_0.b pad iovss sg13_hv_nmos ad=1.408p pd=5.04u as=2.596p ps=5.58u w=4.4u l=1u
X153 iovdd d2s_block_0.bias_tree_n_f2_0.vbp d2s_block_0.d2s_rhigh_f2_0.sa_B iovdd sg13_hv_pmos ad=1.7p pd=10.68u as=1.7p ps=10.68u w=5u l=6u
X154 a_9918_32196# d2s_block_0.d2s_rhigh_f2_0.sa_C2 iovss rhigh l=12.65u w=0.5u
X155 d2s_block_0.d2s_casc_n_f2_0.x d2s_block_0.d2s_casc_n_f2_0.vbnc d2s_block_0.d2s_ab_n_f2_0.l1 iovss sg13_hv_nmos ad=5.1p pd=30.68u as=5.1p ps=30.68u w=15u l=3u
X156 pad d2s_cma_0.a iovdd iovdd sg13_hv_pmos ad=3.9294p pd=7.84u as=2.1312p ps=7.3u w=6.66u l=0.6u
X157 pad Clamp_N_M1_wiring_0.b iovss iovss sg13_hv_nmos ad=2.596p pd=5.58u as=1.408p ps=5.04u w=4.4u l=1u
X158 pad Clamp_N_M1_wiring_0.b iovss iovss sg13_hv_nmos ad=2.596p pd=5.58u as=1.408p ps=5.04u w=4.4u l=1u
X159 d2s_block_0.d2s_casc_n_f2_0.y vref d2s_block_0.d2s_rhigh_f2_0.sa_B d2s_block_0.d2s_rhigh_f2_0.sa_B sg13_hv_pmos ad=1.9p pd=10.38u as=3.4p ps=20.68u w=10u l=1u
X160 d2s_block_0.d2s_sp2k_f2_1.core iovdd dpantenna l=0.64u w=4.98u
X161 iovdd d2s_cma_0.a pad iovdd sg13_hv_pmos ad=2.1312p pd=7.3u as=3.9294p ps=7.84u w=6.66u l=0.6u
X162 d2s_block_0.d2s_ab_n_f2_0.l1 d2s_block_0.d2s_casc_n_f2_0.vbnc d2s_block_0.d2s_casc_n_f2_0.x iovss sg13_hv_nmos ad=5.1p pd=30.68u as=5.1p ps=30.68u w=15u l=3u
X163 iovdd d2s_cma_0.a pad iovdd sg13_hv_pmos ad=2.1312p pd=7.3u as=3.9294p ps=7.84u w=6.66u l=0.6u
X164 iovss Clamp_N_M1_wiring_0.b pad iovss sg13_hv_nmos ad=1.408p pd=5.04u as=2.596p ps=5.58u w=4.4u l=1u
X165 d2s_block_0.d2s_rhigh_f2_0.sb_B d2s_block_0.bias_tree_n_f2_0.vbp iovdd iovdd sg13_hv_pmos ad=1.7p pd=10.68u as=1.7p ps=10.68u w=5u l=6u
X166 d2s_block_0.d2s_casc_p_c2_0.pr d2s_block_0.d2s_ab_n_f2_0.l2 iovdd iovdd sg13_hv_pmos ad=2.04p pd=12.68u as=2.04p ps=12.68u w=6u l=4u
X167 iovss Clamp_N_M1_wiring_0.b pad iovss sg13_hv_nmos ad=1.408p pd=5.04u as=2.596p ps=5.58u w=4.4u l=1u
X168 pad d2s_cma_0.a iovdd iovdd sg13_hv_pmos ad=3.9294p pd=7.84u as=3.1302p ps=14.26u w=6.66u l=0.6u
X169 Clamp_N_M1_wiring_0.dabn Clamp_N_M1_wiring_0.dabn iovss iovss sg13_hv_nmos ad=2.596p pd=5.58u as=1.408p ps=5.04u w=4.4u l=1u
X170 iovdd d2s_cma_0.a pad iovdd sg13_hv_pmos ad=2.1312p pd=7.3u as=3.9294p ps=7.84u w=6.66u l=0.6u
X171 d2s_block_0.d2s_casc_n_f2_0.x d2s_block_0.sinks_6x6_f2_0.vbn iovss iovss sg13_hv_nmos ad=2.04p pd=12.68u as=2.04p ps=12.68u w=6u l=6u
X172 a_10734_32196# a_10326_29580# iovss rhigh l=12.65u w=0.5u
X173 d2s_block_0.d2s_rhigh_f2_0.sb_B vinn d2s_block_0.d2s_casc_n_f2_0.x d2s_block_0.d2s_rhigh_f2_0.sb_B sg13_hv_pmos ad=3.4p pd=20.68u as=1.9p ps=10.38u w=10u l=1u
X174 pad d2s_cma_0.a iovdd iovdd sg13_hv_pmos ad=3.9294p pd=7.84u as=2.1312p ps=7.3u w=6.66u l=0.6u
X175 iovdd d2s_block_0.bias_tree_n_f2_0.vbp d2s_block_0.d2s_casc_n_f2_0.vbnc iovdd sg13_hv_pmos ad=0.68p pd=4.68u as=0.68p ps=4.68u w=2u l=6u
X176 a_9646_32196# a_10326_29580# iovss rhigh l=12.65u w=0.5u
X177 pad d2s_cma_0.a iovdd iovdd sg13_hv_pmos ad=3.9294p pd=7.84u as=2.1312p ps=7.3u w=6.66u l=0.6u
X178 iovdd d2s_block_0.d2s_ab_n_f2_0.l2 d2s_block_0.d2s_casc_p_c2_0.pl iovdd sg13_hv_pmos ad=2.04p pd=12.68u as=2.04p ps=12.68u w=6u l=4u
X179 d2s_block_0.d2s_casc_p_c2_0.pl d2s_block_0.bias_tree_n_f2_0.vbpc d2s_block_0.d2s_ab_n_f2_0.l2 iovdd sg13_hv_pmos ad=5.1p pd=30.68u as=5.1p ps=30.68u w=15u l=3u
X180 iovss d2s_block_0.sinks_6x6_f2_0.vbn d2s_block_0.d2s_casc_n_f2_0.x iovss sg13_hv_nmos ad=2.04p pd=12.68u as=2.04p ps=12.68u w=6u l=6u
X181 pad Clamp_N_M1_wiring_0.b iovss iovss sg13_hv_nmos ad=2.596p pd=5.58u as=1.408p ps=5.04u w=4.4u l=1u
X182 iovdd d2s_block_0.bias_tree_n_f2_0.vbp iovdd iovdd sg13_hv_pmos ad=1.7p pd=10.68u as=0 ps=0 w=5u l=6u
X183 iovss d2s_block_0.sinks_6x6_f2_0.vbn d2s_block_0.sinks_6x6_f2_0.vbn iovss sg13_hv_nmos ad=2.04p pd=12.68u as=2.04p ps=12.68u w=6u l=6u
X184 d2s_block_0.d2s_ab_n_f2_0.vabn en_3v3_b iovss iovss sg13_hv_nmos ad=0.34p pd=2.68u as=0.34p ps=2.68u w=1u l=0.45u
X185 iovdd d2s_cma_0.a pad iovdd sg13_hv_pmos ad=2.1312p pd=7.3u as=3.9294p ps=7.84u w=6.66u l=0.6u
X186 pad d2s_cma_0.a iovdd iovdd sg13_hv_pmos ad=3.9294p pd=7.84u as=2.1312p ps=7.3u w=6.66u l=0.6u
X187 d2s_block_0.bias_tree_n_f2_0.ni d2s_block_0.bias_tree_n_f2_0.ni d2s_block_0.bias_tree_n_f2_0.ni iovss sg13_hv_nmos ad=0.816p pd=5.48u as=0 ps=0 w=2.4u l=6u
X188 d2s_block_0.d2s_casc_p_c2_0.pr d2s_block_0.d2s_ab_n_f2_0.l2 iovdd iovdd sg13_hv_pmos ad=2.04p pd=12.68u as=2.04p ps=12.68u w=6u l=4u
X189 iovss Clamp_N_M1_wiring_0.b pad iovss sg13_hv_nmos ad=1.408p pd=5.04u as=2.596p ps=5.58u w=4.4u l=1u
X190 pad d2s_cma_0.a iovdd iovdd sg13_hv_pmos ad=3.9294p pd=7.84u as=2.1312p ps=7.3u w=6.66u l=0.6u
X191 iovdd iovdd iovdd iovdd sg13_hv_pmos ad=1.9p pd=10.38u as=0 ps=0 w=10u l=1u
X192 d2s_block_0.d2s_casc_n_f2_0.y d2s_block_0.d2s_casc_n_f2_0.vbnc Clamp_N_M1_wiring_0.b iovss sg13_hv_nmos ad=5.1p pd=30.68u as=5.1p ps=30.68u w=15u l=3u
X193 pad Clamp_N_M1_wiring_0.b iovss iovss sg13_hv_nmos ad=2.596p pd=5.58u as=1.408p ps=5.04u w=4.4u l=1u
X194 iovdd d2s_block_0.bias_tree_n_f2_0.vbp d2s_block_0.d2s_rhigh_f2_0.sb_C2 iovdd sg13_hv_pmos ad=1.7p pd=10.68u as=1.7p ps=10.68u w=5u l=6u
X195 a_9646_32196# d2s_block_0.d2s_rhigh_f2_0.sa_B iovss rhigh l=12.65u w=0.5u
X196 iovdd d2s_cma_0.a pad iovdd sg13_hv_pmos ad=2.1312p pd=7.3u as=3.9294p ps=7.84u w=6.66u l=0.6u
X197 pad d2s_cma_0.a iovdd iovdd sg13_hv_pmos ad=3.9294p pd=7.84u as=2.1312p ps=7.3u w=6.66u l=0.6u
X198 iovss Clamp_N_M1_wiring_0.b pad iovss sg13_hv_nmos ad=1.408p pd=5.04u as=2.596p ps=5.58u w=4.4u l=1u
X199 iovdd d2s_block_0.d2s_ab_n_f2_0.l2 iovdd iovdd sg13_hv_pmos ad=0.34p pd=2.68u as=0 ps=0 w=1u l=4u
X200 iovdd d2s_cma_0.a pad iovdd sg13_hv_pmos ad=2.1312p pd=7.3u as=3.9294p ps=7.84u w=6.66u l=0.6u
X201 Clamp_P_M1_wiring_0.dabp iovdd iovdd iovdd sg13_hv_pmos ad=3.9294p pd=7.84u as=2.1312p ps=7.3u w=6.66u l=0.6u
X202 iovss Clamp_N_M1_wiring_0.b pad iovss sg13_hv_nmos ad=1.408p pd=5.04u as=2.596p ps=5.58u w=4.4u l=1u
X203 d2s_block_0.d2s_casc_n_f2_0.x vref d2s_block_0.d2s_rhigh_f2_0.sb_A d2s_block_0.d2s_rhigh_f2_0.sb_A sg13_hv_pmos ad=1.9p pd=10.38u as=3.4p ps=20.68u w=10u l=1u
X204 iovdd d2s_cma_0.a pad iovdd sg13_hv_pmos ad=2.1312p pd=7.3u as=3.9294p ps=7.84u w=6.66u l=0.6u
X205 iovdd d2s_cma_0.a pad iovdd sg13_hv_pmos ad=2.1312p pd=7.3u as=3.9294p ps=7.84u w=6.66u l=0.6u
X206 d2s_block_0.d2s_rhigh_f2_0.sb_C2 pad d2s_block_0.d2s_casc_n_f2_0.x d2s_block_0.d2s_rhigh_f2_0.sb_C2 sg13_hv_pmos ad=3.4p pd=20.68u as=1.9p ps=10.38u w=10u l=1u
X207 pad Clamp_N_M1_wiring_0.b iovss iovss sg13_hv_nmos ad=2.596p pd=5.58u as=1.408p ps=5.04u w=4.4u l=1u
X208 iovss pad dantenna l=1.26u w=67.6u
X209 iovss d2s_block_0.d2s_sp2k_f2_0.core dantenna l=3.1u w=0.64u
X210 pad d2s_cma_0.a iovdd iovdd sg13_hv_pmos ad=3.9294p pd=7.84u as=2.1312p ps=7.3u w=6.66u l=0.6u
X211 pad Clamp_N_M1_wiring_0.b iovss iovss sg13_hv_nmos ad=2.596p pd=5.58u as=1.408p ps=5.04u w=4.4u l=1u
X212 iovss d2s_block_0.bias_tree_n_f2_0.ni d2s_block_0.bias_tree_n_f2_0.vabp iovss sg13_hv_nmos ad=2.04p pd=12.68u as=2.04p ps=12.68u w=6u l=6u
X213 a_10870_32196# a_10190_29580# iovss rhigh l=12.65u w=0.5u
X214 d2s_block_0.d2s_casc_n_f2_0.vbnc d2s_block_0.d2s_casc_n_f2_0.vbnc d2s_block_0.d2s_casc_n_f2_0.vbnc iovss sg13_hv_nmos ad=0.68p pd=4.68u as=0 ps=0 w=2u l=3u
X215 Clamp_N_M1_wiring_0.dabn d2s_block_0.d2s_ab_n_f2_0.vabn d2s_block_0.d2s_ab_n_f2_0.vabn iovss sg13_hv_nmos ad=1.496p pd=9.48u as=1.496p ps=9.48u w=4.4u l=1u
X216 iovdd d2s_cma_0.a pad iovdd sg13_hv_pmos ad=2.1312p pd=7.3u as=3.9294p ps=7.84u w=6.66u l=0.6u
X217 a_9510_32196# a_10462_29580# iovss rhigh l=12.65u w=0.5u
X218 iovss Clamp_N_M1_wiring_0.b pad iovss sg13_hv_nmos ad=1.408p pd=5.04u as=2.596p ps=5.58u w=4.4u l=1u
X219 pad d2s_cma_0.a iovdd iovdd sg13_hv_pmos ad=3.9294p pd=7.84u as=2.1312p ps=7.3u w=6.66u l=0.6u
X220 a_9918_32196# a_10054_29580# iovss rhigh l=12.65u w=0.5u
X221 d2s_block_0.sinks_6x6_f2_0.vbn d2s_block_0.sinks_6x6_f2_0.vbn d2s_block_0.sinks_6x6_f2_0.vbn iovss sg13_hv_nmos ad=0.68p pd=4.68u as=0 ps=0 w=2u l=6u
X222 iovdd d2s_block_0.d2s_ab_n_f2_0.l2 iovdd iovdd sg13_hv_pmos ad=0.34p pd=2.68u as=0 ps=0 w=1u l=4u
X223 iovss Clamp_N_M1_wiring_0.b pad iovss sg13_hv_nmos ad=1.408p pd=5.04u as=2.596p ps=5.58u w=4.4u l=1u
X224 pad d2s_cma_0.a iovdd iovdd sg13_hv_pmos ad=3.9294p pd=7.84u as=2.1312p ps=7.3u w=6.66u l=0.6u
X225 pad Clamp_N_M1_wiring_0.b iovss iovss sg13_hv_nmos ad=3.256p pd=10.28u as=1.408p ps=5.04u w=4.4u l=1u
X226 pad Clamp_N_M1_wiring_0.b iovss iovss sg13_hv_nmos ad=2.596p pd=5.58u as=1.408p ps=5.04u w=4.4u l=1u
X227 pad d2s_cma_0.a iovdd iovdd sg13_hv_pmos ad=3.9294p pd=7.84u as=2.1312p ps=7.3u w=6.66u l=0.6u
X228 d2s_block_0.d2s_casc_n_f2_0.x d2s_block_0.sinks_6x6_f2_0.vbn iovss iovss sg13_hv_nmos ad=2.04p pd=12.68u as=2.04p ps=12.68u w=6u l=6u
X229 iovdd d2s_block_0.bias_tree_n_f2_0.vbp d2s_block_0.d2s_rhigh_f2_0.sb_C1 iovdd sg13_hv_pmos ad=1.7p pd=10.68u as=1.7p ps=10.68u w=5u l=6u
X230 iovdd iovdd iovdd iovdd sg13_hv_pmos ad=1.9p pd=10.38u as=0 ps=0 w=10u l=1u
X231 d2s_block_0.d2s_casc_n_f2_0.y d2s_block_0.sinks_6x6_f2_0.vbn iovss iovss sg13_hv_nmos ad=2.04p pd=12.68u as=2.04p ps=12.68u w=6u l=6u
X232 pad d2s_cma_0.a iovdd iovdd sg13_hv_pmos ad=3.9294p pd=7.84u as=2.1312p ps=7.3u w=6.66u l=0.6u
X233 pad d2s_cma_0.a iovdd iovdd sg13_hv_pmos ad=3.9294p pd=7.84u as=2.1312p ps=7.3u w=6.66u l=0.6u
X234 iovdd iovdd iovdd iovdd sg13_hv_pmos ad=2.2644p pd=14u as=0 ps=0 w=6.66u l=0.6u
X235 iovdd d2s_cma_0.a pad iovdd sg13_hv_pmos ad=2.1312p pd=7.3u as=3.9294p ps=7.84u w=6.66u l=0.6u
X236 iovdd d2s_block_0.bias_tree_n_f2_0.vbp d2s_block_0.bias_tree_n_f2_0.vbp iovdd sg13_hv_pmos ad=1.7p pd=10.68u as=1.7p ps=10.68u w=5u l=6u
X237 a_9782_32196# d2s_block_0.d2s_rhigh_f2_0.sa_C1 iovss rhigh l=12.65u w=0.5u
X238 pad d2s_cma_0.a iovdd iovdd sg13_hv_pmos ad=3.9294p pd=7.84u as=2.1312p ps=7.3u w=6.66u l=0.6u
X239 Clamp_P_M1_wiring_0.dabp iovdd iovdd iovdd sg13_hv_pmos ad=3.9294p pd=7.84u as=2.1312p ps=7.3u w=6.66u l=0.6u
X240 iovss iovss iovss rhigh l=12.65u w=0.5u
X241 iovdd iovdd iovdd iovdd sg13_hv_pmos ad=3.4p pd=20.68u as=0 ps=0 w=10u l=1u
X242 iovdd d2s_cma_0.a pad iovdd sg13_hv_pmos ad=2.1312p pd=7.3u as=3.9294p ps=7.84u w=6.66u l=0.6u
X243 iovdd d2s_cma_0.a pad iovdd sg13_hv_pmos ad=2.1312p pd=7.3u as=3.9294p ps=7.84u w=6.66u l=0.6u
X244 iovdd d2s_cma_0.a pad iovdd sg13_hv_pmos ad=2.1312p pd=7.3u as=3.9294p ps=7.84u w=6.66u l=0.6u
X245 d2s_block_0.d2s_casc_n_f2_0.vbnc d2s_block_0.d2s_casc_n_f2_0.vbnc d2s_block_0.d2s_casc_n_f2_0.vbnc iovss sg13_hv_nmos ad=0.68p pd=4.68u as=0 ps=0 w=2u l=3u
X246 iovss d2s_block_0.sinks_6x6_f2_0.vbn d2s_block_0.d2s_casc_n_f2_0.y iovss sg13_hv_nmos ad=2.04p pd=12.68u as=2.04p ps=12.68u w=6u l=6u
X247 pad d2s_cma_0.a iovdd iovdd sg13_hv_pmos ad=3.9294p pd=7.84u as=2.1312p ps=7.3u w=6.66u l=0.6u
X248 pad Clamp_N_M1_wiring_0.b iovss iovss sg13_hv_nmos ad=2.596p pd=5.58u as=1.408p ps=5.04u w=4.4u l=1u
X249 pad Clamp_N_M1_wiring_0.b iovss iovss sg13_hv_nmos ad=2.596p pd=5.58u as=1.408p ps=5.04u w=4.4u l=1u
X250 iovdd d2s_cma_0.a pad iovdd sg13_hv_pmos ad=2.1312p pd=7.3u as=3.9294p ps=7.84u w=6.66u l=0.6u
X251 pad Clamp_N_M1_wiring_0.b iovss iovss sg13_hv_nmos ad=2.596p pd=5.58u as=1.408p ps=5.04u w=4.4u l=1u
X252 iovss iovss iovss rhigh l=12.65u w=0.5u
X253 d2s_cma_0.a d2s_block_0.bias_tree_n_f2_0.vbpc d2s_block_0.d2s_casc_p_c2_0.pr iovdd sg13_hv_pmos ad=5.1p pd=30.68u as=5.1p ps=30.68u w=15u l=3u
X254 pad d2s_cma_0.a iovdd iovdd sg13_hv_pmos ad=3.9294p pd=7.84u as=2.1312p ps=7.3u w=6.66u l=0.6u
X255 a_10870_32196# d2s_block_0.d2s_rhigh_f2_0.sb_C1 iovss rhigh l=12.65u w=0.5u
X256 pad d2s_cma_0.a iovdd iovdd sg13_hv_pmos ad=3.9294p pd=7.84u as=2.1312p ps=7.3u w=6.66u l=0.6u
X257 iovdd d2s_cma_0.a pad iovdd sg13_hv_pmos ad=2.1312p pd=7.3u as=3.9294p ps=7.84u w=6.66u l=0.6u
X258 d2s_block_0.d2s_casc_n_f2_0.x pad d2s_block_0.d2s_rhigh_f2_0.sb_C1 d2s_block_0.d2s_rhigh_f2_0.sb_C1 sg13_hv_pmos ad=1.9p pd=10.38u as=3.4p ps=20.68u w=10u l=1u
X259 d2s_block_0.d2s_rhigh_f2_0.sa_C1 vref d2s_block_0.d2s_casc_n_f2_0.y d2s_block_0.d2s_rhigh_f2_0.sa_C1 sg13_hv_pmos ad=3.4p pd=20.68u as=1.9p ps=10.38u w=10u l=1u
X260 iovss Clamp_N_M1_wiring_0.b pad iovss sg13_hv_nmos ad=1.408p pd=5.04u as=2.596p ps=5.58u w=4.4u l=1u
X261 iovss Clamp_N_M1_wiring_0.b pad iovss sg13_hv_nmos ad=1.408p pd=5.04u as=2.596p ps=5.58u w=4.4u l=1u
X262 iovss Clamp_N_M1_wiring_0.b pad iovss sg13_hv_nmos ad=1.408p pd=5.04u as=2.596p ps=5.58u w=4.4u l=1u
X263 a_9782_32196# a_10190_29580# iovss rhigh l=12.65u w=0.5u
X264 pad d2s_cma_0.a iovdd iovdd sg13_hv_pmos ad=3.9294p pd=7.84u as=2.1312p ps=7.3u w=6.66u l=0.6u
X265 pad Clamp_N_M1_wiring_0.b iovss iovss sg13_hv_nmos ad=2.596p pd=5.58u as=1.408p ps=5.04u w=4.4u l=1u
X266 d2s_block_0.bias_tree_n_f2_0.vabp en_3v3 iovdd iovdd sg13_hv_pmos ad=0.34p pd=2.68u as=0.34p ps=2.68u w=1u l=0.45u
X267 pad d2s_cma_0.a iovdd iovdd sg13_hv_pmos ad=3.9294p pd=7.84u as=2.1312p ps=7.3u w=6.66u l=0.6u
X268 pad Clamp_N_M1_wiring_0.b iovss iovss sg13_hv_nmos ad=2.596p pd=5.58u as=1.408p ps=5.04u w=4.4u l=1u
X269 pad d2s_cma_0.a iovdd iovdd sg13_hv_pmos ad=3.9294p pd=7.84u as=2.1312p ps=7.3u w=6.66u l=0.6u
X270 iovdd d2s_block_0.bias_tree_n_f2_0.vbp d2s_block_0.d2s_rhigh_f2_0.sa_A iovdd sg13_hv_pmos ad=1.7p pd=10.68u as=1.7p ps=10.68u w=5u l=6u
X271 Clamp_N_M1_wiring_0.b d2s_block_0.bias_tree_n_f2_0.vabp d2s_cma_0.a iovdd sg13_hv_pmos ad=2.2644p pd=14u as=2.2644p ps=14u w=6.66u l=0.6u
X272 pad d2s_cma_0.a iovdd iovdd sg13_hv_pmos ad=3.9294p pd=7.84u as=2.1312p ps=7.3u w=6.66u l=0.6u
X273 iovss Clamp_N_M1_wiring_0.b pad iovss sg13_hv_nmos ad=1.408p pd=5.04u as=2.596p ps=5.58u w=4.4u l=1u
X274 iovdd d2s_cma_0.a pad iovdd sg13_hv_pmos ad=2.1312p pd=7.3u as=3.9294p ps=7.84u w=6.66u l=0.6u
X275 iovss Clamp_N_M1_wiring_0.b pad iovss sg13_hv_nmos ad=1.408p pd=5.04u as=2.596p ps=5.58u w=4.4u l=1u
X276 iovss Clamp_N_M1_wiring_0.dabn Clamp_N_M1_wiring_0.dabn iovss sg13_hv_nmos ad=1.408p pd=5.04u as=2.596p ps=5.58u w=4.4u l=1u
X277 pad Clamp_N_M1_wiring_0.b iovss iovss sg13_hv_nmos ad=2.596p pd=5.58u as=2.068p ps=9.74u w=4.4u l=1u
X278 iovdd iovdd iovdd iovdd sg13_hv_pmos ad=1.9p pd=10.38u as=0 ps=0 w=10u l=1u
X279 iovdd d2s_cma_0.a pad iovdd sg13_hv_pmos ad=2.1312p pd=7.3u as=3.9294p ps=7.84u w=6.66u l=0.6u
X280 pad Clamp_N_M1_wiring_0.b iovss iovss sg13_hv_nmos ad=2.596p pd=5.58u as=1.408p ps=5.04u w=4.4u l=1u
X281 pad Clamp_N_M1_wiring_0.b iovss iovss sg13_hv_nmos ad=2.596p pd=5.58u as=1.408p ps=5.04u w=4.4u l=1u
X282 pad d2s_cma_0.a iovdd iovdd sg13_hv_pmos ad=4.9284p pd=14.8u as=2.1312p ps=7.3u w=6.66u l=0.6u
X283 iovdd d2s_cma_0.a pad iovdd sg13_hv_pmos ad=2.1312p pd=7.3u as=3.9294p ps=7.84u w=6.66u l=0.6u
X284 d2s_block_0.d2s_casc_n_f2_0.x d2s_block_0.sinks_6x6_f2_0.vbn iovss iovss sg13_hv_nmos ad=2.04p pd=12.68u as=2.04p ps=12.68u w=6u l=6u
X285 pad d2s_cma_0.a iovdd iovdd sg13_hv_pmos ad=3.9294p pd=7.84u as=2.1312p ps=7.3u w=6.66u l=0.6u
X286 iovss Clamp_N_M1_wiring_0.b pad iovss sg13_hv_nmos ad=1.408p pd=5.04u as=2.596p ps=5.58u w=4.4u l=1u
X287 iovdd d2s_cma_0.a pad iovdd sg13_hv_pmos ad=2.1312p pd=7.3u as=3.9294p ps=7.84u w=6.66u l=0.6u
X288 iovss Clamp_N_M1_wiring_0.b pad iovss sg13_hv_nmos ad=1.408p pd=5.04u as=2.596p ps=5.58u w=4.4u l=1u
X289 iovdd iovdd iovdd iovdd sg13_hv_pmos ad=3.4p pd=20.68u as=0 ps=0 w=10u l=1u
X290 iovss iovss iovss iovss sg13_hv_nmos ad=1.496p pd=9.48u as=0 ps=0 w=4.4u l=1u
X291 iovdd d2s_cma_0.a pad iovdd sg13_hv_pmos ad=2.1312p pd=7.3u as=3.9294p ps=7.84u w=6.66u l=0.6u
X292 pad Clamp_N_M1_wiring_0.b iovss iovss sg13_hv_nmos ad=2.596p pd=5.58u as=1.408p ps=5.04u w=4.4u l=1u
.ends

.subckt sg13cmos5l_IOPadTriOut16mA pad vdd iovdd iovss iovdd_uq0 c2p_en c2p sg13cmos5l_DCNDiode_0/guard
+ vss
Xsg13cmos5l_DCPDiode_0 pad iovdd_uq0 vss pad sg13cmos5l_DCPDiode
Xsg13cmos5l_Clamp_P8N8D_0 sg13cmos5l_GateDecode_0/pgate iovdd_uq0 vss pad pad pad
+ pad sg13cmos5l_Clamp_P8N8D
Xsg13cmos5l_Clamp_N8N8D_0 sg13cmos5l_GateDecode_0/ngate vss pad pad pad pad sg13cmos5l_DCNDiode_0/guard
+ sg13cmos5l_Clamp_N8N8D
Xsg13cmos5l_GateDecode_0 sg13cmos5l_GateDecode_0/ngate sg13cmos5l_GateDecode_0/pgate
+ c2p c2p_en iovdd vdd vss sg13cmos5l_GateDecode
Xsg13cmos5l_DCNDiode_0 vss pad sg13cmos5l_DCNDiode_0/guard pad sg13cmos5l_DCNDiode
.ends

.subckt sg13cmos5l_IOPadIOVss vdd vss iovdd sg13cmos5l_DCNDiode_0/guard
Xsg13cmos5l_DCPDiode_0 vss iovdd vss vss sg13cmos5l_DCPDiode
Xsg13cmos5l_DCNDiode_0 vss vss sg13cmos5l_DCNDiode_0/guard vss sg13cmos5l_DCNDiode
.ends

.subckt sg13cmos5l_padframe CSB SCK gpio[11] s13_an[1] s14_an[0] s15_an[0] s17_an[0]
+ s17_an[1] s18_an[0] s18_an[1] SCK_in clk_in gpio_0_out gpio_1_in gpio_1_oe gpio_2_out
+ gpio_4_in gpio_5_out gpio_5_oe gpio_6_out gpio_7_in gpio_7_oe gpio_9_in gpio_9_out
+ gpio_11_in analog_0_esd analog_2_esd s1_an_0_esd s1_an_1_esd s2_an_0_esd s2_an_1_esd
+ s3_an_1_esd s4_an_0_esd s5_an_0_esd s5_an_2_esd s6_an_1 s7_an_0_vref s7_an_0_outp
+ s7_an_0_outn s7_an_0_vcm s7_an_0_en_3v3 s7_an_0_en_3v3_b s7_an_0_iref s7_an_1_vinp
+ s7_an_1_vinn s7_an_1_vref s7_an_1_iref s7_an_1_en_3v3_b s7_an_1_en_3v3 s8_an_0_esd
+ s10_an_0_esd s10_an_2_esd s12_an_1_esd s14_an_2_esd s16_an_1_esd s17_an_0 mask_rev[7]
+ mask_rev[8] mask_rev[9] mask_rev[10] mask_rev[11] mask_rev[12] mask_rev[14] mask_rev[15]
+ mask_rev[16] mask_rev[17] mask_rev[18] mask_rev[19] mask_rev[20] mask_rev[21] mask_rev[22]
+ mask_rev[23] mask_rev[24] mask_rev[25] mask_rev[26] mask_rev[30] mask_rev[31] vdd3v3
+ s16_an[1] s12_an[1] s12_an[0] s8_an[0] s9_an[0] s10_an[2] s10_an[1] analog[0] analog[3]
+ pad_s9_an_2/padres SDI s6_an_0 s5_an_1_esd pad_s9_an_1/padres s1_an[1] s10_an_1_esd
+ gpio[7] s3_an_0_esd gpio_8_in s14_an_1_esd s13_an_1 gpio_5_in s6_an[0] s5_an[1]
+ gpio[1] pad_s9_an_0/padres analog_3_esd s18_an_1_esd gpio_2_in mask_rev[13] s11_an_0_esd
+ gpio_10_out gpio[4] s13_an_0 s12_an_0_esd s9_an[2] s2_an[0] s7_an[1] s3_an[0] s2_an[1]
+ gpio[10] s14_an_0_esd s17_an_1 gpio_2_oe s15_an_0_esd s14_an[1] gpio[8] s16_an_0_esd
+ analog[1] SDO_ena s18_an_0_esd gpio_4_out gpio_8_oe gpio[5] s16_an[0] CSB_in s14_an[2]
+ gpio[6] gpio[0] mask_rev[27] s5_an[0] gpio_6_in vddd gpio_10_oe gpio_3_oe mask_rev[28]
+ gpio_1_out s6_an[1] mask_rev[0] s11_an[0] mask_rev[29] gpio_3_out SDI_in mask_rev[1]
+ gpio_3_in s13_an[0] vdd1v2 mask_rev[2] analog_1_esd s4_an[0] mask_rev[3] gpio_11_out
+ gpio_9_oe gpio_6_oe mask_rev[4] gpio_0_in s10_an[0] gpio_8_out gpio[2] mask_rev[5]
+ SDO s5_an[2] gpio[9] gpio[3] gpio_11_oe clk s3_an[1] gpio_4_oe s9_an[1] mask_rev[6]
+ analog[2] SDO_out gpio_10_in gpio_7_out gpio_0_oe sub s7_an[0] s1_an[0]
Xpad_s12_an_1 s12_an[1] s12_an_1_esd vdd1v2 vdd3v3 sub vdd3v3 vdd3v3 sub sg13cmos5l_IOPadAnalog
Xpad_vss1v2_0 vdd1v2 sub vdd3v3 vdd3v3 sg13cmos5l_IOPadVss
Xpad_gpio_3 gpio[3] gpio_3_in vddd vdd3v3 sub vdd3v3 gpio_3_oe gpio_3_out vdd3v3 sub
+ sg13cmos5l_IOPadInOut16mA
Xpad_s6_an_1 s6_an[1] s6_an_1 vdd1v2 vdd3v3 sub sub vdd3v3 vdd3v3 sg13cmos5l_IOPadOut16mA
Xpad_vdd3v3_0 vddd vdd3v3 sub sub sg13cmos5l_IOPadIOVdd
Xpad_vdd3v3_1 vdd1v2 vdd3v3 sub sub sg13cmos5l_IOPadIOVdd
Xpad_vss1v2_1 vdd1v2 sub vdd3v3 vdd3v3 sg13cmos5l_IOPadVss
Xpad_gpio_4 gpio[4] gpio_4_in vddd vdd3v3 sub vdd3v3 gpio_4_oe gpio_4_out vdd3v3 sub
+ sg13cmos5l_IOPadInOut16mA
Xpad_s15_an_0 s15_an[0] s15_an_0_esd vdd1v2 vdd3v3 sub vdd3v3 vdd3v3 sub sg13cmos5l_IOPadAnalog
Xpad_s9_an_0 s9_an[0] pad_s9_an_0/padres vdd1v2 vdd3v3 sub vdd3v3 vdd3v3 sub sg13cmos5l_IOPadAnalog
Xpad_vss1v2_2 vdd1v2 sub vdd3v3 vdd3v3 sg13cmos5l_IOPadVss
Xpad_gpio_5 gpio[5] gpio_5_in vddd vdd3v3 sub vdd3v3 gpio_5_oe gpio_5_out vdd3v3 sub
+ sg13cmos5l_IOPadInOut16mA
Xpad_vdd3v3_2 vdd1v2 vdd3v3 sub sub sg13cmos5l_IOPadIOVdd
Xpad_vdd3v3_3 vdd1v2 vdd3v3 sub sub sg13cmos5l_IOPadIOVdd
Xpad_s9_an_1 s9_an[1] pad_s9_an_1/padres vdd1v2 vdd3v3 sub vdd3v3 vdd3v3 sub sg13cmos5l_IOPadAnalog
Xpad_vss1v2_3 vdd1v2 sub vdd3v3 vdd3v3 sg13cmos5l_IOPadVss
Xpad_gpio_6 gpio[6] gpio_6_in vddd vdd3v3 sub vdd3v3 gpio_6_oe gpio_6_out vdd3v3 sub
+ sg13cmos5l_IOPadInOut16mA
Xpad_s9_an_2 s9_an[2] pad_s9_an_2/padres vdd1v2 vdd3v3 sub vdd3v3 vdd3v3 sub sg13cmos5l_IOPadAnalog
Xpad_gpio_7 gpio[7] gpio_7_in vddd vdd3v3 sub vdd3v3 gpio_7_oe gpio_7_out vdd3v3 sub
+ sg13cmos5l_IOPadInOut16mA
Xpad_vss1v2_4 vddd sub vdd3v3 vdd3v3 sg13cmos5l_IOPadVss
Xpad_vdd3v3_4 vdd1v2 vdd3v3 sub sub sg13cmos5l_IOPadIOVdd
Xpad_s18_an_0 s18_an[0] s18_an_0_esd vdd1v2 vdd3v3 sub vdd3v3 vdd3v3 sub sg13cmos5l_IOPadAnalog
Xpad_gpio_8 gpio[8] gpio_8_in vdd1v2 vdd3v3 sub vdd3v3 gpio_8_oe gpio_8_out vdd3v3
+ sub sg13cmos5l_IOPadInOut16mA
Xpad_s18_an_1 s18_an[1] s18_an_1_esd vdd1v2 vdd3v3 sub vdd3v3 vdd3v3 sub sg13cmos5l_IOPadAnalog
Xpad_vdd1v2_0 vdd1v2 vdd3v3 sub vdd3v3 sub vdd3v3 sg13cmos5l_IOPadVdd
Xpad_gpio_9 gpio[9] gpio_9_in vdd1v2 vdd3v3 sub vdd3v3 gpio_9_oe gpio_9_out vdd3v3
+ sub sg13cmos5l_IOPadInOut16mA
Xpad_vdd1v2_1 vdd1v2 vdd3v3 sub vdd3v3 sub vdd3v3 sg13cmos5l_IOPadVdd
Xpad_vdd1v2_2 vdd1v2 vdd3v3 sub vdd3v3 sub vdd3v3 sg13cmos5l_IOPadVdd
Xpad_s2_an_0 s2_an[0] s2_an_0_esd vdd1v2 vdd3v3 sub vdd3v3 vdd3v3 sub sg13cmos5l_IOPadAnalog
Xpad_s2_an_1 s2_an[1] s2_an_1_esd vdd1v2 vdd3v3 sub vdd3v3 vdd3v3 sub sg13cmos5l_IOPadAnalog
Xpad_vdd1v2_3 vdd1v2 vdd3v3 sub vdd3v3 sub vdd3v3 sg13cmos5l_IOPadVdd
Xpad_vddd_0 vddd vdd3v3 sub vdd3v3 sub vdd3v3 sg13cmos5l_IOPadVdd
Xpad_vdd1v2_4 vdd1v2 vdd3v3 sub vdd3v3 sub vdd3v3 sg13cmos5l_IOPadVdd
Xpad_s11_an_0 s11_an[0] s11_an_0_esd vdd1v2 vdd3v3 sub vdd3v3 vdd3v3 sub sg13cmos5l_IOPadAnalog
Xpad_s5_an_0 s5_an[0] s5_an_0_esd vdd1v2 vdd3v3 sub vdd3v3 vdd3v3 sub sg13cmos5l_IOPadAnalog
Xpad_vddd_1 vddd vdd3v3 sub vdd3v3 sub vdd3v3 sg13cmos5l_IOPadVdd
Xpad_s5_an_1 s5_an[1] s5_an_1_esd vdd1v2 vdd3v3 sub vdd3v3 vdd3v3 sub sg13cmos5l_IOPadAnalog
Xpad_s5_an_2 s5_an[2] s5_an_2_esd vdd1v2 vdd3v3 sub vdd3v3 vdd3v3 sub sg13cmos5l_IOPadAnalog
Xproject_id mask_rev[0] mask_rev[1] mask_rev[2] mask_rev[3] mask_rev[4] mask_rev[5]
+ mask_rev[6] mask_rev[7] mask_rev[8] mask_rev[9] mask_rev[10] mask_rev[11] mask_rev[12]
+ mask_rev[14] mask_rev[15] mask_rev[16] mask_rev[17] mask_rev[18] mask_rev[19] mask_rev[20]
+ mask_rev[21] mask_rev[22] mask_rev[23] mask_rev[24] mask_rev[25] mask_rev[26] mask_rev[27]
+ mask_rev[28] mask_rev[29] mask_rev[30] mask_rev[31] vddd mask_rev[13] sub user_id_routing
Xpad_s14_an_0 s14_an[0] s14_an_0_esd vdd1v2 vdd3v3 sub vdd3v3 vdd3v3 sub sg13cmos5l_IOPadAnalog
Xpad_s8_an_0 s8_an[0] s8_an_0_esd vdd1v2 vdd3v3 sub vdd3v3 vdd3v3 sub sg13cmos5l_IOPadAnalog
Xpad_s14_an_1 s14_an[1] s14_an_1_esd vdd1v2 vdd3v3 sub vdd3v3 vdd3v3 sub sg13cmos5l_IOPadAnalog
Xpad_s14_an_2 s14_an[2] s14_an_2_esd vdd1v2 vdd3v3 sub vdd3v3 vdd3v3 sub sg13cmos5l_IOPadAnalog
Xpad_s17_an_0 s17_an[0] s17_an_0 vdd1v2 vdd3v3 sub sub vdd3v3 vdd3v3 sg13cmos5l_IOPadOut16mA
Xpad_s17_an_1 s17_an[1] s17_an_1 vdd1v2 vdd3v3 sub sub vdd3v3 vdd3v3 sg13cmos5l_IOPadOut16mA
Xpad_s1_an_0 s1_an[0] s1_an_0_esd vdd1v2 vdd3v3 sub vdd3v3 vdd3v3 sub sg13cmos5l_IOPadAnalog
Xpad_s1_an_1 s1_an[1] s1_an_1_esd vdd1v2 vdd3v3 sub vdd3v3 vdd3v3 sub sg13cmos5l_IOPadAnalog
Xpad_s10_an_0 s10_an[0] s10_an_0_esd vdd1v2 vdd3v3 sub vdd3v3 vdd3v3 sub sg13cmos5l_IOPadAnalog
Xpad_s4_an_0 s4_an[0] s4_an_0_esd vdd1v2 vdd3v3 sub vdd3v3 vdd3v3 sub sg13cmos5l_IOPadAnalog
Xpad_s10_an_1 s10_an[1] s10_an_1_esd vdd1v2 vdd3v3 sub vdd3v3 vdd3v3 sub sg13cmos5l_IOPadAnalog
Xpad_SDI SDI SDI_in vddd sub vdd3v3 vdd3v3 sg13cmos5l_IOPadIn
Xpad_gpio_10 gpio[10] gpio_10_in vdd1v2 vdd3v3 sub vdd3v3 gpio_10_oe gpio_10_out vdd3v3
+ sub sg13cmos5l_IOPadInOut16mA
Xpad_s10_an_2 s10_an[2] s10_an_2_esd vdd1v2 vdd3v3 sub vdd3v3 vdd3v3 sub sg13cmos5l_IOPadAnalog
Xpad_gpio_11 gpio[11] gpio_11_in vdd1v2 vdd3v3 sub vdd3v3 gpio_11_oe gpio_11_out vdd3v3
+ sub sg13cmos5l_IOPadInOut16mA
Xpad_analog_0 analog[0] analog_0_esd vdd1v2 vdd3v3 sub vdd3v3 vdd3v3 sub sg13cmos5l_IOPadAnalog
Xpad_s13_an_0 s13_an[0] s13_an_0 vdd1v2 sub vdd3v3 vdd3v3 sg13cmos5l_IOPadIn
Xpad_s7_an_0 vdd3v3 sub vdd1v2 s7_an[0] s7_an_0_outp s7_an_0_outn s7_an_0_vcm s7_an_0_vref
+ s7_an_0_iref s7_an_0_en_3v3 s7_an_0_en_3v3_b sub sg13cmos5l_IOPadSingle2Diff
Xpad_analog_1 analog[1] analog_1_esd vdd1v2 vdd3v3 sub vdd3v3 vdd3v3 sub sg13cmos5l_IOPadAnalog
Xpad_s13_an_1 s13_an[1] s13_an_1 vdd1v2 vdd3v3 sub sub vdd3v3 vdd3v3 sg13cmos5l_IOPadOut16mA
Xpad_s7_an_1 vdd3v3 sub vdd1v2 s7_an[1] s7_an_1_vinp s7_an_1_vinn s7_an_1_vref s7_an_1_iref
+ s7_an_1_en_3v3 s7_an_1_en_3v3_b sg13cmos5l_IOPadDiff2Single
Xpad_SCK SCK SCK_in vddd sub vdd3v3 vdd3v3 sg13cmos5l_IOPadIn
Xpad_analog_2 analog[2] analog_2_esd vdd1v2 vdd3v3 sub vdd3v3 vdd3v3 sub sg13cmos5l_IOPadAnalog
Xpad_CSB CSB CSB_in vddd sub vdd3v3 vdd3v3 sg13cmos5l_IOPadIn
Xpad_s16_an_0 s16_an[0] s16_an_0_esd vdd1v2 vdd3v3 sub vdd3v3 vdd3v3 sub sg13cmos5l_IOPadAnalog
Xpad_clk clk clk_in vddd sub vdd3v3 vdd3v3 sg13cmos5l_IOPadIn
Xpad_analog_3 analog[3] analog_3_esd vdd1v2 vdd3v3 sub vdd3v3 vdd3v3 sub sg13cmos5l_IOPadAnalog
Xpad_s16_an_1 s16_an[1] s16_an_1_esd vdd1v2 vdd3v3 sub vdd3v3 vdd3v3 sub sg13cmos5l_IOPadAnalog
Xpad_SDO SDO vddd vdd3v3 sub vdd3v3 SDO_ena SDO_out vdd3v3 sub sg13cmos5l_IOPadTriOut16mA
Xpad_vss3v3_0 vdd1v2 sub vdd3v3 vdd3v3 sg13cmos5l_IOPadIOVss
Xpad_vss3v3_1 vdd1v2 sub vdd3v3 vdd3v3 sg13cmos5l_IOPadIOVss
Xpad_vss3v3_2 vdd1v2 sub vdd3v3 vdd3v3 sg13cmos5l_IOPadIOVss
Xpad_s3_an_0 s3_an[0] s3_an_0_esd vdd1v2 vdd3v3 sub vdd3v3 vdd3v3 sub sg13cmos5l_IOPadAnalog
Xpad_vss3v3_3 vdd1v2 sub vdd3v3 vdd3v3 sg13cmos5l_IOPadIOVss
Xpad_gpio_0 gpio[0] gpio_0_in vddd vdd3v3 sub vdd3v3 gpio_0_oe gpio_0_out vdd3v3 sub
+ sg13cmos5l_IOPadInOut16mA
Xpad_s3_an_1 s3_an[1] s3_an_1_esd vdd1v2 vdd3v3 sub vdd3v3 vdd3v3 sub sg13cmos5l_IOPadAnalog
Xpad_gpio_1 gpio[1] gpio_1_in vddd vdd3v3 sub vdd3v3 gpio_1_oe gpio_1_out vdd3v3 sub
+ sg13cmos5l_IOPadInOut16mA
Xpad_vss3v3_4 vdd1v2 sub vdd3v3 vdd3v3 sg13cmos5l_IOPadIOVss
Xpad_s12_an_0 s12_an[0] s12_an_0_esd vdd1v2 vdd3v3 sub vdd3v3 vdd3v3 sub sg13cmos5l_IOPadAnalog
Xpad_gpio_2 gpio[2] gpio_2_in vddd vdd3v3 sub vdd3v3 gpio_2_oe gpio_2_out vdd3v3 sub
+ sg13cmos5l_IOPadInOut16mA
Xpad_s6_an_0 s6_an[0] s6_an_0 vdd1v2 sub vdd3v3 vdd3v3 sg13cmos5l_IOPadIn
Xpad_vss3v3_5 vdd1v2 sub vdd3v3 vdd3v3 sg13cmos5l_IOPadIOVss
.ends

* Black-box entry subcircuit for slot16_wrapper abstract view
.subckt slot16_wrapper vss_1v2 s16_an[0] s16_an[1] s16_an_0_esd s16_an_1_esd vbias
+ dig_in[23] dig_in[22] dig_in[21] dig_in[20] dig_in[19] dig_in[18] dig_in[17] dig_in[16]
+ dig_in[15] dig_in[14] dig_in[13] dig_in[12] dig_in[11] dig_in[10] dig_in[9] dig_in[8]
+ dig_in[7] dig_in[6] dig_in[5] dig_in[4] dig_in[3] dig_in[2] dig_in[1] dig_in[0]
+ dig_out[11] dig_out[10] dig_out[9] dig_out[8] dig_out[7] dig_out[6] dig_out[5] dig_out[4]
+ dig_out[3] dig_out[2] dig_out[1] dig_out[0] ibias0 ibias1 analog_bus3 analog_bus2
+ analog_bus1 analog_bus0 vdd_1v2 vss_3v3 vdd_3v3 enable clk reset
.ends

.subckt sg13cmos5l_antennanp A VDD VSS
X0 A VDD dpantenna l=1.34u w=1.05u
X1 VSS A dantenna l=0.78u w=0.78u
.ends

.subckt sg13_hv_pmos_3CJ4LL B D0_0 G D0_1 D0_2 D0_3 S1_0 S1_1 S1_2 S1_3 D2_0 D2_1
+ D2_2 D2_3 S3_0 S3_1 S3_2 S3_3 D4_0 D4_1 D4_2 D4_3 S5_0 S5_1 S5_2 S5_3 D6_0 D6_1
+ D6_2 D6_3 S7_0 S7_1 S7_2 S7_3 D8_0 D8_1 D8_2 D8_3 S9_0 S9_1 S9_2 S9_3 a_1048_44#
+ a_1048_n4132# a_1048_n2044# a_1048_2132#
X0 a_1048_2132# G S9_3 B sg13_hv_pmos ad=6.8p pd=21.36u as=3.6p ps=10.72u w=10u l=0.4u
X1 S7_1 G D6_1 B sg13_hv_pmos ad=3.6p pd=10.72u as=3.6p ps=10.72u w=10u l=0.4u
X2 D6_3 G S5_3 B sg13_hv_pmos ad=3.6p pd=10.72u as=3.6p ps=10.72u w=10u l=0.4u
X3 D2_1 G S1_1 B sg13_hv_pmos ad=3.6p pd=10.72u as=3.6p ps=10.72u w=10u l=0.4u
X4 S9_3 G D8_3 B sg13_hv_pmos ad=3.6p pd=10.72u as=3.6p ps=10.72u w=10u l=0.4u
X5 S3_0 G D2_0 B sg13_hv_pmos ad=3.6p pd=10.72u as=3.6p ps=10.72u w=10u l=0.4u
X6 D8_3 G S7_3 B sg13_hv_pmos ad=3.6p pd=10.72u as=3.6p ps=10.72u w=10u l=0.4u
X7 D6_2 G S5_2 B sg13_hv_pmos ad=3.6p pd=10.72u as=3.6p ps=10.72u w=10u l=0.4u
X8 S1_1 G D0_1 B sg13_hv_pmos ad=3.6p pd=10.72u as=6.8p ps=21.36u w=10u l=0.4u
X9 a_1048_44# G S9_2 B sg13_hv_pmos ad=6.8p pd=21.36u as=3.6p ps=10.72u w=10u l=0.4u
X10 D6_1 G S5_1 B sg13_hv_pmos ad=3.6p pd=10.72u as=3.6p ps=10.72u w=10u l=0.4u
X11 D8_1 G S7_1 B sg13_hv_pmos ad=3.6p pd=10.72u as=3.6p ps=10.72u w=10u l=0.4u
X12 S7_3 G D6_3 B sg13_hv_pmos ad=3.6p pd=10.72u as=3.6p ps=10.72u w=10u l=0.4u
X13 S3_2 G D2_2 B sg13_hv_pmos ad=3.6p pd=10.72u as=3.6p ps=10.72u w=10u l=0.4u
X14 S7_0 G D6_0 B sg13_hv_pmos ad=3.6p pd=10.72u as=3.6p ps=10.72u w=10u l=0.4u
X15 D2_0 G S1_0 B sg13_hv_pmos ad=3.6p pd=10.72u as=3.6p ps=10.72u w=10u l=0.4u
X16 S9_1 G D8_1 B sg13_hv_pmos ad=3.6p pd=10.72u as=3.6p ps=10.72u w=10u l=0.4u
X17 S1_0 G D0_0 B sg13_hv_pmos ad=3.6p pd=10.72u as=6.8p ps=21.36u w=10u l=0.4u
X18 D2_2 G S1_2 B sg13_hv_pmos ad=3.6p pd=10.72u as=3.6p ps=10.72u w=10u l=0.4u
X19 S9_2 G D8_2 B sg13_hv_pmos ad=3.6p pd=10.72u as=3.6p ps=10.72u w=10u l=0.4u
X20 a_1048_n2044# G S9_1 B sg13_hv_pmos ad=6.8p pd=21.36u as=3.6p ps=10.72u w=10u l=0.4u
X21 D6_0 G S5_0 B sg13_hv_pmos ad=3.6p pd=10.72u as=3.6p ps=10.72u w=10u l=0.4u
X22 D8_0 G S7_0 B sg13_hv_pmos ad=3.6p pd=10.72u as=3.6p ps=10.72u w=10u l=0.4u
X23 S1_3 G D0_3 B sg13_hv_pmos ad=3.6p pd=10.72u as=6.8p ps=21.36u w=10u l=0.4u
X24 D4_2 G S3_2 B sg13_hv_pmos ad=3.6p pd=10.72u as=3.6p ps=10.72u w=10u l=0.4u
X25 S5_1 G D4_1 B sg13_hv_pmos ad=3.6p pd=10.72u as=3.6p ps=10.72u w=10u l=0.4u
X26 D2_3 G S1_3 B sg13_hv_pmos ad=3.6p pd=10.72u as=3.6p ps=10.72u w=10u l=0.4u
X27 S1_2 G D0_2 B sg13_hv_pmos ad=3.6p pd=10.72u as=6.8p ps=21.36u w=10u l=0.4u
X28 S7_2 G D6_2 B sg13_hv_pmos ad=3.6p pd=10.72u as=3.6p ps=10.72u w=10u l=0.4u
X29 S9_0 G D8_0 B sg13_hv_pmos ad=3.6p pd=10.72u as=3.6p ps=10.72u w=10u l=0.4u
X30 S3_3 G D2_3 B sg13_hv_pmos ad=3.6p pd=10.72u as=3.6p ps=10.72u w=10u l=0.4u
X31 D4_1 G S3_1 B sg13_hv_pmos ad=3.6p pd=10.72u as=3.6p ps=10.72u w=10u l=0.4u
X32 a_1048_n4132# G S9_0 B sg13_hv_pmos ad=6.8p pd=21.36u as=3.6p ps=10.72u w=10u l=0.4u
X33 D4_3 G S3_3 B sg13_hv_pmos ad=3.6p pd=10.72u as=3.6p ps=10.72u w=10u l=0.4u
X34 D8_2 G S7_2 B sg13_hv_pmos ad=3.6p pd=10.72u as=3.6p ps=10.72u w=10u l=0.4u
X35 S5_0 G D4_0 B sg13_hv_pmos ad=3.6p pd=10.72u as=3.6p ps=10.72u w=10u l=0.4u
X36 S3_1 G D2_1 B sg13_hv_pmos ad=3.6p pd=10.72u as=3.6p ps=10.72u w=10u l=0.4u
X37 S5_2 G D4_2 B sg13_hv_pmos ad=3.6p pd=10.72u as=3.6p ps=10.72u w=10u l=0.4u
X38 S5_3 G D4_3 B sg13_hv_pmos ad=3.6p pd=10.72u as=3.6p ps=10.72u w=10u l=0.4u
X39 D4_0 G S3_0 B sg13_hv_pmos ad=3.6p pd=10.72u as=3.6p ps=10.72u w=10u l=0.4u
.ends

.subckt sg13_hv_nmos_VCL2HP D0 G0 S1 G1 D2 G2 S3 G3 D4 G4 S5 G5 D6 G6 S7 G7 D8 G8
+ S9 G9 D10 G10 S11 G11 D12 G12 S13 G13 D14 G14 S15 G15 D16 G16 S17 G17 D18 G18 S19
+ G19 D20 G20 S21 G21 D22 G22 S23 G23 D24 G24 S25 G25 D26 G26 S27 G27 D28 G28 S29
+ G29 D30 G30 S31 G31 D32 G32 S33 G33 D34 G34 S35 G35 D36 G36 S37 G37 D38 G38 S39
+ G39 sub a_3482_n500#
X0 S3 G2 D2 sub sg13_hv_nmos ad=0.95p pd=5.38u as=0.95p ps=5.38u w=5u l=0.5u
X1 D22 G21 S21 sub sg13_hv_nmos ad=0.95p pd=5.38u as=0.95p ps=5.38u w=5u l=0.5u
X2 D18 G17 S17 sub sg13_hv_nmos ad=0.95p pd=5.38u as=0.95p ps=5.38u w=5u l=0.5u
X3 D32 G31 S31 sub sg13_hv_nmos ad=0.95p pd=5.38u as=0.95p ps=5.38u w=5u l=0.5u
X4 D2 G1 S1 sub sg13_hv_nmos ad=0.95p pd=5.38u as=0.95p ps=5.38u w=5u l=0.5u
X5 S39 G38 D38 sub sg13_hv_nmos ad=0.95p pd=5.38u as=0.95p ps=5.38u w=5u l=0.5u
X6 S17 G16 D16 sub sg13_hv_nmos ad=0.95p pd=5.38u as=0.95p ps=5.38u w=5u l=0.5u
X7 D8 G7 S7 sub sg13_hv_nmos ad=0.95p pd=5.38u as=0.95p ps=5.38u w=5u l=0.5u
X8 S15 G14 D14 sub sg13_hv_nmos ad=0.95p pd=5.38u as=0.95p ps=5.38u w=5u l=0.5u
X9 D24 G23 S23 sub sg13_hv_nmos ad=0.95p pd=5.38u as=0.95p ps=5.38u w=5u l=0.5u
X10 D38 G37 S37 sub sg13_hv_nmos ad=0.95p pd=5.38u as=0.95p ps=5.38u w=5u l=0.5u
X11 D26 G25 S25 sub sg13_hv_nmos ad=0.95p pd=5.38u as=0.95p ps=5.38u w=5u l=0.5u
X12 D16 G15 S15 sub sg13_hv_nmos ad=0.95p pd=5.38u as=0.95p ps=5.38u w=5u l=0.5u
X13 S9 G8 D8 sub sg13_hv_nmos ad=0.95p pd=5.38u as=0.95p ps=5.38u w=5u l=0.5u
X14 S23 G22 D22 sub sg13_hv_nmos ad=0.95p pd=5.38u as=0.95p ps=5.38u w=5u l=0.5u
X15 D34 G33 S33 sub sg13_hv_nmos ad=0.95p pd=5.38u as=0.95p ps=5.38u w=5u l=0.5u
X16 S7 G6 D6 sub sg13_hv_nmos ad=0.95p pd=5.38u as=0.95p ps=5.38u w=5u l=0.5u
X17 S25 G24 D24 sub sg13_hv_nmos ad=0.95p pd=5.38u as=0.95p ps=5.38u w=5u l=0.5u
X18 S13 G12 D12 sub sg13_hv_nmos ad=0.95p pd=5.38u as=0.95p ps=5.38u w=5u l=0.5u
X19 S33 G32 D32 sub sg13_hv_nmos ad=0.95p pd=5.38u as=0.95p ps=5.38u w=5u l=0.5u
X20 S1 G0 D0 sub sg13_hv_nmos ad=0.95p pd=5.38u as=1.7p ps=10.68u w=5u l=0.5u
X21 D6 G5 S5 sub sg13_hv_nmos ad=0.95p pd=5.38u as=0.95p ps=5.38u w=5u l=0.5u
X22 S21 G20 D20 sub sg13_hv_nmos ad=0.95p pd=5.38u as=0.95p ps=5.38u w=5u l=0.5u
X23 S35 G34 D34 sub sg13_hv_nmos ad=0.95p pd=5.38u as=0.95p ps=5.38u w=5u l=0.5u
X24 a_3482_n500# G39 S39 sub sg13_hv_nmos ad=1.7p pd=10.68u as=0.95p ps=5.38u w=5u l=0.5u
X25 D14 G13 S13 sub sg13_hv_nmos ad=0.95p pd=5.38u as=0.95p ps=5.38u w=5u l=0.5u
X26 S27 G26 D26 sub sg13_hv_nmos ad=0.95p pd=5.38u as=0.95p ps=5.38u w=5u l=0.5u
X27 S29 G28 D28 sub sg13_hv_nmos ad=0.95p pd=5.38u as=0.95p ps=5.38u w=5u l=0.5u
X28 S5 G4 D4 sub sg13_hv_nmos ad=0.95p pd=5.38u as=0.95p ps=5.38u w=5u l=0.5u
X29 D12 G11 S11 sub sg13_hv_nmos ad=0.95p pd=5.38u as=0.95p ps=5.38u w=5u l=0.5u
X30 D36 G35 S35 sub sg13_hv_nmos ad=0.95p pd=5.38u as=0.95p ps=5.38u w=5u l=0.5u
X31 D28 G27 S27 sub sg13_hv_nmos ad=0.95p pd=5.38u as=0.95p ps=5.38u w=5u l=0.5u
X32 D4 G3 S3 sub sg13_hv_nmos ad=0.95p pd=5.38u as=0.95p ps=5.38u w=5u l=0.5u
X33 S11 G10 D10 sub sg13_hv_nmos ad=0.95p pd=5.38u as=0.95p ps=5.38u w=5u l=0.5u
X34 D20 G19 S19 sub sg13_hv_nmos ad=0.95p pd=5.38u as=0.95p ps=5.38u w=5u l=0.5u
X35 D30 G29 S29 sub sg13_hv_nmos ad=0.95p pd=5.38u as=0.95p ps=5.38u w=5u l=0.5u
X36 S37 G36 D36 sub sg13_hv_nmos ad=0.95p pd=5.38u as=0.95p ps=5.38u w=5u l=0.5u
X37 D10 G9 S9 sub sg13_hv_nmos ad=0.95p pd=5.38u as=0.95p ps=5.38u w=5u l=0.5u
X38 S19 G18 D18 sub sg13_hv_nmos ad=0.95p pd=5.38u as=0.95p ps=5.38u w=5u l=0.5u
X39 S31 G30 D30 sub sg13_hv_nmos ad=0.95p pd=5.38u as=0.95p ps=5.38u w=5u l=0.5u
.ends

.subckt sg13_hv_pmos_G9ZGU3 D0 G0 S1 G1 D2 G2 S3 G3 D4 G4 S5 G5 D6 G6 S7 G7 D8 G8
+ S9 G9 D10 G10 S11 G11 D12 G12 S13 G13 D14 G14 S15 G15 D16 G16 S17 G17 D18 G18 S19
+ G19 D20 G20 S21 G21 D22 G22 S23 G23 D24 G24 S25 G25 D26 G26 S27 G27 D28 G28 S29
+ G29 D30 G30 S31 G31 D32 G32 S33 G33 D34 G34 S35 G35 D36 G36 S37 G37 D38 G38 S39
+ G39 w_n3674_n1124# a_3482_n1000#
X0 D6 G5 S5 w_n3674_n1124# sg13_hv_pmos ad=1.9p pd=10.38u as=1.9p ps=10.38u w=10u l=0.5u
X1 S13 G12 D12 w_n3674_n1124# sg13_hv_pmos ad=1.9p pd=10.38u as=1.9p ps=10.38u w=10u l=0.5u
X2 S21 G20 D20 w_n3674_n1124# sg13_hv_pmos ad=1.9p pd=10.38u as=1.9p ps=10.38u w=10u l=0.5u
X3 S33 G32 D32 w_n3674_n1124# sg13_hv_pmos ad=1.9p pd=10.38u as=1.9p ps=10.38u w=10u l=0.5u
X4 S35 G34 D34 w_n3674_n1124# sg13_hv_pmos ad=1.9p pd=10.38u as=1.9p ps=10.38u w=10u l=0.5u
X5 a_3482_n1000# G39 S39 w_n3674_n1124# sg13_hv_pmos ad=3.4p pd=20.68u as=1.9p ps=10.38u w=10u l=0.5u
X6 S1 G0 D0 w_n3674_n1124# sg13_hv_pmos ad=1.9p pd=10.38u as=3.4p ps=20.68u w=10u l=0.5u
X7 D12 G11 S11 w_n3674_n1124# sg13_hv_pmos ad=1.9p pd=10.38u as=1.9p ps=10.38u w=10u l=0.5u
X8 D14 G13 S13 w_n3674_n1124# sg13_hv_pmos ad=1.9p pd=10.38u as=1.9p ps=10.38u w=10u l=0.5u
X9 S27 G26 D26 w_n3674_n1124# sg13_hv_pmos ad=1.9p pd=10.38u as=1.9p ps=10.38u w=10u l=0.5u
X10 S29 G28 D28 w_n3674_n1124# sg13_hv_pmos ad=1.9p pd=10.38u as=1.9p ps=10.38u w=10u l=0.5u
X11 D36 G35 S35 w_n3674_n1124# sg13_hv_pmos ad=1.9p pd=10.38u as=1.9p ps=10.38u w=10u l=0.5u
X12 S5 G4 D4 w_n3674_n1124# sg13_hv_pmos ad=1.9p pd=10.38u as=1.9p ps=10.38u w=10u l=0.5u
X13 S11 G10 D10 w_n3674_n1124# sg13_hv_pmos ad=1.9p pd=10.38u as=1.9p ps=10.38u w=10u l=0.5u
X14 D20 G19 S19 w_n3674_n1124# sg13_hv_pmos ad=1.9p pd=10.38u as=1.9p ps=10.38u w=10u l=0.5u
X15 D28 G27 S27 w_n3674_n1124# sg13_hv_pmos ad=1.9p pd=10.38u as=1.9p ps=10.38u w=10u l=0.5u
X16 D30 G29 S29 w_n3674_n1124# sg13_hv_pmos ad=1.9p pd=10.38u as=1.9p ps=10.38u w=10u l=0.5u
X17 D4 G3 S3 w_n3674_n1124# sg13_hv_pmos ad=1.9p pd=10.38u as=1.9p ps=10.38u w=10u l=0.5u
X18 S37 G36 D36 w_n3674_n1124# sg13_hv_pmos ad=1.9p pd=10.38u as=1.9p ps=10.38u w=10u l=0.5u
X19 S31 G30 D30 w_n3674_n1124# sg13_hv_pmos ad=1.9p pd=10.38u as=1.9p ps=10.38u w=10u l=0.5u
X20 D10 G9 S9 w_n3674_n1124# sg13_hv_pmos ad=1.9p pd=10.38u as=1.9p ps=10.38u w=10u l=0.5u
X21 S19 G18 D18 w_n3674_n1124# sg13_hv_pmos ad=1.9p pd=10.38u as=1.9p ps=10.38u w=10u l=0.5u
X22 D22 G21 S21 w_n3674_n1124# sg13_hv_pmos ad=1.9p pd=10.38u as=1.9p ps=10.38u w=10u l=0.5u
X23 S3 G2 D2 w_n3674_n1124# sg13_hv_pmos ad=1.9p pd=10.38u as=1.9p ps=10.38u w=10u l=0.5u
X24 D18 G17 S17 w_n3674_n1124# sg13_hv_pmos ad=1.9p pd=10.38u as=1.9p ps=10.38u w=10u l=0.5u
X25 D32 G31 S31 w_n3674_n1124# sg13_hv_pmos ad=1.9p pd=10.38u as=1.9p ps=10.38u w=10u l=0.5u
X26 D2 G1 S1 w_n3674_n1124# sg13_hv_pmos ad=1.9p pd=10.38u as=1.9p ps=10.38u w=10u l=0.5u
X27 S39 G38 D38 w_n3674_n1124# sg13_hv_pmos ad=1.9p pd=10.38u as=1.9p ps=10.38u w=10u l=0.5u
X28 S17 G16 D16 w_n3674_n1124# sg13_hv_pmos ad=1.9p pd=10.38u as=1.9p ps=10.38u w=10u l=0.5u
X29 S15 G14 D14 w_n3674_n1124# sg13_hv_pmos ad=1.9p pd=10.38u as=1.9p ps=10.38u w=10u l=0.5u
X30 D8 G7 S7 w_n3674_n1124# sg13_hv_pmos ad=1.9p pd=10.38u as=1.9p ps=10.38u w=10u l=0.5u
X31 D24 G23 S23 w_n3674_n1124# sg13_hv_pmos ad=1.9p pd=10.38u as=1.9p ps=10.38u w=10u l=0.5u
X32 D26 G25 S25 w_n3674_n1124# sg13_hv_pmos ad=1.9p pd=10.38u as=1.9p ps=10.38u w=10u l=0.5u
X33 D38 G37 S37 w_n3674_n1124# sg13_hv_pmos ad=1.9p pd=10.38u as=1.9p ps=10.38u w=10u l=0.5u
X34 D16 G15 S15 w_n3674_n1124# sg13_hv_pmos ad=1.9p pd=10.38u as=1.9p ps=10.38u w=10u l=0.5u
X35 S7 G6 D6 w_n3674_n1124# sg13_hv_pmos ad=1.9p pd=10.38u as=1.9p ps=10.38u w=10u l=0.5u
X36 S9 G8 D8 w_n3674_n1124# sg13_hv_pmos ad=1.9p pd=10.38u as=1.9p ps=10.38u w=10u l=0.5u
X37 S23 G22 D22 w_n3674_n1124# sg13_hv_pmos ad=1.9p pd=10.38u as=1.9p ps=10.38u w=10u l=0.5u
X38 S25 G24 D24 w_n3674_n1124# sg13_hv_pmos ad=1.9p pd=10.38u as=1.9p ps=10.38u w=10u l=0.5u
X39 D34 G33 S33 w_n3674_n1124# sg13_hv_pmos ad=1.9p pd=10.38u as=1.9p ps=10.38u w=10u l=0.5u
.ends

.subckt sg13_hv_pmos_2TUKLB D0 G0 S1 G1 w_n330_n174# a_138_n50#
X0 a_138_n50# G1 S1 w_n330_n174# sg13_hv_pmos ad=0.17p pd=1.68u as=95f ps=0.88u w=0.5u l=0.5u
X1 S1 G0 D0 w_n330_n174# sg13_hv_pmos ad=95f pd=0.88u as=0.17p ps=1.68u w=0.5u l=0.5u
.ends

.subckt sg13_hv_nmos_CJ33WB D0 S0 G0 D1 S1 G1 sub
X0 D1 G1 S1 sub sg13_hv_nmos ad=0.68p pd=4.68u as=0.68p ps=4.68u w=2u l=0.5u
X1 S0 G0 D0 sub sg13_hv_nmos ad=0.68p pd=4.68u as=0.68p ps=4.68u w=2u l=0.5u
.ends

.subckt gate_drive_med in_p in_n vdd out vss outn
Xsg13_hv_nmos_VCL2HP_0 vss sg13_hv_pmos_G9ZGU3_0/G1 sg13_hv_pmos_G9ZGU3_0/S1 sg13_hv_pmos_G9ZGU3_0/G1
+ vss sg13_hv_pmos_G9ZGU3_0/S1 sg13_hv_pmos_G9ZGU3_0/S7 sg13_hv_pmos_G9ZGU3_0/S1 vss
+ sg13_hv_pmos_G9ZGU3_0/S1 sg13_hv_pmos_G9ZGU3_0/S7 sg13_hv_pmos_G9ZGU3_0/S1 vss sg13_hv_pmos_G9ZGU3_0/S1
+ sg13_hv_pmos_G9ZGU3_0/S7 sg13_hv_pmos_G9ZGU3_0/S1 vss sg13_hv_pmos_G9ZGU3_0/S7 outn
+ sg13_hv_pmos_G9ZGU3_0/S7 vss sg13_hv_pmos_G9ZGU3_0/S7 outn sg13_hv_pmos_G9ZGU3_0/S7
+ vss sg13_hv_pmos_G9ZGU3_0/S7 outn sg13_hv_pmos_G9ZGU3_0/S7 vss sg13_hv_pmos_G9ZGU3_0/S7
+ outn sg13_hv_pmos_G9ZGU3_0/S7 vss sg13_hv_pmos_G9ZGU3_0/S7 outn sg13_hv_pmos_G9ZGU3_0/S7
+ vss sg13_hv_pmos_G9ZGU3_0/S7 outn sg13_hv_pmos_G9ZGU3_0/S7 vss sg13_hv_pmos_G9ZGU3_0/S7
+ outn sg13_hv_pmos_G9ZGU3_0/S7 vss sg13_hv_pmos_G9ZGU3_0/S7 outn sg13_hv_pmos_G9ZGU3_0/S7
+ vss outn out outn vss outn out outn vss outn out outn vss outn out outn vss outn
+ out outn vss outn out outn vss outn out outn vss outn out outn vss vss sg13_hv_nmos_VCL2HP
Xsg13_hv_pmos_G9ZGU3_0 vdd sg13_hv_pmos_G9ZGU3_0/G1 sg13_hv_pmos_G9ZGU3_0/S1 sg13_hv_pmos_G9ZGU3_0/G1
+ vdd sg13_hv_pmos_G9ZGU3_0/S1 sg13_hv_pmos_G9ZGU3_0/S7 sg13_hv_pmos_G9ZGU3_0/S1 vdd
+ sg13_hv_pmos_G9ZGU3_0/S1 sg13_hv_pmos_G9ZGU3_0/S7 sg13_hv_pmos_G9ZGU3_0/S1 vdd sg13_hv_pmos_G9ZGU3_0/S1
+ sg13_hv_pmos_G9ZGU3_0/S7 sg13_hv_pmos_G9ZGU3_0/S1 vdd sg13_hv_pmos_G9ZGU3_0/S7 outn
+ sg13_hv_pmos_G9ZGU3_0/S7 vdd sg13_hv_pmos_G9ZGU3_0/S7 outn sg13_hv_pmos_G9ZGU3_0/S7
+ vdd sg13_hv_pmos_G9ZGU3_0/S7 outn sg13_hv_pmos_G9ZGU3_0/S7 vdd sg13_hv_pmos_G9ZGU3_0/S7
+ outn sg13_hv_pmos_G9ZGU3_0/S7 vdd sg13_hv_pmos_G9ZGU3_0/S7 outn sg13_hv_pmos_G9ZGU3_0/S7
+ vdd sg13_hv_pmos_G9ZGU3_0/S7 outn sg13_hv_pmos_G9ZGU3_0/S7 vdd sg13_hv_pmos_G9ZGU3_0/S7
+ outn sg13_hv_pmos_G9ZGU3_0/S7 vdd sg13_hv_pmos_G9ZGU3_0/S7 outn sg13_hv_pmos_G9ZGU3_0/S7
+ vdd outn out outn vdd outn out outn vdd outn out outn vdd outn out outn vdd outn
+ out outn vdd outn out outn vdd outn out outn vdd outn out outn vdd vdd sg13_hv_pmos_G9ZGU3
Xsg13_hv_pmos_2TUKLB_0 sg13_hv_pmos_2TUKLB_0/G1 sg13_hv_pmos_G9ZGU3_0/G1 vdd sg13_hv_pmos_2TUKLB_0/G1
+ vdd sg13_hv_pmos_G9ZGU3_0/G1 sg13_hv_pmos_2TUKLB
Xsg13_hv_nmos_CJ33WB_0 vss sg13_hv_pmos_2TUKLB_0/G1 in_p sg13_hv_pmos_G9ZGU3_0/G1
+ vss in_n vss sg13_hv_nmos_CJ33WB
.ends

.subckt sg13_hv_nmos_9DTRBE B D0_0 G D0_1 D0_2 D0_3 S1_0 S1_1 S1_2 S1_3 D2_0 D2_1
+ D2_2 D2_3 S3_0 S3_1 S3_2 S3_3 D4_0 D4_1 D4_2 D4_3 S5_0 S5_1 S5_2 S5_3 D6_0 D6_1
+ D6_2 D6_3 S7_0 S7_1 S7_2 S7_3 D8_0 D8_1 D8_2 D8_3 S9_0 S9_1 S9_2 S9_3 a_1098_n4132#
+ a_1098_44# a_1098_n2044# a_1098_2132#
X0 D8_0 G S7_0 B sg13_hv_nmos ad=3.6p pd=10.72u as=3.6p ps=10.72u w=10u l=0.45u
X1 S5_2 G D4_2 B sg13_hv_nmos ad=3.6p pd=10.72u as=3.6p ps=10.72u w=10u l=0.45u
X2 S9_2 G D8_2 B sg13_hv_nmos ad=3.6p pd=10.72u as=3.6p ps=10.72u w=10u l=0.45u
X3 S1_3 G D0_3 B sg13_hv_nmos ad=3.6p pd=10.72u as=6.8p ps=21.36u w=10u l=0.45u
X4 D6_3 G S5_3 B sg13_hv_nmos ad=3.6p pd=10.72u as=3.6p ps=10.72u w=10u l=0.45u
X5 D2_1 G S1_1 B sg13_hv_nmos ad=3.6p pd=10.72u as=3.6p ps=10.72u w=10u l=0.45u
X6 S7_1 G D6_1 B sg13_hv_nmos ad=3.6p pd=10.72u as=3.6p ps=10.72u w=10u l=0.45u
X7 D8_2 G S7_2 B sg13_hv_nmos ad=3.6p pd=10.72u as=3.6p ps=10.72u w=10u l=0.45u
X8 S9_3 G D8_3 B sg13_hv_nmos ad=3.6p pd=10.72u as=3.6p ps=10.72u w=10u l=0.45u
X9 D2_2 G S1_2 B sg13_hv_nmos ad=3.6p pd=10.72u as=3.6p ps=10.72u w=10u l=0.45u
X10 D6_2 G S5_2 B sg13_hv_nmos ad=3.6p pd=10.72u as=3.6p ps=10.72u w=10u l=0.45u
X11 D4_3 G S3_3 B sg13_hv_nmos ad=3.6p pd=10.72u as=3.6p ps=10.72u w=10u l=0.45u
X12 D4_1 G S3_1 B sg13_hv_nmos ad=3.6p pd=10.72u as=3.6p ps=10.72u w=10u l=0.45u
X13 S1_0 G D0_0 B sg13_hv_nmos ad=3.6p pd=10.72u as=6.8p ps=21.36u w=10u l=0.45u
X14 D6_1 G S5_1 B sg13_hv_nmos ad=3.6p pd=10.72u as=3.6p ps=10.72u w=10u l=0.45u
X15 S5_1 G D4_1 B sg13_hv_nmos ad=3.6p pd=10.72u as=3.6p ps=10.72u w=10u l=0.45u
X16 D2_0 G S1_0 B sg13_hv_nmos ad=3.6p pd=10.72u as=3.6p ps=10.72u w=10u l=0.45u
X17 S7_0 G D6_0 B sg13_hv_nmos ad=3.6p pd=10.72u as=3.6p ps=10.72u w=10u l=0.45u
X18 D2_3 G S1_3 B sg13_hv_nmos ad=3.6p pd=10.72u as=3.6p ps=10.72u w=10u l=0.45u
X19 S3_1 G D2_1 B sg13_hv_nmos ad=3.6p pd=10.72u as=3.6p ps=10.72u w=10u l=0.45u
X20 D4_0 G S3_0 B sg13_hv_nmos ad=3.6p pd=10.72u as=3.6p ps=10.72u w=10u l=0.45u
X21 a_1098_2132# G S9_3 B sg13_hv_nmos ad=6.8p pd=21.36u as=3.6p ps=10.72u w=10u l=0.45u
X22 S1_2 G D0_2 B sg13_hv_nmos ad=3.6p pd=10.72u as=6.8p ps=21.36u w=10u l=0.45u
X23 D6_0 G S5_0 B sg13_hv_nmos ad=3.6p pd=10.72u as=3.6p ps=10.72u w=10u l=0.45u
X24 S3_3 G D2_3 B sg13_hv_nmos ad=3.6p pd=10.72u as=3.6p ps=10.72u w=10u l=0.45u
X25 D8_3 G S7_3 B sg13_hv_nmos ad=3.6p pd=10.72u as=3.6p ps=10.72u w=10u l=0.45u
X26 S5_0 G D4_0 B sg13_hv_nmos ad=3.6p pd=10.72u as=3.6p ps=10.72u w=10u l=0.45u
X27 S5_3 G D4_3 B sg13_hv_nmos ad=3.6p pd=10.72u as=3.6p ps=10.72u w=10u l=0.45u
X28 S9_1 G D8_1 B sg13_hv_nmos ad=3.6p pd=10.72u as=3.6p ps=10.72u w=10u l=0.45u
X29 a_1098_n2044# G S9_1 B sg13_hv_nmos ad=6.8p pd=21.36u as=3.6p ps=10.72u w=10u l=0.45u
X30 S3_0 G D2_0 B sg13_hv_nmos ad=3.6p pd=10.72u as=3.6p ps=10.72u w=10u l=0.45u
X31 S7_3 G D6_3 B sg13_hv_nmos ad=3.6p pd=10.72u as=3.6p ps=10.72u w=10u l=0.45u
X32 S7_2 G D6_2 B sg13_hv_nmos ad=3.6p pd=10.72u as=3.6p ps=10.72u w=10u l=0.45u
X33 D8_1 G S7_1 B sg13_hv_nmos ad=3.6p pd=10.72u as=3.6p ps=10.72u w=10u l=0.45u
X34 S3_2 G D2_2 B sg13_hv_nmos ad=3.6p pd=10.72u as=3.6p ps=10.72u w=10u l=0.45u
X35 a_1098_44# G S9_2 B sg13_hv_nmos ad=6.8p pd=21.36u as=3.6p ps=10.72u w=10u l=0.45u
X36 S9_0 G D8_0 B sg13_hv_nmos ad=3.6p pd=10.72u as=3.6p ps=10.72u w=10u l=0.45u
X37 D4_2 G S3_2 B sg13_hv_nmos ad=3.6p pd=10.72u as=3.6p ps=10.72u w=10u l=0.45u
X38 a_1098_n4132# G S9_0 B sg13_hv_nmos ad=6.8p pd=21.36u as=3.6p ps=10.72u w=10u l=0.45u
X39 S1_1 G D0_1 B sg13_hv_nmos ad=3.6p pd=10.72u as=6.8p ps=21.36u w=10u l=0.45u
.ends

.subckt sg13cmos5l_inv_4 Y A VDD VSS
X0 Y A VSS VSS sg13_lv_nmos ad=0.1406p pd=1.12u as=0.2516p ps=2.16u w=0.74u l=0.13u
X1 Y A VDD VDD sg13_lv_pmos ad=0.2128p pd=1.5u as=0.3808p ps=2.92u w=1.12u l=0.13u
X2 VSS A Y VSS sg13_lv_nmos ad=0.1406p pd=1.12u as=0.1406p ps=1.12u w=0.74u l=0.13u
X3 Y A VSS VSS sg13_lv_nmos ad=0.1406p pd=1.12u as=0.1406p ps=1.12u w=0.74u l=0.13u
X4 VDD A Y VDD sg13_lv_pmos ad=0.2128p pd=1.5u as=0.2128p ps=1.5u w=1.12u l=0.13u
X5 VSS A Y VSS sg13_lv_nmos ad=0.2516p pd=2.16u as=0.1406p ps=1.12u w=0.74u l=0.13u
X6 Y A VDD VDD sg13_lv_pmos ad=0.2128p pd=1.5u as=0.2128p ps=1.5u w=1.12u l=0.13u
X7 VDD A Y VDD sg13_lv_pmos ad=0.3808p pd=2.92u as=0.2128p ps=1.5u w=1.12u l=0.13u
.ends

.subckt analog_switch_med in enable avdd out dvss dvdd avss
Xsg13cmos5l_antennanp_0 enable dvdd dvss sg13cmos5l_antennanp
Xsg13_hv_pmos_3CJ4LL_0 avdd out gate_drive_med_0/outn out out out in in in in out
+ out out out in in in in out out out out in in in in out out out out in in in in
+ out out out out in in in in out out out out sg13_hv_pmos_3CJ4LL
Xgate_drive_med_0 sg13cmos5l_inv_4_1/Y sg13cmos5l_inv_4_1/A avdd gate_drive_med_0/out
+ avss gate_drive_med_0/outn gate_drive_med
Xsg13_hv_nmos_9DTRBE_0 avss out gate_drive_med_0/out out out out in in in in out out
+ out out in in in in out out out out in in in in out out out out in in in in out
+ out out out in in in in out out out out sg13_hv_nmos_9DTRBE
Xsg13cmos5l_decap_4_0 dvdd dvss sg13cmos5l_decap_4
Xsg13cmos5l_decap_4_1 dvdd dvss sg13cmos5l_decap_4
Xsg13cmos5l_inv_4_0 sg13cmos5l_inv_4_1/A enable dvdd dvss sg13cmos5l_inv_4
Xsg13cmos5l_inv_4_1 sg13cmos5l_inv_4_1/Y sg13cmos5l_inv_4_1/A dvdd dvss sg13cmos5l_inv_4
.ends

.subckt sg13_hv_pmos_HVFXC8 B D0 G S1 D2 S3 a_376_n500#
X0 a_376_n500# G S3 B sg13_hv_pmos ad=3.4p pd=11.36u as=1.8p ps=5.72u w=5u l=0.4u
X1 S1 G D0 B sg13_hv_pmos ad=1.8p pd=5.72u as=3.4p ps=11.36u w=5u l=0.4u
X2 D2 G S1 B sg13_hv_pmos ad=1.8p pd=5.72u as=1.8p ps=5.72u w=5u l=0.4u
X3 S3 G D2 B sg13_hv_pmos ad=1.8p pd=5.72u as=1.8p ps=5.72u w=5u l=0.4u
.ends

.subckt sg13_hv_pmos_XRP95E D0 G0 S1 G1 D2 G2 S3 G3 w_n506_n324# a_314_n200#
X0 S3 G2 D2 w_n506_n324# sg13_hv_pmos ad=0.38p pd=2.38u as=0.38p ps=2.38u w=2u l=0.5u
X1 D2 G1 S1 w_n506_n324# sg13_hv_pmos ad=0.38p pd=2.38u as=0.38p ps=2.38u w=2u l=0.5u
X2 S1 G0 D0 w_n506_n324# sg13_hv_pmos ad=0.38p pd=2.38u as=0.68p ps=4.68u w=2u l=0.5u
X3 a_314_n200# G3 S3 w_n506_n324# sg13_hv_pmos ad=0.68p pd=4.68u as=0.38p ps=2.38u w=2u l=0.5u
.ends

.subckt sg13_hv_nmos_HSMMZS D0 G0 S1 G1 D2 G2 S3 G3 a_314_n100# sub
X0 S3 G2 D2 sub sg13_hv_nmos ad=0.19p pd=1.38u as=0.19p ps=1.38u w=1u l=0.5u
X1 D2 G1 S1 sub sg13_hv_nmos ad=0.19p pd=1.38u as=0.19p ps=1.38u w=1u l=0.5u
X2 S1 G0 D0 sub sg13_hv_nmos ad=0.19p pd=1.38u as=0.34p ps=2.68u w=1u l=0.5u
X3 a_314_n100# G3 S3 sub sg13_hv_nmos ad=0.34p pd=2.68u as=0.19p ps=1.38u w=1u l=0.5u
.ends

.subckt sw_lvl_shift in_n in_p out outn vss vdd
Xsg13_hv_pmos_XRP95E_0 vdd sg13_hv_pmos_XRP95E_0/G1 outn sg13_hv_pmos_XRP95E_0/G1
+ vdd outn out outn vdd vdd sg13_hv_pmos_XRP95E
Xsg13_hv_pmos_2TUKLB_0 sg13_hv_pmos_2TUKLB_0/G1 sg13_hv_pmos_XRP95E_0/G1 vdd sg13_hv_pmos_2TUKLB_0/G1
+ vdd sg13_hv_pmos_XRP95E_0/G1 sg13_hv_pmos_2TUKLB
Xsg13_hv_nmos_CJ33WB_0 vss sg13_hv_pmos_2TUKLB_0/G1 in_p sg13_hv_pmos_XRP95E_0/G1
+ vss in_n vss sg13_hv_nmos_CJ33WB
Xsg13_hv_nmos_HSMMZS_0 vss sg13_hv_pmos_XRP95E_0/G1 outn sg13_hv_pmos_XRP95E_0/G1
+ vss outn out outn vss vss sg13_hv_nmos_HSMMZS
.ends

.subckt analog_pswitch_small in out avss enable avdd dvdd dvss
Xsg13cmos5l_antennanp_0 enable dvdd dvss sg13cmos5l_antennanp
Xsg13_hv_pmos_HVFXC8_0 avdd out sw_lvl_shift_0/outn in out in out sg13_hv_pmos_HVFXC8
Xsg13cmos5l_decap_4_0 dvdd dvss sg13cmos5l_decap_4
Xsw_lvl_shift_0 sw_lvl_shift_0/in_n sw_lvl_shift_0/in_p sw_lvl_shift_0/out sw_lvl_shift_0/outn
+ avss avdd sw_lvl_shift
Xsg13cmos5l_decap_4_1 dvdd dvss sg13cmos5l_decap_4
Xsg13cmos5l_inv_4_0 sw_lvl_shift_0/in_n enable dvdd dvss sg13cmos5l_inv_4
Xsg13cmos5l_inv_4_1 sw_lvl_shift_0/in_p sw_lvl_shift_0/in_n dvdd dvss sg13cmos5l_inv_4
.ends

.subckt sg13_hv_nmos_U4HMWB B D0 G S1 D2 S3 a_396_n500#
X0 S1 G D0 B sg13_hv_nmos ad=1.8p pd=5.72u as=3.4p ps=11.36u w=5u l=0.45u
X1 D2 G S1 B sg13_hv_nmos ad=1.8p pd=5.72u as=1.8p ps=5.72u w=5u l=0.45u
X2 a_396_n500# G S3 B sg13_hv_nmos ad=3.4p pd=11.36u as=1.8p ps=5.72u w=5u l=0.45u
X3 S3 G D2 B sg13_hv_nmos ad=1.8p pd=5.72u as=1.8p ps=5.72u w=5u l=0.45u
.ends

.subckt analog_switch_small in out avss enable avdd dvdd dvss
Xsg13_hv_nmos_U4HMWB_0 avss in sw_lvl_shift_0/out out in out in sg13_hv_nmos_U4HMWB
Xsg13cmos5l_antennanp_0 enable dvdd dvss sg13cmos5l_antennanp
Xsg13_hv_pmos_HVFXC8_0 avdd out sw_lvl_shift_0/outn in out in out sg13_hv_pmos_HVFXC8
Xsw_lvl_shift_0 sw_lvl_shift_0/in_n sw_lvl_shift_0/in_p sw_lvl_shift_0/out sw_lvl_shift_0/outn
+ avss avdd sw_lvl_shift
Xsg13cmos5l_decap_4_0 dvdd dvss sg13cmos5l_decap_4
Xsg13cmos5l_decap_4_1 dvdd dvss sg13cmos5l_decap_4
Xsg13cmos5l_inv_4_0 sw_lvl_shift_0/in_n enable dvdd dvss sg13cmos5l_inv_4
Xsg13cmos5l_inv_4_1 sw_lvl_shift_0/in_p sw_lvl_shift_0/in_n dvdd dvss sg13cmos5l_inv_4
.ends

.subckt analog_switch_array analog_switch_med_3/out analog_switch_med_17/enable analog_switch_small_1/in
+ m3_189186_500988# analog_switch_med_0/enable analog_switch_med_2/enable m3_189186_501576#
+ analog_switch_med_20/in m3_189186_500400# analog_switch_med_18/in analog_switch_med_20/enable
+ analog_switch_med_1/enable analog_pswitch_small_3/in m3_248802_509908# analog_switch_small_0/avdd
+ analog_pswitch_small_3/enable analog_pswitch_small_2/in analog_switch_med_22/in
+ m3_250566_516139# analog_switch_med_0/in m3_249390_511986# analog_pswitch_small_2/enable
+ analog_pswitch_small_2/avdd analog_switch_small_1/enable analog_pswitch_small_0/avdd
+ analog_switch_med_3/enable analog_switch_small_0/out analog_switch_med_3/in analog_switch_med_2/in
+ analog_switch_small_1/dvdd analog_switch_med_1/in analog_switch_small_1/avdd analog_switch_small_0/dvdd
+ m3_229182_500988# analog_pswitch_small_3/out analog_pswitch_small_1/out analog_switch_med_17/in
+ analog_pswitch_small_1/enable m3_229182_501576# analog_pswitch_small_0/dvdd analog_pswitch_small_0/out
+ analog_switch_small_0/enable m3_189186_502176# analog_pswitch_small_2/dvdd analog_pswitch_small_2/dvss
+ m3_251154_516139# m3_229182_500400# analog_pswitch_small_3/avdd analog_switch_med_0/out
+ analog_switch_med_1/out analog_pswitch_small_2/out analog_switch_small_0/dvss analog_switch_med_18/enable
+ analog_switch_small_1/out analog_pswitch_small_0/enable analog_pswitch_small_1/avdd
+ m3_249978_514146# analog_switch_med_22/enable analog_pswitch_small_1/dvdd m3_222018_502176#
+ analog_switch_med_3/dvss analog_switch_med_3/dvdd analog_pswitch_small_1/dvss analog_switch_small_1/dvss
+ analog_switch_med_2/out analog_switch_med_3/avdd analog_switch_med_22/dvdd sub analog_pswitch_small_3/dvdd
+ analog_pswitch_small_3/dvss analog_pswitch_small_0/dvss analog_switch_med_22/dvss
Xanalog_switch_med_0 analog_switch_med_0/in analog_switch_med_0/enable analog_switch_med_3/avdd
+ analog_switch_med_0/out analog_switch_med_3/dvss analog_switch_med_3/dvdd sub analog_switch_med
Xanalog_switch_med_1 analog_switch_med_1/in analog_switch_med_1/enable analog_switch_med_3/avdd
+ analog_switch_med_1/out analog_switch_med_3/dvss analog_switch_med_3/dvdd sub analog_switch_med
Xanalog_switch_med_2 analog_switch_med_2/in analog_switch_med_2/enable analog_switch_med_3/avdd
+ analog_switch_med_2/out analog_switch_med_3/dvss analog_switch_med_3/dvdd sub analog_switch_med
Xanalog_switch_med_3 analog_switch_med_3/in analog_switch_med_3/enable analog_switch_med_3/avdd
+ analog_switch_med_3/out analog_switch_med_3/dvss analog_switch_med_3/dvdd sub analog_switch_med
Xanalog_pswitch_small_1 analog_pswitch_small_2/in analog_pswitch_small_1/out sub analog_pswitch_small_1/enable
+ analog_pswitch_small_1/avdd analog_pswitch_small_1/dvdd analog_pswitch_small_1/dvss
+ analog_pswitch_small
Xanalog_pswitch_small_0 analog_pswitch_small_3/in analog_pswitch_small_0/out sub analog_pswitch_small_0/enable
+ analog_pswitch_small_0/avdd analog_pswitch_small_0/dvdd analog_pswitch_small_0/dvss
+ analog_pswitch_small
Xanalog_pswitch_small_2 analog_pswitch_small_2/in analog_pswitch_small_2/out sub analog_pswitch_small_2/enable
+ analog_pswitch_small_2/avdd analog_pswitch_small_2/dvdd analog_pswitch_small_2/dvss
+ analog_pswitch_small
Xanalog_pswitch_small_3 analog_pswitch_small_3/in analog_pswitch_small_3/out sub analog_pswitch_small_3/enable
+ analog_pswitch_small_3/avdd analog_pswitch_small_3/dvdd analog_pswitch_small_3/dvss
+ analog_pswitch_small
Xanalog_switch_med_20 analog_switch_med_20/in analog_switch_med_20/enable analog_switch_med_3/avdd
+ analog_switch_med_2/out analog_switch_med_22/dvss analog_switch_med_22/dvdd sub
+ analog_switch_med
Xanalog_switch_med_22 analog_switch_med_22/in analog_switch_med_22/enable analog_switch_med_3/avdd
+ analog_switch_med_3/out analog_switch_med_22/dvss analog_switch_med_22/dvdd sub
+ analog_switch_med
Xanalog_switch_med_17 analog_switch_med_17/in analog_switch_med_17/enable analog_switch_med_3/avdd
+ analog_switch_med_0/out analog_switch_med_22/dvss analog_switch_med_22/dvdd sub
+ analog_switch_med
Xanalog_switch_med_18 analog_switch_med_18/in analog_switch_med_18/enable analog_switch_med_3/avdd
+ analog_switch_med_1/out analog_switch_med_22/dvss analog_switch_med_22/dvdd sub
+ analog_switch_med
Xanalog_switch_small_0 analog_switch_small_1/in analog_switch_small_0/out sub analog_switch_small_0/enable
+ analog_switch_small_0/avdd analog_switch_small_0/dvdd analog_switch_small_0/dvss
+ analog_switch_small
Xanalog_switch_small_1 analog_switch_small_1/in analog_switch_small_1/out sub analog_switch_small_1/enable
+ analog_switch_small_1/avdd analog_switch_small_1/dvdd analog_switch_small_1/dvss
+ analog_switch_small
.ends

.subckt sg13_hv_pmos_ZN7EJW B D0_0 G D0_1 D0_2 D0_3 D0_4 D0_5 D0_6 D0_7 D0_8 D0_9
+ S1_0 S1_1 S1_2 S1_3 S1_4 S1_5 S1_6 S1_7 S1_8 S1_9 D2_0 D2_1 D2_2 D2_3 D2_4 D2_5
+ D2_6 D2_7 D2_8 D2_9 S3_0 S3_1 S3_2 S3_3 S3_4 S3_5 S3_6 S3_7 S3_8 S3_9 D4_0 D4_1
+ D4_2 D4_3 D4_4 D4_5 D4_6 D4_7 D4_8 D4_9 S5_0 S5_1 S5_2 S5_3 S5_4 S5_5 S5_6 S5_7
+ S5_8 S5_9 D6_0 D6_1 D6_2 D6_3 D6_4 D6_5 D6_6 D6_7 D6_8 D6_9 S7_0 S7_1 S7_2 S7_3
+ S7_4 S7_5 S7_6 S7_7 S7_8 S7_9 D8_0 D8_1 D8_2 D8_3 D8_4 D8_5 D8_6 D8_7 D8_8 D8_9
+ S9_0 S9_1 S9_2 S9_3 S9_4 S9_5 S9_6 S9_7 S9_8 S9_9 a_1048_44# a_1048_n4132# a_1048_n8308#
+ a_1048_8396# a_1048_4220# a_1048_n10396# a_1048_n2044# a_1048_2132# a_1048_6308#
+ a_1048_n6220#
X0 a_1048_n8308# G S9_1 B sg13_hv_pmos ad=6.8p pd=21.36u as=3.6p ps=10.72u w=10u l=0.4u
X1 S3_7 G D2_7 B sg13_hv_pmos ad=3.6p pd=10.72u as=3.6p ps=10.72u w=10u l=0.4u
X2 a_1048_2132# G S9_6 B sg13_hv_pmos ad=6.8p pd=21.36u as=3.6p ps=10.72u w=10u l=0.4u
X3 S7_9 G D6_9 B sg13_hv_pmos ad=3.6p pd=10.72u as=3.6p ps=10.72u w=10u l=0.4u
X4 D4_0 G S3_0 B sg13_hv_pmos ad=3.6p pd=10.72u as=3.6p ps=10.72u w=10u l=0.4u
X5 D4_8 G S3_8 B sg13_hv_pmos ad=3.6p pd=10.72u as=3.6p ps=10.72u w=10u l=0.4u
X6 S5_1 G D4_1 B sg13_hv_pmos ad=3.6p pd=10.72u as=3.6p ps=10.72u w=10u l=0.4u
X7 S7_4 G D6_4 B sg13_hv_pmos ad=3.6p pd=10.72u as=3.6p ps=10.72u w=10u l=0.4u
X8 S1_0 G D0_0 B sg13_hv_pmos ad=3.6p pd=10.72u as=6.8p ps=21.36u w=10u l=0.4u
X9 S3_2 G D2_2 B sg13_hv_pmos ad=3.6p pd=10.72u as=3.6p ps=10.72u w=10u l=0.4u
X10 D4_7 G S3_7 B sg13_hv_pmos ad=3.6p pd=10.72u as=3.6p ps=10.72u w=10u l=0.4u
X11 a_1048_n10396# G S9_0 B sg13_hv_pmos ad=6.8p pd=21.36u as=3.6p ps=10.72u w=10u l=0.4u
X12 D2_4 G S1_4 B sg13_hv_pmos ad=3.6p pd=10.72u as=3.6p ps=10.72u w=10u l=0.4u
X13 D6_6 G S5_6 B sg13_hv_pmos ad=3.6p pd=10.72u as=3.6p ps=10.72u w=10u l=0.4u
X14 S3_3 G D2_3 B sg13_hv_pmos ad=3.6p pd=10.72u as=3.6p ps=10.72u w=10u l=0.4u
X15 S9_6 G D8_6 B sg13_hv_pmos ad=3.6p pd=10.72u as=3.6p ps=10.72u w=10u l=0.4u
X16 S5_8 G D4_8 B sg13_hv_pmos ad=3.6p pd=10.72u as=3.6p ps=10.72u w=10u l=0.4u
X17 D4_1 G S3_1 B sg13_hv_pmos ad=3.6p pd=10.72u as=3.6p ps=10.72u w=10u l=0.4u
X18 S5_7 G D4_7 B sg13_hv_pmos ad=3.6p pd=10.72u as=3.6p ps=10.72u w=10u l=0.4u
X19 S1_4 G D0_4 B sg13_hv_pmos ad=3.6p pd=10.72u as=6.8p ps=21.36u w=10u l=0.4u
X20 a_1048_6308# G S9_8 B sg13_hv_pmos ad=6.8p pd=21.36u as=3.6p ps=10.72u w=10u l=0.4u
X21 D6_5 G S5_5 B sg13_hv_pmos ad=3.6p pd=10.72u as=3.6p ps=10.72u w=10u l=0.4u
X22 S5_0 G D4_0 B sg13_hv_pmos ad=3.6p pd=10.72u as=3.6p ps=10.72u w=10u l=0.4u
X23 D8_6 G S7_6 B sg13_hv_pmos ad=3.6p pd=10.72u as=3.6p ps=10.72u w=10u l=0.4u
X24 a_1048_44# G S9_5 B sg13_hv_pmos ad=6.8p pd=21.36u as=3.6p ps=10.72u w=10u l=0.4u
X25 S7_2 G D6_2 B sg13_hv_pmos ad=3.6p pd=10.72u as=3.6p ps=10.72u w=10u l=0.4u
X26 a_1048_4220# G S9_7 B sg13_hv_pmos ad=6.8p pd=21.36u as=3.6p ps=10.72u w=10u l=0.4u
X27 S1_9 G D0_9 B sg13_hv_pmos ad=3.6p pd=10.72u as=6.8p ps=21.36u w=10u l=0.4u
X28 D8_4 G S7_4 B sg13_hv_pmos ad=3.6p pd=10.72u as=3.6p ps=10.72u w=10u l=0.4u
X29 D6_4 G S5_4 B sg13_hv_pmos ad=3.6p pd=10.72u as=3.6p ps=10.72u w=10u l=0.4u
X30 S9_0 G D8_0 B sg13_hv_pmos ad=3.6p pd=10.72u as=3.6p ps=10.72u w=10u l=0.4u
X31 D2_2 G S1_2 B sg13_hv_pmos ad=3.6p pd=10.72u as=3.6p ps=10.72u w=10u l=0.4u
X32 D6_8 G S5_8 B sg13_hv_pmos ad=3.6p pd=10.72u as=3.6p ps=10.72u w=10u l=0.4u
X33 S7_3 G D6_3 B sg13_hv_pmos ad=3.6p pd=10.72u as=3.6p ps=10.72u w=10u l=0.4u
X34 S3_5 G D2_5 B sg13_hv_pmos ad=3.6p pd=10.72u as=3.6p ps=10.72u w=10u l=0.4u
X35 S3_1 G D2_1 B sg13_hv_pmos ad=3.6p pd=10.72u as=3.6p ps=10.72u w=10u l=0.4u
X36 S9_8 G D8_8 B sg13_hv_pmos ad=3.6p pd=10.72u as=3.6p ps=10.72u w=10u l=0.4u
X37 D2_9 G S1_9 B sg13_hv_pmos ad=3.6p pd=10.72u as=3.6p ps=10.72u w=10u l=0.4u
X38 S7_6 G D6_6 B sg13_hv_pmos ad=3.6p pd=10.72u as=3.6p ps=10.72u w=10u l=0.4u
X39 D2_3 G S1_3 B sg13_hv_pmos ad=3.6p pd=10.72u as=3.6p ps=10.72u w=10u l=0.4u
X40 D6_7 G S5_7 B sg13_hv_pmos ad=3.6p pd=10.72u as=3.6p ps=10.72u w=10u l=0.4u
X41 S9_7 G D8_7 B sg13_hv_pmos ad=3.6p pd=10.72u as=3.6p ps=10.72u w=10u l=0.4u
X42 S1_2 G D0_2 B sg13_hv_pmos ad=3.6p pd=10.72u as=6.8p ps=21.36u w=10u l=0.4u
X43 S9_4 G D8_4 B sg13_hv_pmos ad=3.6p pd=10.72u as=3.6p ps=10.72u w=10u l=0.4u
X44 S3_9 G D2_9 B sg13_hv_pmos ad=3.6p pd=10.72u as=3.6p ps=10.72u w=10u l=0.4u
X45 D8_8 G S7_8 B sg13_hv_pmos ad=3.6p pd=10.72u as=3.6p ps=10.72u w=10u l=0.4u
X46 S1_3 G D0_3 B sg13_hv_pmos ad=3.6p pd=10.72u as=6.8p ps=21.36u w=10u l=0.4u
X47 S7_0 G D6_0 B sg13_hv_pmos ad=3.6p pd=10.72u as=3.6p ps=10.72u w=10u l=0.4u
X48 D8_2 G S7_2 B sg13_hv_pmos ad=3.6p pd=10.72u as=3.6p ps=10.72u w=10u l=0.4u
X49 D8_7 G S7_7 B sg13_hv_pmos ad=3.6p pd=10.72u as=3.6p ps=10.72u w=10u l=0.4u
X50 D6_2 G S5_2 B sg13_hv_pmos ad=3.6p pd=10.72u as=3.6p ps=10.72u w=10u l=0.4u
X51 D8_0 G S7_0 B sg13_hv_pmos ad=3.6p pd=10.72u as=3.6p ps=10.72u w=10u l=0.4u
X52 S7_1 G D6_1 B sg13_hv_pmos ad=3.6p pd=10.72u as=3.6p ps=10.72u w=10u l=0.4u
X53 D2_5 G S1_5 B sg13_hv_pmos ad=3.6p pd=10.72u as=3.6p ps=10.72u w=10u l=0.4u
X54 D8_3 G S7_3 B sg13_hv_pmos ad=3.6p pd=10.72u as=3.6p ps=10.72u w=10u l=0.4u
X55 D6_3 G S5_3 B sg13_hv_pmos ad=3.6p pd=10.72u as=3.6p ps=10.72u w=10u l=0.4u
X56 S7_8 G D6_8 B sg13_hv_pmos ad=3.6p pd=10.72u as=3.6p ps=10.72u w=10u l=0.4u
X57 D4_9 G S3_9 B sg13_hv_pmos ad=3.6p pd=10.72u as=3.6p ps=10.72u w=10u l=0.4u
X58 S9_5 G D8_5 B sg13_hv_pmos ad=3.6p pd=10.72u as=3.6p ps=10.72u w=10u l=0.4u
X59 D2_1 G S1_1 B sg13_hv_pmos ad=3.6p pd=10.72u as=3.6p ps=10.72u w=10u l=0.4u
X60 a_1048_n2044# G S9_4 B sg13_hv_pmos ad=6.8p pd=21.36u as=3.6p ps=10.72u w=10u l=0.4u
X61 S7_7 G D6_7 B sg13_hv_pmos ad=3.6p pd=10.72u as=3.6p ps=10.72u w=10u l=0.4u
X62 S1_6 G D0_6 B sg13_hv_pmos ad=3.6p pd=10.72u as=6.8p ps=21.36u w=10u l=0.4u
X63 S5_4 G D4_4 B sg13_hv_pmos ad=3.6p pd=10.72u as=3.6p ps=10.72u w=10u l=0.4u
X64 D4_5 G S3_5 B sg13_hv_pmos ad=3.6p pd=10.72u as=3.6p ps=10.72u w=10u l=0.4u
X65 S9_2 G D8_2 B sg13_hv_pmos ad=3.6p pd=10.72u as=3.6p ps=10.72u w=10u l=0.4u
X66 S1_5 G D0_5 B sg13_hv_pmos ad=3.6p pd=10.72u as=6.8p ps=21.36u w=10u l=0.4u
X67 S7_5 G D6_5 B sg13_hv_pmos ad=3.6p pd=10.72u as=3.6p ps=10.72u w=10u l=0.4u
X68 D2_6 G S1_6 B sg13_hv_pmos ad=3.6p pd=10.72u as=3.6p ps=10.72u w=10u l=0.4u
X69 S5_9 G D4_9 B sg13_hv_pmos ad=3.6p pd=10.72u as=3.6p ps=10.72u w=10u l=0.4u
X70 S1_1 G D0_1 B sg13_hv_pmos ad=3.6p pd=10.72u as=6.8p ps=21.36u w=10u l=0.4u
X71 S9_3 G D8_3 B sg13_hv_pmos ad=3.6p pd=10.72u as=3.6p ps=10.72u w=10u l=0.4u
X72 a_1048_8396# G S9_9 B sg13_hv_pmos ad=6.8p pd=21.36u as=3.6p ps=10.72u w=10u l=0.4u
X73 D8_1 G S7_1 B sg13_hv_pmos ad=3.6p pd=10.72u as=3.6p ps=10.72u w=10u l=0.4u
X74 D6_1 G S5_1 B sg13_hv_pmos ad=3.6p pd=10.72u as=3.6p ps=10.72u w=10u l=0.4u
X75 D4_4 G S3_4 B sg13_hv_pmos ad=3.6p pd=10.72u as=3.6p ps=10.72u w=10u l=0.4u
X76 S3_6 G D2_6 B sg13_hv_pmos ad=3.6p pd=10.72u as=3.6p ps=10.72u w=10u l=0.4u
X77 D6_0 G S5_0 B sg13_hv_pmos ad=3.6p pd=10.72u as=3.6p ps=10.72u w=10u l=0.4u
X78 a_1048_n6220# G S9_2 B sg13_hv_pmos ad=6.8p pd=21.36u as=3.6p ps=10.72u w=10u l=0.4u
X79 S1_8 G D0_8 B sg13_hv_pmos ad=3.6p pd=10.72u as=6.8p ps=21.36u w=10u l=0.4u
X80 D6_9 G S5_9 B sg13_hv_pmos ad=3.6p pd=10.72u as=3.6p ps=10.72u w=10u l=0.4u
X81 a_1048_n4132# G S9_3 B sg13_hv_pmos ad=6.8p pd=21.36u as=3.6p ps=10.72u w=10u l=0.4u
X82 S5_2 G D4_2 B sg13_hv_pmos ad=3.6p pd=10.72u as=3.6p ps=10.72u w=10u l=0.4u
X83 S9_9 G D8_9 B sg13_hv_pmos ad=3.6p pd=10.72u as=3.6p ps=10.72u w=10u l=0.4u
X84 S3_0 G D2_0 B sg13_hv_pmos ad=3.6p pd=10.72u as=3.6p ps=10.72u w=10u l=0.4u
X85 D8_5 G S7_5 B sg13_hv_pmos ad=3.6p pd=10.72u as=3.6p ps=10.72u w=10u l=0.4u
X86 S1_7 G D0_7 B sg13_hv_pmos ad=3.6p pd=10.72u as=6.8p ps=21.36u w=10u l=0.4u
X87 D2_8 G S1_8 B sg13_hv_pmos ad=3.6p pd=10.72u as=3.6p ps=10.72u w=10u l=0.4u
X88 S5_3 G D4_3 B sg13_hv_pmos ad=3.6p pd=10.72u as=3.6p ps=10.72u w=10u l=0.4u
X89 D4_6 G S3_6 B sg13_hv_pmos ad=3.6p pd=10.72u as=3.6p ps=10.72u w=10u l=0.4u
X90 D2_0 G S1_0 B sg13_hv_pmos ad=3.6p pd=10.72u as=3.6p ps=10.72u w=10u l=0.4u
X91 S9_1 G D8_1 B sg13_hv_pmos ad=3.6p pd=10.72u as=3.6p ps=10.72u w=10u l=0.4u
X92 S3_4 G D2_4 B sg13_hv_pmos ad=3.6p pd=10.72u as=3.6p ps=10.72u w=10u l=0.4u
X93 D2_7 G S1_7 B sg13_hv_pmos ad=3.6p pd=10.72u as=3.6p ps=10.72u w=10u l=0.4u
X94 S5_5 G D4_5 B sg13_hv_pmos ad=3.6p pd=10.72u as=3.6p ps=10.72u w=10u l=0.4u
X95 D8_9 G S7_9 B sg13_hv_pmos ad=3.6p pd=10.72u as=3.6p ps=10.72u w=10u l=0.4u
X96 D4_2 G S3_2 B sg13_hv_pmos ad=3.6p pd=10.72u as=3.6p ps=10.72u w=10u l=0.4u
X97 S3_8 G D2_8 B sg13_hv_pmos ad=3.6p pd=10.72u as=3.6p ps=10.72u w=10u l=0.4u
X98 S5_6 G D4_6 B sg13_hv_pmos ad=3.6p pd=10.72u as=3.6p ps=10.72u w=10u l=0.4u
X99 D4_3 G S3_3 B sg13_hv_pmos ad=3.6p pd=10.72u as=3.6p ps=10.72u w=10u l=0.4u
.ends

.subckt sg13_hv_nmos_XAVYYR D0 G0 S1 G1 D2 G2 S3 G3 sub a_314_n200#
X0 S3 G2 D2 sub sg13_hv_nmos ad=0.38p pd=2.38u as=0.38p ps=2.38u w=2u l=0.5u
X1 D2 G1 S1 sub sg13_hv_nmos ad=0.38p pd=2.38u as=0.38p ps=2.38u w=2u l=0.5u
X2 S1 G0 D0 sub sg13_hv_nmos ad=0.38p pd=2.38u as=0.68p ps=4.68u w=2u l=0.5u
X3 a_314_n200# G3 S3 sub sg13_hv_nmos ad=0.68p pd=4.68u as=0.38p ps=2.38u w=2u l=0.5u
.ends

.subckt sg13_hv_nmos_3JX36Y D0 G0 S1 G1 D2 G2 S3 G3 D4 G4 S5 G5 D6 G6 S7 G7 D8 G8
+ S9 G9 D10 G10 S11 G11 D12 G12 S13 G13 D14 G14 S15 G15 D16 G16 S17 G17 D18 G18 S19
+ G19 D20 G20 S21 G21 D22 G22 S23 G23 D24 G24 S25 G25 D26 G26 S27 G27 D28 G28 S29
+ G29 D30 G30 S31 G31 D32 G32 S33 G33 D34 G34 S35 G35 D36 G36 S37 G37 D38 G38 S39
+ G39 D40 G40 S41 G41 D42 G42 S43 G43 D44 G44 S45 G45 D46 G46 S47 G47 D48 G48 S49
+ G49 D50 G50 S51 G51 D52 G52 S53 G53 D54 G54 S55 G55 D56 G56 S57 G57 D58 G58 S59
+ G59 D60 G60 S61 G61 D62 G62 S63 G63 D64 G64 S65 G65 D66 G66 S67 G67 D68 G68 S69
+ G69 D70 G70 S71 G71 D72 G72 S73 G73 D74 G74 S75 G75 D76 G76 S77 G77 D78 G78 S79
+ G79 D80 G80 S81 G81 D82 G82 S83 G83 D84 G84 S85 G85 D86 G86 S87 G87 a_7706_n500#
+ sub
X0 S27 G26 D26 sub sg13_hv_nmos ad=0.95p pd=5.38u as=0.95p ps=5.38u w=5u l=0.5u
X1 D46 G45 S45 sub sg13_hv_nmos ad=0.95p pd=5.38u as=0.95p ps=5.38u w=5u l=0.5u
X2 D8 G7 S7 sub sg13_hv_nmos ad=0.95p pd=5.38u as=0.95p ps=5.38u w=5u l=0.5u
X3 S15 G14 D14 sub sg13_hv_nmos ad=0.95p pd=5.38u as=0.95p ps=5.38u w=5u l=0.5u
X4 D42 G41 S41 sub sg13_hv_nmos ad=0.95p pd=5.38u as=0.95p ps=5.38u w=5u l=0.5u
X5 D56 G55 S55 sub sg13_hv_nmos ad=0.95p pd=5.38u as=0.95p ps=5.38u w=5u l=0.5u
X6 D74 G73 S73 sub sg13_hv_nmos ad=0.95p pd=5.38u as=0.95p ps=5.38u w=5u l=0.5u
X7 S81 G80 D80 sub sg13_hv_nmos ad=0.95p pd=5.38u as=0.95p ps=5.38u w=5u l=0.5u
X8 D6 G5 S5 sub sg13_hv_nmos ad=0.95p pd=5.38u as=0.95p ps=5.38u w=5u l=0.5u
X9 S83 G82 D82 sub sg13_hv_nmos ad=0.95p pd=5.38u as=0.95p ps=5.38u w=5u l=0.5u
X10 S19 G18 D18 sub sg13_hv_nmos ad=0.95p pd=5.38u as=0.95p ps=5.38u w=5u l=0.5u
X11 S21 G20 D20 sub sg13_hv_nmos ad=0.95p pd=5.38u as=0.95p ps=5.38u w=5u l=0.5u
X12 D26 G25 S25 sub sg13_hv_nmos ad=0.95p pd=5.38u as=0.95p ps=5.38u w=5u l=0.5u
X13 S63 G62 D62 sub sg13_hv_nmos ad=0.95p pd=5.38u as=0.95p ps=5.38u w=5u l=0.5u
X14 D68 G67 S67 sub sg13_hv_nmos ad=0.95p pd=5.38u as=0.95p ps=5.38u w=5u l=0.5u
X15 D70 G69 S69 sub sg13_hv_nmos ad=0.95p pd=5.38u as=0.95p ps=5.38u w=5u l=0.5u
X16 D12 G11 S11 sub sg13_hv_nmos ad=0.95p pd=5.38u as=0.95p ps=5.38u w=5u l=0.5u
X17 S41 G40 D40 sub sg13_hv_nmos ad=0.95p pd=5.38u as=0.95p ps=5.38u w=5u l=0.5u
X18 D82 G81 S81 sub sg13_hv_nmos ad=0.95p pd=5.38u as=0.95p ps=5.38u w=5u l=0.5u
X19 D84 G83 S83 sub sg13_hv_nmos ad=0.95p pd=5.38u as=0.95p ps=5.38u w=5u l=0.5u
X20 D32 G31 S31 sub sg13_hv_nmos ad=0.95p pd=5.38u as=0.95p ps=5.38u w=5u l=0.5u
X21 S39 G38 D38 sub sg13_hv_nmos ad=0.95p pd=5.38u as=0.95p ps=5.38u w=5u l=0.5u
X22 D48 G47 S47 sub sg13_hv_nmos ad=0.95p pd=5.38u as=0.95p ps=5.38u w=5u l=0.5u
X23 D62 G61 S61 sub sg13_hv_nmos ad=0.95p pd=5.38u as=0.95p ps=5.38u w=5u l=0.5u
X24 S13 G12 D12 sub sg13_hv_nmos ad=0.95p pd=5.38u as=0.95p ps=5.38u w=5u l=0.5u
X25 D18 G17 S17 sub sg13_hv_nmos ad=0.95p pd=5.38u as=0.95p ps=5.38u w=5u l=0.5u
X26 D20 G19 S19 sub sg13_hv_nmos ad=0.95p pd=5.38u as=0.95p ps=5.38u w=5u l=0.5u
X27 D50 G49 S49 sub sg13_hv_nmos ad=0.95p pd=5.38u as=0.95p ps=5.38u w=5u l=0.5u
X28 S69 G68 D68 sub sg13_hv_nmos ad=0.95p pd=5.38u as=0.95p ps=5.38u w=5u l=0.5u
X29 S71 G70 D70 sub sg13_hv_nmos ad=0.95p pd=5.38u as=0.95p ps=5.38u w=5u l=0.5u
X30 D76 G75 S75 sub sg13_hv_nmos ad=0.95p pd=5.38u as=0.95p ps=5.38u w=5u l=0.5u
X31 S11 G10 D10 sub sg13_hv_nmos ad=0.95p pd=5.38u as=0.95p ps=5.38u w=5u l=0.5u
X32 D40 G39 S39 sub sg13_hv_nmos ad=0.95p pd=5.38u as=0.95p ps=5.38u w=5u l=0.5u
X33 D78 G77 S77 sub sg13_hv_nmos ad=0.95p pd=5.38u as=0.95p ps=5.38u w=5u l=0.5u
X34 S33 G32 D32 sub sg13_hv_nmos ad=0.95p pd=5.38u as=0.95p ps=5.38u w=5u l=0.5u
X35 S47 G46 D46 sub sg13_hv_nmos ad=0.95p pd=5.38u as=0.95p ps=5.38u w=5u l=0.5u
X36 D58 G57 S57 sub sg13_hv_nmos ad=0.95p pd=5.38u as=0.95p ps=5.38u w=5u l=0.5u
X37 D24 G23 S23 sub sg13_hv_nmos ad=0.95p pd=5.38u as=0.95p ps=5.38u w=5u l=0.5u
X38 S31 G30 D30 sub sg13_hv_nmos ad=0.95p pd=5.38u as=0.95p ps=5.38u w=5u l=0.5u
X39 S49 G48 D48 sub sg13_hv_nmos ad=0.95p pd=5.38u as=0.95p ps=5.38u w=5u l=0.5u
X40 S65 G64 D64 sub sg13_hv_nmos ad=0.95p pd=5.38u as=0.95p ps=5.38u w=5u l=0.5u
X41 S17 G16 D16 sub sg13_hv_nmos ad=0.95p pd=5.38u as=0.95p ps=5.38u w=5u l=0.5u
X42 S77 G76 D76 sub sg13_hv_nmos ad=0.95p pd=5.38u as=0.95p ps=5.38u w=5u l=0.5u
X43 S37 G36 D36 sub sg13_hv_nmos ad=0.95p pd=5.38u as=0.95p ps=5.38u w=5u l=0.5u
X44 S57 G56 D56 sub sg13_hv_nmos ad=0.95p pd=5.38u as=0.95p ps=5.38u w=5u l=0.5u
X45 S5 G4 D4 sub sg13_hv_nmos ad=0.95p pd=5.38u as=0.95p ps=5.38u w=5u l=0.5u
X46 S23 G22 D22 sub sg13_hv_nmos ad=0.95p pd=5.38u as=0.95p ps=5.38u w=5u l=0.5u
X47 S25 G24 D24 sub sg13_hv_nmos ad=0.95p pd=5.38u as=0.95p ps=5.38u w=5u l=0.5u
X48 D30 G29 S29 sub sg13_hv_nmos ad=0.95p pd=5.38u as=0.95p ps=5.38u w=5u l=0.5u
X49 S45 G44 D44 sub sg13_hv_nmos ad=0.95p pd=5.38u as=0.95p ps=5.38u w=5u l=0.5u
X50 S59 G58 D58 sub sg13_hv_nmos ad=0.95p pd=5.38u as=0.95p ps=5.38u w=5u l=0.5u
X51 D64 G63 S63 sub sg13_hv_nmos ad=0.95p pd=5.38u as=0.95p ps=5.38u w=5u l=0.5u
X52 D66 G65 S65 sub sg13_hv_nmos ad=0.95p pd=5.38u as=0.95p ps=5.38u w=5u l=0.5u
X53 S73 G72 D72 sub sg13_hv_nmos ad=0.95p pd=5.38u as=0.95p ps=5.38u w=5u l=0.5u
X54 D38 G37 S37 sub sg13_hv_nmos ad=0.95p pd=5.38u as=0.95p ps=5.38u w=5u l=0.5u
X55 S51 G50 D50 sub sg13_hv_nmos ad=0.95p pd=5.38u as=0.95p ps=5.38u w=5u l=0.5u
X56 S53 G52 D52 sub sg13_hv_nmos ad=0.95p pd=5.38u as=0.95p ps=5.38u w=5u l=0.5u
X57 D4 G3 S3 sub sg13_hv_nmos ad=0.95p pd=5.38u as=0.95p ps=5.38u w=5u l=0.5u
X58 S29 G28 D28 sub sg13_hv_nmos ad=0.95p pd=5.38u as=0.95p ps=5.38u w=5u l=0.5u
X59 D36 G35 S35 sub sg13_hv_nmos ad=0.95p pd=5.38u as=0.95p ps=5.38u w=5u l=0.5u
X60 D60 G59 S59 sub sg13_hv_nmos ad=0.95p pd=5.38u as=0.95p ps=5.38u w=5u l=0.5u
X61 S85 G84 D84 sub sg13_hv_nmos ad=0.95p pd=5.38u as=0.95p ps=5.38u w=5u l=0.5u
X62 D2 G1 S1 sub sg13_hv_nmos ad=0.95p pd=5.38u as=0.95p ps=5.38u w=5u l=0.5u
X63 S67 G66 D66 sub sg13_hv_nmos ad=0.95p pd=5.38u as=0.95p ps=5.38u w=5u l=0.5u
X64 D72 G71 S71 sub sg13_hv_nmos ad=0.95p pd=5.38u as=0.95p ps=5.38u w=5u l=0.5u
X65 D22 G21 S21 sub sg13_hv_nmos ad=0.95p pd=5.38u as=0.95p ps=5.38u w=5u l=0.5u
X66 D52 G51 S51 sub sg13_hv_nmos ad=0.95p pd=5.38u as=0.95p ps=5.38u w=5u l=0.5u
X67 S3 G2 D2 sub sg13_hv_nmos ad=0.95p pd=5.38u as=0.95p ps=5.38u w=5u l=0.5u
X68 D10 G9 S9 sub sg13_hv_nmos ad=0.95p pd=5.38u as=0.95p ps=5.38u w=5u l=0.5u
X69 D28 G27 S27 sub sg13_hv_nmos ad=0.95p pd=5.38u as=0.95p ps=5.38u w=5u l=0.5u
X70 S35 G34 D34 sub sg13_hv_nmos ad=0.95p pd=5.38u as=0.95p ps=5.38u w=5u l=0.5u
X71 D44 G43 S43 sub sg13_hv_nmos ad=0.95p pd=5.38u as=0.95p ps=5.38u w=5u l=0.5u
X72 D54 G53 S53 sub sg13_hv_nmos ad=0.95p pd=5.38u as=0.95p ps=5.38u w=5u l=0.5u
X73 S61 G60 D60 sub sg13_hv_nmos ad=0.95p pd=5.38u as=0.95p ps=5.38u w=5u l=0.5u
X74 S79 G78 D78 sub sg13_hv_nmos ad=0.95p pd=5.38u as=0.95p ps=5.38u w=5u l=0.5u
X75 D86 G85 S85 sub sg13_hv_nmos ad=0.95p pd=5.38u as=0.95p ps=5.38u w=5u l=0.5u
X76 S1 G0 D0 sub sg13_hv_nmos ad=0.95p pd=5.38u as=1.7p ps=10.68u w=5u l=0.5u
X77 a_7706_n500# G87 S87 sub sg13_hv_nmos ad=1.7p pd=10.68u as=0.95p ps=5.38u w=5u l=0.5u
X78 S9 G8 D8 sub sg13_hv_nmos ad=0.95p pd=5.38u as=0.95p ps=5.38u w=5u l=0.5u
X79 D14 G13 S13 sub sg13_hv_nmos ad=0.95p pd=5.38u as=0.95p ps=5.38u w=5u l=0.5u
X80 D16 G15 S15 sub sg13_hv_nmos ad=0.95p pd=5.38u as=0.95p ps=5.38u w=5u l=0.5u
X81 D34 G33 S33 sub sg13_hv_nmos ad=0.95p pd=5.38u as=0.95p ps=5.38u w=5u l=0.5u
X82 S43 G42 D42 sub sg13_hv_nmos ad=0.95p pd=5.38u as=0.95p ps=5.38u w=5u l=0.5u
X83 S55 G54 D54 sub sg13_hv_nmos ad=0.95p pd=5.38u as=0.95p ps=5.38u w=5u l=0.5u
X84 S75 G74 D74 sub sg13_hv_nmos ad=0.95p pd=5.38u as=0.95p ps=5.38u w=5u l=0.5u
X85 D80 G79 S79 sub sg13_hv_nmos ad=0.95p pd=5.38u as=0.95p ps=5.38u w=5u l=0.5u
X86 S7 G6 D6 sub sg13_hv_nmos ad=0.95p pd=5.38u as=0.95p ps=5.38u w=5u l=0.5u
X87 S87 G86 D86 sub sg13_hv_nmos ad=0.95p pd=5.38u as=0.95p ps=5.38u w=5u l=0.5u
.ends

.subckt sg13_hv_pmos_RQMCRC D0 G0 S1 G1 D2 G2 S3 G3 D4 G4 S5 G5 D6 G6 S7 G7 D8 G8
+ S9 G9 D10 G10 S11 G11 D12 G12 S13 G13 D14 G14 S15 G15 D16 G16 S17 G17 D18 G18 S19
+ G19 D20 G20 S21 G21 D22 G22 S23 G23 D24 G24 S25 G25 D26 G26 S27 G27 D28 G28 S29
+ G29 D30 G30 S31 G31 D32 G32 S33 G33 D34 G34 S35 G35 D36 G36 S37 G37 D38 G38 S39
+ G39 D40 G40 S41 G41 D42 G42 S43 G43 D44 G44 S45 G45 D46 G46 S47 G47 D48 G48 S49
+ G49 D50 G50 S51 G51 D52 G52 S53 G53 D54 G54 S55 G55 D56 G56 S57 G57 D58 G58 S59
+ G59 D60 G60 S61 G61 D62 G62 S63 G63 D64 G64 S65 G65 D66 G66 S67 G67 D68 G68 S69
+ G69 D70 G70 S71 G71 D72 G72 S73 G73 D74 G74 S75 G75 D76 G76 S77 G77 D78 G78 S79
+ G79 D80 G80 S81 G81 D82 G82 S83 G83 D84 G84 S85 G85 D86 G86 S87 G87 w_n7898_n1124#
+ a_7706_n1000#
X0 D30 G29 S29 w_n7898_n1124# sg13_hv_pmos ad=1.9p pd=10.38u as=1.9p ps=10.38u w=10u l=0.5u
X1 S37 G36 D36 w_n7898_n1124# sg13_hv_pmos ad=1.9p pd=10.38u as=1.9p ps=10.38u w=10u l=0.5u
X2 S45 G44 D44 w_n7898_n1124# sg13_hv_pmos ad=1.9p pd=10.38u as=1.9p ps=10.38u w=10u l=0.5u
X3 S57 G56 D56 w_n7898_n1124# sg13_hv_pmos ad=1.9p pd=10.38u as=1.9p ps=10.38u w=10u l=0.5u
X4 S59 G58 D58 w_n7898_n1124# sg13_hv_pmos ad=1.9p pd=10.38u as=1.9p ps=10.38u w=10u l=0.5u
X5 D64 G63 S63 w_n7898_n1124# sg13_hv_pmos ad=1.9p pd=10.38u as=1.9p ps=10.38u w=10u l=0.5u
X6 S5 G4 D4 w_n7898_n1124# sg13_hv_pmos ad=1.9p pd=10.38u as=1.9p ps=10.38u w=10u l=0.5u
X7 S23 G22 D22 w_n7898_n1124# sg13_hv_pmos ad=1.9p pd=10.38u as=1.9p ps=10.38u w=10u l=0.5u
X8 S25 G24 D24 w_n7898_n1124# sg13_hv_pmos ad=1.9p pd=10.38u as=1.9p ps=10.38u w=10u l=0.5u
X9 D66 G65 S65 w_n7898_n1124# sg13_hv_pmos ad=1.9p pd=10.38u as=1.9p ps=10.38u w=10u l=0.5u
X10 S73 G72 D72 w_n7898_n1124# sg13_hv_pmos ad=1.9p pd=10.38u as=1.9p ps=10.38u w=10u l=0.5u
X11 D36 G35 S35 w_n7898_n1124# sg13_hv_pmos ad=1.9p pd=10.38u as=1.9p ps=10.38u w=10u l=0.5u
X12 D38 G37 S37 w_n7898_n1124# sg13_hv_pmos ad=1.9p pd=10.38u as=1.9p ps=10.38u w=10u l=0.5u
X13 S51 G50 D50 w_n7898_n1124# sg13_hv_pmos ad=1.9p pd=10.38u as=1.9p ps=10.38u w=10u l=0.5u
X14 S53 G52 D52 w_n7898_n1124# sg13_hv_pmos ad=1.9p pd=10.38u as=1.9p ps=10.38u w=10u l=0.5u
X15 D60 G59 S59 w_n7898_n1124# sg13_hv_pmos ad=1.9p pd=10.38u as=1.9p ps=10.38u w=10u l=0.5u
X16 D2 G1 S1 w_n7898_n1124# sg13_hv_pmos ad=1.9p pd=10.38u as=1.9p ps=10.38u w=10u l=0.5u
X17 D4 G3 S3 w_n7898_n1124# sg13_hv_pmos ad=1.9p pd=10.38u as=1.9p ps=10.38u w=10u l=0.5u
X18 S29 G28 D28 w_n7898_n1124# sg13_hv_pmos ad=1.9p pd=10.38u as=1.9p ps=10.38u w=10u l=0.5u
X19 S67 G66 D66 w_n7898_n1124# sg13_hv_pmos ad=1.9p pd=10.38u as=1.9p ps=10.38u w=10u l=0.5u
X20 D72 G71 S71 w_n7898_n1124# sg13_hv_pmos ad=1.9p pd=10.38u as=1.9p ps=10.38u w=10u l=0.5u
X21 S85 G84 D84 w_n7898_n1124# sg13_hv_pmos ad=1.9p pd=10.38u as=1.9p ps=10.38u w=10u l=0.5u
X22 D22 G21 S21 w_n7898_n1124# sg13_hv_pmos ad=1.9p pd=10.38u as=1.9p ps=10.38u w=10u l=0.5u
X23 S35 G34 D34 w_n7898_n1124# sg13_hv_pmos ad=1.9p pd=10.38u as=1.9p ps=10.38u w=10u l=0.5u
X24 D44 G43 S43 w_n7898_n1124# sg13_hv_pmos ad=1.9p pd=10.38u as=1.9p ps=10.38u w=10u l=0.5u
X25 D52 G51 S51 w_n7898_n1124# sg13_hv_pmos ad=1.9p pd=10.38u as=1.9p ps=10.38u w=10u l=0.5u
X26 D54 G53 S53 w_n7898_n1124# sg13_hv_pmos ad=1.9p pd=10.38u as=1.9p ps=10.38u w=10u l=0.5u
X27 S79 G78 D78 w_n7898_n1124# sg13_hv_pmos ad=1.9p pd=10.38u as=1.9p ps=10.38u w=10u l=0.5u
X28 S1 G0 D0 w_n7898_n1124# sg13_hv_pmos ad=1.9p pd=10.38u as=3.4p ps=20.68u w=10u l=0.5u
X29 S3 G2 D2 w_n7898_n1124# sg13_hv_pmos ad=1.9p pd=10.38u as=1.9p ps=10.38u w=10u l=0.5u
X30 D10 G9 S9 w_n7898_n1124# sg13_hv_pmos ad=1.9p pd=10.38u as=1.9p ps=10.38u w=10u l=0.5u
X31 D28 G27 S27 w_n7898_n1124# sg13_hv_pmos ad=1.9p pd=10.38u as=1.9p ps=10.38u w=10u l=0.5u
X32 S61 G60 D60 w_n7898_n1124# sg13_hv_pmos ad=1.9p pd=10.38u as=1.9p ps=10.38u w=10u l=0.5u
X33 D86 G85 S85 w_n7898_n1124# sg13_hv_pmos ad=1.9p pd=10.38u as=1.9p ps=10.38u w=10u l=0.5u
X34 a_7706_n1000# G87 S87 w_n7898_n1124# sg13_hv_pmos ad=3.4p pd=20.68u as=1.9p ps=10.38u w=10u l=0.5u
X35 D16 G15 S15 w_n7898_n1124# sg13_hv_pmos ad=1.9p pd=10.38u as=1.9p ps=10.38u w=10u l=0.5u
X36 S55 G54 D54 w_n7898_n1124# sg13_hv_pmos ad=1.9p pd=10.38u as=1.9p ps=10.38u w=10u l=0.5u
X37 S75 G74 D74 w_n7898_n1124# sg13_hv_pmos ad=1.9p pd=10.38u as=1.9p ps=10.38u w=10u l=0.5u
X38 S7 G6 D6 w_n7898_n1124# sg13_hv_pmos ad=1.9p pd=10.38u as=1.9p ps=10.38u w=10u l=0.5u
X39 S9 G8 D8 w_n7898_n1124# sg13_hv_pmos ad=1.9p pd=10.38u as=1.9p ps=10.38u w=10u l=0.5u
X40 D14 G13 S13 w_n7898_n1124# sg13_hv_pmos ad=1.9p pd=10.38u as=1.9p ps=10.38u w=10u l=0.5u
X41 D34 G33 S33 w_n7898_n1124# sg13_hv_pmos ad=1.9p pd=10.38u as=1.9p ps=10.38u w=10u l=0.5u
X42 S43 G42 D42 w_n7898_n1124# sg13_hv_pmos ad=1.9p pd=10.38u as=1.9p ps=10.38u w=10u l=0.5u
X43 D80 G79 S79 w_n7898_n1124# sg13_hv_pmos ad=1.9p pd=10.38u as=1.9p ps=10.38u w=10u l=0.5u
X44 S87 G86 D86 w_n7898_n1124# sg13_hv_pmos ad=1.9p pd=10.38u as=1.9p ps=10.38u w=10u l=0.5u
X45 D46 G45 S45 w_n7898_n1124# sg13_hv_pmos ad=1.9p pd=10.38u as=1.9p ps=10.38u w=10u l=0.5u
X46 S27 G26 D26 w_n7898_n1124# sg13_hv_pmos ad=1.9p pd=10.38u as=1.9p ps=10.38u w=10u l=0.5u
X47 D74 G73 S73 w_n7898_n1124# sg13_hv_pmos ad=1.9p pd=10.38u as=1.9p ps=10.38u w=10u l=0.5u
X48 D6 G5 S5 w_n7898_n1124# sg13_hv_pmos ad=1.9p pd=10.38u as=1.9p ps=10.38u w=10u l=0.5u
X49 D8 G7 S7 w_n7898_n1124# sg13_hv_pmos ad=1.9p pd=10.38u as=1.9p ps=10.38u w=10u l=0.5u
X50 S15 G14 D14 w_n7898_n1124# sg13_hv_pmos ad=1.9p pd=10.38u as=1.9p ps=10.38u w=10u l=0.5u
X51 D42 G41 S41 w_n7898_n1124# sg13_hv_pmos ad=1.9p pd=10.38u as=1.9p ps=10.38u w=10u l=0.5u
X52 D56 G55 S55 w_n7898_n1124# sg13_hv_pmos ad=1.9p pd=10.38u as=1.9p ps=10.38u w=10u l=0.5u
X53 S81 G80 D80 w_n7898_n1124# sg13_hv_pmos ad=1.9p pd=10.38u as=1.9p ps=10.38u w=10u l=0.5u
X54 S83 G82 D82 w_n7898_n1124# sg13_hv_pmos ad=1.9p pd=10.38u as=1.9p ps=10.38u w=10u l=0.5u
X55 S21 G20 D20 w_n7898_n1124# sg13_hv_pmos ad=1.9p pd=10.38u as=1.9p ps=10.38u w=10u l=0.5u
X56 D26 G25 S25 w_n7898_n1124# sg13_hv_pmos ad=1.9p pd=10.38u as=1.9p ps=10.38u w=10u l=0.5u
X57 S63 G62 D62 w_n7898_n1124# sg13_hv_pmos ad=1.9p pd=10.38u as=1.9p ps=10.38u w=10u l=0.5u
X58 D68 G67 S67 w_n7898_n1124# sg13_hv_pmos ad=1.9p pd=10.38u as=1.9p ps=10.38u w=10u l=0.5u
X59 D70 G69 S69 w_n7898_n1124# sg13_hv_pmos ad=1.9p pd=10.38u as=1.9p ps=10.38u w=10u l=0.5u
X60 D12 G11 S11 w_n7898_n1124# sg13_hv_pmos ad=1.9p pd=10.38u as=1.9p ps=10.38u w=10u l=0.5u
X61 S19 G18 D18 w_n7898_n1124# sg13_hv_pmos ad=1.9p pd=10.38u as=1.9p ps=10.38u w=10u l=0.5u
X62 S41 G40 D40 w_n7898_n1124# sg13_hv_pmos ad=1.9p pd=10.38u as=1.9p ps=10.38u w=10u l=0.5u
X63 D82 G81 S81 w_n7898_n1124# sg13_hv_pmos ad=1.9p pd=10.38u as=1.9p ps=10.38u w=10u l=0.5u
X64 D84 G83 S83 w_n7898_n1124# sg13_hv_pmos ad=1.9p pd=10.38u as=1.9p ps=10.38u w=10u l=0.5u
X65 S39 G38 D38 w_n7898_n1124# sg13_hv_pmos ad=1.9p pd=10.38u as=1.9p ps=10.38u w=10u l=0.5u
X66 D32 G31 S31 w_n7898_n1124# sg13_hv_pmos ad=1.9p pd=10.38u as=1.9p ps=10.38u w=10u l=0.5u
X67 D48 G47 S47 w_n7898_n1124# sg13_hv_pmos ad=1.9p pd=10.38u as=1.9p ps=10.38u w=10u l=0.5u
X68 D50 G49 S49 w_n7898_n1124# sg13_hv_pmos ad=1.9p pd=10.38u as=1.9p ps=10.38u w=10u l=0.5u
X69 D62 G61 S61 w_n7898_n1124# sg13_hv_pmos ad=1.9p pd=10.38u as=1.9p ps=10.38u w=10u l=0.5u
X70 S69 G68 D68 w_n7898_n1124# sg13_hv_pmos ad=1.9p pd=10.38u as=1.9p ps=10.38u w=10u l=0.5u
X71 S11 G10 D10 w_n7898_n1124# sg13_hv_pmos ad=1.9p pd=10.38u as=1.9p ps=10.38u w=10u l=0.5u
X72 S13 G12 D12 w_n7898_n1124# sg13_hv_pmos ad=1.9p pd=10.38u as=1.9p ps=10.38u w=10u l=0.5u
X73 D18 G17 S17 w_n7898_n1124# sg13_hv_pmos ad=1.9p pd=10.38u as=1.9p ps=10.38u w=10u l=0.5u
X74 D20 G19 S19 w_n7898_n1124# sg13_hv_pmos ad=1.9p pd=10.38u as=1.9p ps=10.38u w=10u l=0.5u
X75 D40 G39 S39 w_n7898_n1124# sg13_hv_pmos ad=1.9p pd=10.38u as=1.9p ps=10.38u w=10u l=0.5u
X76 S71 G70 D70 w_n7898_n1124# sg13_hv_pmos ad=1.9p pd=10.38u as=1.9p ps=10.38u w=10u l=0.5u
X77 D76 G75 S75 w_n7898_n1124# sg13_hv_pmos ad=1.9p pd=10.38u as=1.9p ps=10.38u w=10u l=0.5u
X78 D78 G77 S77 w_n7898_n1124# sg13_hv_pmos ad=1.9p pd=10.38u as=1.9p ps=10.38u w=10u l=0.5u
X79 S31 G30 D30 w_n7898_n1124# sg13_hv_pmos ad=1.9p pd=10.38u as=1.9p ps=10.38u w=10u l=0.5u
X80 S33 G32 D32 w_n7898_n1124# sg13_hv_pmos ad=1.9p pd=10.38u as=1.9p ps=10.38u w=10u l=0.5u
X81 S47 G46 D46 w_n7898_n1124# sg13_hv_pmos ad=1.9p pd=10.38u as=1.9p ps=10.38u w=10u l=0.5u
X82 S49 G48 D48 w_n7898_n1124# sg13_hv_pmos ad=1.9p pd=10.38u as=1.9p ps=10.38u w=10u l=0.5u
X83 D58 G57 S57 w_n7898_n1124# sg13_hv_pmos ad=1.9p pd=10.38u as=1.9p ps=10.38u w=10u l=0.5u
X84 S65 G64 D64 w_n7898_n1124# sg13_hv_pmos ad=1.9p pd=10.38u as=1.9p ps=10.38u w=10u l=0.5u
X85 S17 G16 D16 w_n7898_n1124# sg13_hv_pmos ad=1.9p pd=10.38u as=1.9p ps=10.38u w=10u l=0.5u
X86 D24 G23 S23 w_n7898_n1124# sg13_hv_pmos ad=1.9p pd=10.38u as=1.9p ps=10.38u w=10u l=0.5u
X87 S77 G76 D76 w_n7898_n1124# sg13_hv_pmos ad=1.9p pd=10.38u as=1.9p ps=10.38u w=10u l=0.5u
.ends

.subckt sg13_hv_pmos_FG6ZZW D0 G0 S1 G1 D2 G2 S3 G3 a_314_n100# w_n506_n224#
X0 a_314_n100# G3 S3 w_n506_n224# sg13_hv_pmos ad=0.34p pd=2.68u as=0.19p ps=1.38u w=1u l=0.5u
X1 S3 G2 D2 w_n506_n224# sg13_hv_pmos ad=0.19p pd=1.38u as=0.19p ps=1.38u w=1u l=0.5u
X2 D2 G1 S1 w_n506_n224# sg13_hv_pmos ad=0.19p pd=1.38u as=0.19p ps=1.38u w=1u l=0.5u
X3 S1 G0 D0 w_n506_n224# sg13_hv_pmos ad=0.19p pd=1.38u as=0.34p ps=2.68u w=1u l=0.5u
.ends

.subckt gate_drive_large in_p in_n out vss vdd
Xsg13_hv_nmos_XAVYYR_0 vss in_p sg13_hv_pmos_FG6ZZW_0/S1 in_p vss in_n sg13_hv_pmos_RQMCRC_0/G1
+ in_n vss vss sg13_hv_nmos_XAVYYR
Xsg13_hv_nmos_3JX36Y_0 vss sg13_hv_pmos_RQMCRC_0/G1 sg13_hv_pmos_RQMCRC_0/S1 sg13_hv_pmos_RQMCRC_0/G1
+ vss sg13_hv_pmos_RQMCRC_0/S1 sg13_hv_pmos_RQMCRC_0/S7 sg13_hv_pmos_RQMCRC_0/S1 vss
+ sg13_hv_pmos_RQMCRC_0/S1 sg13_hv_pmos_RQMCRC_0/S7 sg13_hv_pmos_RQMCRC_0/S1 vss sg13_hv_pmos_RQMCRC_0/S1
+ sg13_hv_pmos_RQMCRC_0/S7 sg13_hv_pmos_RQMCRC_0/S1 vss sg13_hv_pmos_RQMCRC_0/S7 sg13_hv_pmos_RQMCRC_0/S9
+ sg13_hv_pmos_RQMCRC_0/S7 vss sg13_hv_pmos_RQMCRC_0/S7 sg13_hv_pmos_RQMCRC_0/S9 sg13_hv_pmos_RQMCRC_0/S7
+ vss sg13_hv_pmos_RQMCRC_0/S7 sg13_hv_pmos_RQMCRC_0/S9 sg13_hv_pmos_RQMCRC_0/S7 vss
+ sg13_hv_pmos_RQMCRC_0/S7 sg13_hv_pmos_RQMCRC_0/S9 sg13_hv_pmos_RQMCRC_0/S7 vss sg13_hv_pmos_RQMCRC_0/S7
+ sg13_hv_pmos_RQMCRC_0/S9 sg13_hv_pmos_RQMCRC_0/S7 vss sg13_hv_pmos_RQMCRC_0/S7 sg13_hv_pmos_RQMCRC_0/S9
+ sg13_hv_pmos_RQMCRC_0/S7 vss sg13_hv_pmos_RQMCRC_0/S7 sg13_hv_pmos_RQMCRC_0/S9 sg13_hv_pmos_RQMCRC_0/S7
+ vss sg13_hv_pmos_RQMCRC_0/S7 sg13_hv_pmos_RQMCRC_0/S9 sg13_hv_pmos_RQMCRC_0/S7 vss
+ sg13_hv_pmos_RQMCRC_0/S7 sg13_hv_pmos_RQMCRC_0/S9 sg13_hv_pmos_RQMCRC_0/S7 vss sg13_hv_pmos_RQMCRC_0/S7
+ sg13_hv_pmos_RQMCRC_0/S9 sg13_hv_pmos_RQMCRC_0/S7 vss sg13_hv_pmos_RQMCRC_0/S9 out
+ sg13_hv_pmos_RQMCRC_0/S9 vss sg13_hv_pmos_RQMCRC_0/S9 out sg13_hv_pmos_RQMCRC_0/S9
+ vss sg13_hv_pmos_RQMCRC_0/S9 out sg13_hv_pmos_RQMCRC_0/S9 vss sg13_hv_pmos_RQMCRC_0/S9
+ out sg13_hv_pmos_RQMCRC_0/S9 vss sg13_hv_pmos_RQMCRC_0/S9 out sg13_hv_pmos_RQMCRC_0/S9
+ vss sg13_hv_pmos_RQMCRC_0/S9 out sg13_hv_pmos_RQMCRC_0/S9 vss sg13_hv_pmos_RQMCRC_0/S9
+ out sg13_hv_pmos_RQMCRC_0/S9 vss sg13_hv_pmos_RQMCRC_0/S9 out sg13_hv_pmos_RQMCRC_0/S9
+ vss sg13_hv_pmos_RQMCRC_0/S9 out sg13_hv_pmos_RQMCRC_0/S9 vss sg13_hv_pmos_RQMCRC_0/S9
+ out sg13_hv_pmos_RQMCRC_0/S9 vss sg13_hv_pmos_RQMCRC_0/S9 out sg13_hv_pmos_RQMCRC_0/S9
+ vss sg13_hv_pmos_RQMCRC_0/S9 out sg13_hv_pmos_RQMCRC_0/S9 vss sg13_hv_pmos_RQMCRC_0/S9
+ out sg13_hv_pmos_RQMCRC_0/S9 vss sg13_hv_pmos_RQMCRC_0/S9 out sg13_hv_pmos_RQMCRC_0/S9
+ vss sg13_hv_pmos_RQMCRC_0/S9 out sg13_hv_pmos_RQMCRC_0/S9 vss sg13_hv_pmos_RQMCRC_0/S9
+ out sg13_hv_pmos_RQMCRC_0/S9 vss sg13_hv_pmos_RQMCRC_0/S9 out sg13_hv_pmos_RQMCRC_0/S9
+ vss sg13_hv_pmos_RQMCRC_0/S9 out sg13_hv_pmos_RQMCRC_0/S9 vss sg13_hv_pmos_RQMCRC_0/S9
+ out sg13_hv_pmos_RQMCRC_0/S9 vss sg13_hv_pmos_RQMCRC_0/S9 out sg13_hv_pmos_RQMCRC_0/S9
+ vss sg13_hv_pmos_RQMCRC_0/S9 out sg13_hv_pmos_RQMCRC_0/S9 vss sg13_hv_pmos_RQMCRC_0/S9
+ out sg13_hv_pmos_RQMCRC_0/S9 vss sg13_hv_pmos_RQMCRC_0/S9 out sg13_hv_pmos_RQMCRC_0/S9
+ vss sg13_hv_pmos_RQMCRC_0/S9 out sg13_hv_pmos_RQMCRC_0/S9 vss sg13_hv_pmos_RQMCRC_0/S9
+ out sg13_hv_pmos_RQMCRC_0/S9 vss sg13_hv_pmos_RQMCRC_0/S9 out sg13_hv_pmos_RQMCRC_0/S9
+ vss sg13_hv_pmos_RQMCRC_0/S9 out sg13_hv_pmos_RQMCRC_0/S9 vss sg13_hv_pmos_RQMCRC_0/S9
+ out sg13_hv_pmos_RQMCRC_0/S9 vss sg13_hv_pmos_RQMCRC_0/S9 out sg13_hv_pmos_RQMCRC_0/S9
+ vss sg13_hv_pmos_RQMCRC_0/S9 out sg13_hv_pmos_RQMCRC_0/S9 vss vss sg13_hv_nmos_3JX36Y
Xsg13_hv_pmos_RQMCRC_0 vdd sg13_hv_pmos_RQMCRC_0/G1 sg13_hv_pmos_RQMCRC_0/S1 sg13_hv_pmos_RQMCRC_0/G1
+ vdd sg13_hv_pmos_RQMCRC_0/S1 sg13_hv_pmos_RQMCRC_0/S7 sg13_hv_pmos_RQMCRC_0/S1 vdd
+ sg13_hv_pmos_RQMCRC_0/S1 sg13_hv_pmos_RQMCRC_0/S7 sg13_hv_pmos_RQMCRC_0/S1 vdd sg13_hv_pmos_RQMCRC_0/S1
+ sg13_hv_pmos_RQMCRC_0/S7 sg13_hv_pmos_RQMCRC_0/S1 vdd sg13_hv_pmos_RQMCRC_0/S7 sg13_hv_pmos_RQMCRC_0/S9
+ sg13_hv_pmos_RQMCRC_0/S7 vdd sg13_hv_pmos_RQMCRC_0/S7 sg13_hv_pmos_RQMCRC_0/S9 sg13_hv_pmos_RQMCRC_0/S7
+ vdd sg13_hv_pmos_RQMCRC_0/S7 sg13_hv_pmos_RQMCRC_0/S9 sg13_hv_pmos_RQMCRC_0/S7 vdd
+ sg13_hv_pmos_RQMCRC_0/S7 sg13_hv_pmos_RQMCRC_0/S9 sg13_hv_pmos_RQMCRC_0/S7 vdd sg13_hv_pmos_RQMCRC_0/S7
+ sg13_hv_pmos_RQMCRC_0/S9 sg13_hv_pmos_RQMCRC_0/S7 vdd sg13_hv_pmos_RQMCRC_0/S7 sg13_hv_pmos_RQMCRC_0/S9
+ sg13_hv_pmos_RQMCRC_0/S7 vdd sg13_hv_pmos_RQMCRC_0/S7 sg13_hv_pmos_RQMCRC_0/S9 sg13_hv_pmos_RQMCRC_0/S7
+ vdd sg13_hv_pmos_RQMCRC_0/S7 sg13_hv_pmos_RQMCRC_0/S9 sg13_hv_pmos_RQMCRC_0/S7 vdd
+ sg13_hv_pmos_RQMCRC_0/S7 sg13_hv_pmos_RQMCRC_0/S9 sg13_hv_pmos_RQMCRC_0/S7 vdd sg13_hv_pmos_RQMCRC_0/S7
+ sg13_hv_pmos_RQMCRC_0/S9 sg13_hv_pmos_RQMCRC_0/S7 vdd sg13_hv_pmos_RQMCRC_0/S9 out
+ sg13_hv_pmos_RQMCRC_0/S9 vdd sg13_hv_pmos_RQMCRC_0/S9 out sg13_hv_pmos_RQMCRC_0/S9
+ vdd sg13_hv_pmos_RQMCRC_0/S9 out sg13_hv_pmos_RQMCRC_0/S9 vdd sg13_hv_pmos_RQMCRC_0/S9
+ out sg13_hv_pmos_RQMCRC_0/S9 vdd sg13_hv_pmos_RQMCRC_0/S9 out sg13_hv_pmos_RQMCRC_0/S9
+ vdd sg13_hv_pmos_RQMCRC_0/S9 out sg13_hv_pmos_RQMCRC_0/S9 vdd sg13_hv_pmos_RQMCRC_0/S9
+ out sg13_hv_pmos_RQMCRC_0/S9 vdd sg13_hv_pmos_RQMCRC_0/S9 out sg13_hv_pmos_RQMCRC_0/S9
+ vdd sg13_hv_pmos_RQMCRC_0/S9 out sg13_hv_pmos_RQMCRC_0/S9 vdd sg13_hv_pmos_RQMCRC_0/S9
+ out sg13_hv_pmos_RQMCRC_0/S9 vdd sg13_hv_pmos_RQMCRC_0/S9 out sg13_hv_pmos_RQMCRC_0/S9
+ vdd sg13_hv_pmos_RQMCRC_0/S9 out sg13_hv_pmos_RQMCRC_0/S9 vdd sg13_hv_pmos_RQMCRC_0/S9
+ out sg13_hv_pmos_RQMCRC_0/S9 vdd sg13_hv_pmos_RQMCRC_0/S9 out sg13_hv_pmos_RQMCRC_0/S9
+ vdd sg13_hv_pmos_RQMCRC_0/S9 out sg13_hv_pmos_RQMCRC_0/S9 vdd sg13_hv_pmos_RQMCRC_0/S9
+ out sg13_hv_pmos_RQMCRC_0/S9 vdd sg13_hv_pmos_RQMCRC_0/S9 out sg13_hv_pmos_RQMCRC_0/S9
+ vdd sg13_hv_pmos_RQMCRC_0/S9 out sg13_hv_pmos_RQMCRC_0/S9 vdd sg13_hv_pmos_RQMCRC_0/S9
+ out sg13_hv_pmos_RQMCRC_0/S9 vdd sg13_hv_pmos_RQMCRC_0/S9 out sg13_hv_pmos_RQMCRC_0/S9
+ vdd sg13_hv_pmos_RQMCRC_0/S9 out sg13_hv_pmos_RQMCRC_0/S9 vdd sg13_hv_pmos_RQMCRC_0/S9
+ out sg13_hv_pmos_RQMCRC_0/S9 vdd sg13_hv_pmos_RQMCRC_0/S9 out sg13_hv_pmos_RQMCRC_0/S9
+ vdd sg13_hv_pmos_RQMCRC_0/S9 out sg13_hv_pmos_RQMCRC_0/S9 vdd sg13_hv_pmos_RQMCRC_0/S9
+ out sg13_hv_pmos_RQMCRC_0/S9 vdd sg13_hv_pmos_RQMCRC_0/S9 out sg13_hv_pmos_RQMCRC_0/S9
+ vdd sg13_hv_pmos_RQMCRC_0/S9 out sg13_hv_pmos_RQMCRC_0/S9 vdd sg13_hv_pmos_RQMCRC_0/S9
+ out sg13_hv_pmos_RQMCRC_0/S9 vdd sg13_hv_pmos_RQMCRC_0/S9 out sg13_hv_pmos_RQMCRC_0/S9
+ vdd sg13_hv_pmos_RQMCRC_0/S9 out sg13_hv_pmos_RQMCRC_0/S9 vdd vdd sg13_hv_pmos_RQMCRC
Xsg13_hv_pmos_FG6ZZW_0 vdd sg13_hv_pmos_RQMCRC_0/G1 sg13_hv_pmos_FG6ZZW_0/S1 sg13_hv_pmos_RQMCRC_0/G1
+ vdd sg13_hv_pmos_FG6ZZW_0/S1 sg13_hv_pmos_RQMCRC_0/G1 sg13_hv_pmos_FG6ZZW_0/S1 vdd
+ vdd sg13_hv_pmos_FG6ZZW
.ends

.subckt power_stage2 IOVDD_IN enable IOVSS IOVDD_OUT DVSS DVDD
Xsg13_hv_pmos_ZN7EJW_2 IOVDD_IN IOVDD_IN gate_drive_large_0/out IOVDD_IN IOVDD_IN
+ IOVDD_IN IOVDD_IN IOVDD_IN IOVDD_IN IOVDD_IN IOVDD_IN IOVDD_IN IOVDD_OUT IOVDD_OUT
+ IOVDD_OUT IOVDD_OUT IOVDD_OUT IOVDD_OUT IOVDD_OUT IOVDD_OUT IOVDD_OUT IOVDD_OUT
+ IOVDD_IN IOVDD_IN IOVDD_IN IOVDD_IN IOVDD_IN IOVDD_IN IOVDD_IN IOVDD_IN IOVDD_IN
+ IOVDD_IN IOVDD_OUT IOVDD_OUT IOVDD_OUT IOVDD_OUT IOVDD_OUT IOVDD_OUT IOVDD_OUT IOVDD_OUT
+ IOVDD_OUT IOVDD_OUT IOVDD_IN IOVDD_IN IOVDD_IN IOVDD_IN IOVDD_IN IOVDD_IN IOVDD_IN
+ IOVDD_IN IOVDD_IN IOVDD_IN IOVDD_OUT IOVDD_OUT IOVDD_OUT IOVDD_OUT IOVDD_OUT IOVDD_OUT
+ IOVDD_OUT IOVDD_OUT IOVDD_OUT IOVDD_OUT IOVDD_IN IOVDD_IN IOVDD_IN IOVDD_IN IOVDD_IN
+ IOVDD_IN IOVDD_IN IOVDD_IN IOVDD_IN IOVDD_IN IOVDD_OUT IOVDD_OUT IOVDD_OUT IOVDD_OUT
+ IOVDD_OUT IOVDD_OUT IOVDD_OUT IOVDD_OUT IOVDD_OUT IOVDD_OUT IOVDD_IN IOVDD_IN IOVDD_IN
+ IOVDD_IN IOVDD_IN IOVDD_IN IOVDD_IN IOVDD_IN IOVDD_IN IOVDD_IN IOVDD_OUT IOVDD_OUT
+ IOVDD_OUT IOVDD_OUT IOVDD_OUT IOVDD_OUT IOVDD_OUT IOVDD_OUT IOVDD_OUT IOVDD_OUT
+ IOVDD_IN IOVDD_IN IOVDD_IN IOVDD_IN IOVDD_IN IOVDD_IN IOVDD_IN IOVDD_IN IOVDD_IN
+ IOVDD_IN sg13_hv_pmos_ZN7EJW
Xsg13_hv_pmos_ZN7EJW_3 IOVDD_IN IOVDD_IN gate_drive_large_0/out IOVDD_IN IOVDD_IN
+ IOVDD_IN IOVDD_IN IOVDD_IN IOVDD_IN IOVDD_IN IOVDD_IN IOVDD_IN IOVDD_OUT IOVDD_OUT
+ IOVDD_OUT IOVDD_OUT IOVDD_OUT IOVDD_OUT IOVDD_OUT IOVDD_OUT IOVDD_OUT IOVDD_OUT
+ IOVDD_IN IOVDD_IN IOVDD_IN IOVDD_IN IOVDD_IN IOVDD_IN IOVDD_IN IOVDD_IN IOVDD_IN
+ IOVDD_IN IOVDD_OUT IOVDD_OUT IOVDD_OUT IOVDD_OUT IOVDD_OUT IOVDD_OUT IOVDD_OUT IOVDD_OUT
+ IOVDD_OUT IOVDD_OUT IOVDD_IN IOVDD_IN IOVDD_IN IOVDD_IN IOVDD_IN IOVDD_IN IOVDD_IN
+ IOVDD_IN IOVDD_IN IOVDD_IN IOVDD_OUT IOVDD_OUT IOVDD_OUT IOVDD_OUT IOVDD_OUT IOVDD_OUT
+ IOVDD_OUT IOVDD_OUT IOVDD_OUT IOVDD_OUT IOVDD_IN IOVDD_IN IOVDD_IN IOVDD_IN IOVDD_IN
+ IOVDD_IN IOVDD_IN IOVDD_IN IOVDD_IN IOVDD_IN IOVDD_OUT IOVDD_OUT IOVDD_OUT IOVDD_OUT
+ IOVDD_OUT IOVDD_OUT IOVDD_OUT IOVDD_OUT IOVDD_OUT IOVDD_OUT IOVDD_IN IOVDD_IN IOVDD_IN
+ IOVDD_IN IOVDD_IN IOVDD_IN IOVDD_IN IOVDD_IN IOVDD_IN IOVDD_IN IOVDD_OUT IOVDD_OUT
+ IOVDD_OUT IOVDD_OUT IOVDD_OUT IOVDD_OUT IOVDD_OUT IOVDD_OUT IOVDD_OUT IOVDD_OUT
+ IOVDD_IN IOVDD_IN IOVDD_IN IOVDD_IN IOVDD_IN IOVDD_IN IOVDD_IN IOVDD_IN IOVDD_IN
+ IOVDD_IN sg13_hv_pmos_ZN7EJW
Xsg13_hv_pmos_ZN7EJW_4 IOVDD_IN IOVDD_IN gate_drive_large_0/out IOVDD_IN IOVDD_IN
+ IOVDD_IN IOVDD_IN IOVDD_IN IOVDD_IN IOVDD_IN IOVDD_IN IOVDD_IN IOVDD_OUT IOVDD_OUT
+ IOVDD_OUT IOVDD_OUT IOVDD_OUT IOVDD_OUT IOVDD_OUT IOVDD_OUT IOVDD_OUT IOVDD_OUT
+ IOVDD_IN IOVDD_IN IOVDD_IN IOVDD_IN IOVDD_IN IOVDD_IN IOVDD_IN IOVDD_IN IOVDD_IN
+ IOVDD_IN IOVDD_OUT IOVDD_OUT IOVDD_OUT IOVDD_OUT IOVDD_OUT IOVDD_OUT IOVDD_OUT IOVDD_OUT
+ IOVDD_OUT IOVDD_OUT IOVDD_IN IOVDD_IN IOVDD_IN IOVDD_IN IOVDD_IN IOVDD_IN IOVDD_IN
+ IOVDD_IN IOVDD_IN IOVDD_IN IOVDD_OUT IOVDD_OUT IOVDD_OUT IOVDD_OUT IOVDD_OUT IOVDD_OUT
+ IOVDD_OUT IOVDD_OUT IOVDD_OUT IOVDD_OUT IOVDD_IN IOVDD_IN IOVDD_IN IOVDD_IN IOVDD_IN
+ IOVDD_IN IOVDD_IN IOVDD_IN IOVDD_IN IOVDD_IN IOVDD_OUT IOVDD_OUT IOVDD_OUT IOVDD_OUT
+ IOVDD_OUT IOVDD_OUT IOVDD_OUT IOVDD_OUT IOVDD_OUT IOVDD_OUT IOVDD_IN IOVDD_IN IOVDD_IN
+ IOVDD_IN IOVDD_IN IOVDD_IN IOVDD_IN IOVDD_IN IOVDD_IN IOVDD_IN IOVDD_OUT IOVDD_OUT
+ IOVDD_OUT IOVDD_OUT IOVDD_OUT IOVDD_OUT IOVDD_OUT IOVDD_OUT IOVDD_OUT IOVDD_OUT
+ IOVDD_IN IOVDD_IN IOVDD_IN IOVDD_IN IOVDD_IN IOVDD_IN IOVDD_IN IOVDD_IN IOVDD_IN
+ IOVDD_IN sg13_hv_pmos_ZN7EJW
Xsg13_hv_pmos_ZN7EJW_5 IOVDD_IN IOVDD_IN gate_drive_large_0/out IOVDD_IN IOVDD_IN
+ IOVDD_IN IOVDD_IN IOVDD_IN IOVDD_IN IOVDD_IN IOVDD_IN IOVDD_IN IOVDD_OUT IOVDD_OUT
+ IOVDD_OUT IOVDD_OUT IOVDD_OUT IOVDD_OUT IOVDD_OUT IOVDD_OUT IOVDD_OUT IOVDD_OUT
+ IOVDD_IN IOVDD_IN IOVDD_IN IOVDD_IN IOVDD_IN IOVDD_IN IOVDD_IN IOVDD_IN IOVDD_IN
+ IOVDD_IN IOVDD_OUT IOVDD_OUT IOVDD_OUT IOVDD_OUT IOVDD_OUT IOVDD_OUT IOVDD_OUT IOVDD_OUT
+ IOVDD_OUT IOVDD_OUT IOVDD_IN IOVDD_IN IOVDD_IN IOVDD_IN IOVDD_IN IOVDD_IN IOVDD_IN
+ IOVDD_IN IOVDD_IN IOVDD_IN IOVDD_OUT IOVDD_OUT IOVDD_OUT IOVDD_OUT IOVDD_OUT IOVDD_OUT
+ IOVDD_OUT IOVDD_OUT IOVDD_OUT IOVDD_OUT IOVDD_IN IOVDD_IN IOVDD_IN IOVDD_IN IOVDD_IN
+ IOVDD_IN IOVDD_IN IOVDD_IN IOVDD_IN IOVDD_IN IOVDD_OUT IOVDD_OUT IOVDD_OUT IOVDD_OUT
+ IOVDD_OUT IOVDD_OUT IOVDD_OUT IOVDD_OUT IOVDD_OUT IOVDD_OUT IOVDD_IN IOVDD_IN IOVDD_IN
+ IOVDD_IN IOVDD_IN IOVDD_IN IOVDD_IN IOVDD_IN IOVDD_IN IOVDD_IN IOVDD_OUT IOVDD_OUT
+ IOVDD_OUT IOVDD_OUT IOVDD_OUT IOVDD_OUT IOVDD_OUT IOVDD_OUT IOVDD_OUT IOVDD_OUT
+ IOVDD_IN IOVDD_IN IOVDD_IN IOVDD_IN IOVDD_IN IOVDD_IN IOVDD_IN IOVDD_IN IOVDD_IN
+ IOVDD_IN sg13_hv_pmos_ZN7EJW
Xsg13_hv_pmos_ZN7EJW_6 IOVDD_IN IOVDD_IN gate_drive_large_0/out IOVDD_IN IOVDD_IN
+ IOVDD_IN IOVDD_IN IOVDD_IN IOVDD_IN IOVDD_IN IOVDD_IN IOVDD_IN IOVDD_OUT IOVDD_OUT
+ IOVDD_OUT IOVDD_OUT IOVDD_OUT IOVDD_OUT IOVDD_OUT IOVDD_OUT IOVDD_OUT IOVDD_OUT
+ IOVDD_IN IOVDD_IN IOVDD_IN IOVDD_IN IOVDD_IN IOVDD_IN IOVDD_IN IOVDD_IN IOVDD_IN
+ IOVDD_IN IOVDD_OUT IOVDD_OUT IOVDD_OUT IOVDD_OUT IOVDD_OUT IOVDD_OUT IOVDD_OUT IOVDD_OUT
+ IOVDD_OUT IOVDD_OUT IOVDD_IN IOVDD_IN IOVDD_IN IOVDD_IN IOVDD_IN IOVDD_IN IOVDD_IN
+ IOVDD_IN IOVDD_IN IOVDD_IN IOVDD_OUT IOVDD_OUT IOVDD_OUT IOVDD_OUT IOVDD_OUT IOVDD_OUT
+ IOVDD_OUT IOVDD_OUT IOVDD_OUT IOVDD_OUT IOVDD_IN IOVDD_IN IOVDD_IN IOVDD_IN IOVDD_IN
+ IOVDD_IN IOVDD_IN IOVDD_IN IOVDD_IN IOVDD_IN IOVDD_OUT IOVDD_OUT IOVDD_OUT IOVDD_OUT
+ IOVDD_OUT IOVDD_OUT IOVDD_OUT IOVDD_OUT IOVDD_OUT IOVDD_OUT IOVDD_IN IOVDD_IN IOVDD_IN
+ IOVDD_IN IOVDD_IN IOVDD_IN IOVDD_IN IOVDD_IN IOVDD_IN IOVDD_IN IOVDD_OUT IOVDD_OUT
+ IOVDD_OUT IOVDD_OUT IOVDD_OUT IOVDD_OUT IOVDD_OUT IOVDD_OUT IOVDD_OUT IOVDD_OUT
+ IOVDD_IN IOVDD_IN IOVDD_IN IOVDD_IN IOVDD_IN IOVDD_IN IOVDD_IN IOVDD_IN IOVDD_IN
+ IOVDD_IN sg13_hv_pmos_ZN7EJW
Xsg13cmos5l_antennanp_0 enable DVDD DVSS sg13cmos5l_antennanp
Xsg13cmos5l_decap_4_0 DVDD DVSS sg13cmos5l_decap_4
Xsg13cmos5l_decap_4_1 DVDD DVSS sg13cmos5l_decap_4
Xgate_drive_large_0 sg13cmos5l_inv_4_1/A sg13cmos5l_inv_4_1/Y gate_drive_large_0/out
+ IOVSS IOVDD_IN gate_drive_large
Xsg13cmos5l_inv_4_0 sg13cmos5l_inv_4_1/A enable DVDD DVSS sg13cmos5l_inv_4
Xsg13_hv_pmos_ZN7EJW_0 IOVDD_IN IOVDD_IN gate_drive_large_0/out IOVDD_IN IOVDD_IN
+ IOVDD_IN IOVDD_IN IOVDD_IN IOVDD_IN IOVDD_IN IOVDD_IN IOVDD_IN IOVDD_OUT IOVDD_OUT
+ IOVDD_OUT IOVDD_OUT IOVDD_OUT IOVDD_OUT IOVDD_OUT IOVDD_OUT IOVDD_OUT IOVDD_OUT
+ IOVDD_IN IOVDD_IN IOVDD_IN IOVDD_IN IOVDD_IN IOVDD_IN IOVDD_IN IOVDD_IN IOVDD_IN
+ IOVDD_IN IOVDD_OUT IOVDD_OUT IOVDD_OUT IOVDD_OUT IOVDD_OUT IOVDD_OUT IOVDD_OUT IOVDD_OUT
+ IOVDD_OUT IOVDD_OUT IOVDD_IN IOVDD_IN IOVDD_IN IOVDD_IN IOVDD_IN IOVDD_IN IOVDD_IN
+ IOVDD_IN IOVDD_IN IOVDD_IN IOVDD_OUT IOVDD_OUT IOVDD_OUT IOVDD_OUT IOVDD_OUT IOVDD_OUT
+ IOVDD_OUT IOVDD_OUT IOVDD_OUT IOVDD_OUT IOVDD_IN IOVDD_IN IOVDD_IN IOVDD_IN IOVDD_IN
+ IOVDD_IN IOVDD_IN IOVDD_IN IOVDD_IN IOVDD_IN IOVDD_OUT IOVDD_OUT IOVDD_OUT IOVDD_OUT
+ IOVDD_OUT IOVDD_OUT IOVDD_OUT IOVDD_OUT IOVDD_OUT IOVDD_OUT IOVDD_IN IOVDD_IN IOVDD_IN
+ IOVDD_IN IOVDD_IN IOVDD_IN IOVDD_IN IOVDD_IN IOVDD_IN IOVDD_IN IOVDD_OUT IOVDD_OUT
+ IOVDD_OUT IOVDD_OUT IOVDD_OUT IOVDD_OUT IOVDD_OUT IOVDD_OUT IOVDD_OUT IOVDD_OUT
+ IOVDD_IN IOVDD_IN IOVDD_IN IOVDD_IN IOVDD_IN IOVDD_IN IOVDD_IN IOVDD_IN IOVDD_IN
+ IOVDD_IN sg13_hv_pmos_ZN7EJW
Xsg13cmos5l_inv_4_1 sg13cmos5l_inv_4_1/Y sg13cmos5l_inv_4_1/A DVDD DVSS sg13cmos5l_inv_4
Xsg13_hv_pmos_ZN7EJW_1 IOVDD_IN IOVDD_IN gate_drive_large_0/out IOVDD_IN IOVDD_IN
+ IOVDD_IN IOVDD_IN IOVDD_IN IOVDD_IN IOVDD_IN IOVDD_IN IOVDD_IN IOVDD_OUT IOVDD_OUT
+ IOVDD_OUT IOVDD_OUT IOVDD_OUT IOVDD_OUT IOVDD_OUT IOVDD_OUT IOVDD_OUT IOVDD_OUT
+ IOVDD_IN IOVDD_IN IOVDD_IN IOVDD_IN IOVDD_IN IOVDD_IN IOVDD_IN IOVDD_IN IOVDD_IN
+ IOVDD_IN IOVDD_OUT IOVDD_OUT IOVDD_OUT IOVDD_OUT IOVDD_OUT IOVDD_OUT IOVDD_OUT IOVDD_OUT
+ IOVDD_OUT IOVDD_OUT IOVDD_IN IOVDD_IN IOVDD_IN IOVDD_IN IOVDD_IN IOVDD_IN IOVDD_IN
+ IOVDD_IN IOVDD_IN IOVDD_IN IOVDD_OUT IOVDD_OUT IOVDD_OUT IOVDD_OUT IOVDD_OUT IOVDD_OUT
+ IOVDD_OUT IOVDD_OUT IOVDD_OUT IOVDD_OUT IOVDD_IN IOVDD_IN IOVDD_IN IOVDD_IN IOVDD_IN
+ IOVDD_IN IOVDD_IN IOVDD_IN IOVDD_IN IOVDD_IN IOVDD_OUT IOVDD_OUT IOVDD_OUT IOVDD_OUT
+ IOVDD_OUT IOVDD_OUT IOVDD_OUT IOVDD_OUT IOVDD_OUT IOVDD_OUT IOVDD_IN IOVDD_IN IOVDD_IN
+ IOVDD_IN IOVDD_IN IOVDD_IN IOVDD_IN IOVDD_IN IOVDD_IN IOVDD_IN IOVDD_OUT IOVDD_OUT
+ IOVDD_OUT IOVDD_OUT IOVDD_OUT IOVDD_OUT IOVDD_OUT IOVDD_OUT IOVDD_OUT IOVDD_OUT
+ IOVDD_IN IOVDD_IN IOVDD_IN IOVDD_IN IOVDD_IN IOVDD_IN IOVDD_IN IOVDD_IN IOVDD_IN
+ IOVDD_IN sg13_hv_pmos_ZN7EJW
.ends

.subckt sg13_lv_pmos_5MXUJM B D0_0 G D0_1 D0_2 D0_3 D0_4 D0_5 D0_6 D0_7 D0_8 D0_9
+ S1_0 S1_1 S1_2 S1_3 S1_4 S1_5 S1_6 S1_7 S1_8 S1_9 D2_0 D2_1 D2_2 D2_3 D2_4 D2_5
+ D2_6 D2_7 D2_8 D2_9 S3_0 S3_1 S3_2 S3_3 S3_4 S3_5 S3_6 S3_7 S3_8 S3_9 D4_0 D4_1
+ D4_2 D4_3 D4_4 D4_5 D4_6 D4_7 D4_8 D4_9 S5_0 S5_1 S5_2 S5_3 S5_4 S5_5 S5_6 S5_7
+ S5_8 S5_9 D6_0 D6_1 D6_2 D6_3 D6_4 D6_5 D6_6 D6_7 D6_8 D6_9 S7_0 S7_1 S7_2 S7_3
+ S7_4 S7_5 S7_6 S7_7 S7_8 S7_9 D8_0 D8_1 D8_2 D8_3 D8_4 D8_5 D8_6 D8_7 D8_8 D8_9
+ S9_0 S9_1 S9_2 S9_3 S9_4 S9_5 S9_6 S9_7 S9_8 S9_9 a_778_n3220# a_778_n4308# a_778_1132#
+ a_778_n5396# a_778_n1044# a_778_44# a_778_2220# a_778_3308# a_778_n2132# a_778_4396#
X0 D8_4 G S7_4 B sg13_lv_pmos ad=1.8p pd=5.72u as=1.8p ps=5.72u w=5u l=0.13u
X1 S7_1 G D6_1 B sg13_lv_pmos ad=1.8p pd=5.72u as=1.8p ps=5.72u w=5u l=0.13u
X2 S3_4 G D2_4 B sg13_lv_pmos ad=1.8p pd=5.72u as=1.8p ps=5.72u w=5u l=0.13u
X3 D4_1 G S3_1 B sg13_lv_pmos ad=1.8p pd=5.72u as=1.8p ps=5.72u w=5u l=0.13u
X4 a_778_n3220# G S9_2 B sg13_lv_pmos ad=3.4p pd=11.36u as=1.8p ps=5.72u w=5u l=0.13u
X5 S1_2 G D0_2 B sg13_lv_pmos ad=1.8p pd=5.72u as=3.4p ps=11.36u w=5u l=0.13u
X6 a_778_n2132# G S9_3 B sg13_lv_pmos ad=3.4p pd=11.36u as=1.8p ps=5.72u w=5u l=0.13u
X7 S1_3 G D0_3 B sg13_lv_pmos ad=1.8p pd=5.72u as=3.4p ps=11.36u w=5u l=0.13u
X8 D8_9 G S7_9 B sg13_lv_pmos ad=1.8p pd=5.72u as=1.8p ps=5.72u w=5u l=0.13u
X9 S3_9 G D2_9 B sg13_lv_pmos ad=1.8p pd=5.72u as=1.8p ps=5.72u w=5u l=0.13u
X10 S5_9 G D4_9 B sg13_lv_pmos ad=1.8p pd=5.72u as=1.8p ps=5.72u w=5u l=0.13u
X11 D8_0 G S7_0 B sg13_lv_pmos ad=1.8p pd=5.72u as=1.8p ps=5.72u w=5u l=0.13u
X12 S3_0 G D2_0 B sg13_lv_pmos ad=1.8p pd=5.72u as=1.8p ps=5.72u w=5u l=0.13u
X13 D6_6 G S5_6 B sg13_lv_pmos ad=1.8p pd=5.72u as=1.8p ps=5.72u w=5u l=0.13u
X14 D2_1 G S1_1 B sg13_lv_pmos ad=1.8p pd=5.72u as=1.8p ps=5.72u w=5u l=0.13u
X15 S7_8 G D6_8 B sg13_lv_pmos ad=1.8p pd=5.72u as=1.8p ps=5.72u w=5u l=0.13u
X16 a_778_4396# G S9_9 B sg13_lv_pmos ad=3.4p pd=11.36u as=1.8p ps=5.72u w=5u l=0.13u
X17 S7_7 G D6_7 B sg13_lv_pmos ad=1.8p pd=5.72u as=1.8p ps=5.72u w=5u l=0.13u
X18 D4_8 G S3_8 B sg13_lv_pmos ad=1.8p pd=5.72u as=1.8p ps=5.72u w=5u l=0.13u
X19 S1_9 G D0_9 B sg13_lv_pmos ad=1.8p pd=5.72u as=3.4p ps=11.36u w=5u l=0.13u
X20 D4_7 G S3_7 B sg13_lv_pmos ad=1.8p pd=5.72u as=1.8p ps=5.72u w=5u l=0.13u
X21 D6_5 G S5_5 B sg13_lv_pmos ad=1.8p pd=5.72u as=1.8p ps=5.72u w=5u l=0.13u
X22 S9_8 G D8_8 B sg13_lv_pmos ad=1.8p pd=5.72u as=1.8p ps=5.72u w=5u l=0.13u
X23 S5_4 G D4_4 B sg13_lv_pmos ad=1.8p pd=5.72u as=1.8p ps=5.72u w=5u l=0.13u
X24 S9_7 G D8_7 B sg13_lv_pmos ad=1.8p pd=5.72u as=1.8p ps=5.72u w=5u l=0.13u
X25 S9_4 G D8_4 B sg13_lv_pmos ad=1.8p pd=5.72u as=1.8p ps=5.72u w=5u l=0.13u
X26 D8_6 G S7_6 B sg13_lv_pmos ad=1.8p pd=5.72u as=1.8p ps=5.72u w=5u l=0.13u
X27 S5_0 G D4_0 B sg13_lv_pmos ad=1.8p pd=5.72u as=1.8p ps=5.72u w=5u l=0.13u
X28 D8_2 G S7_2 B sg13_lv_pmos ad=1.8p pd=5.72u as=1.8p ps=5.72u w=5u l=0.13u
X29 D6_4 G S5_4 B sg13_lv_pmos ad=1.8p pd=5.72u as=1.8p ps=5.72u w=5u l=0.13u
X30 S3_2 G D2_2 B sg13_lv_pmos ad=1.8p pd=5.72u as=1.8p ps=5.72u w=5u l=0.13u
X31 S5_6 G D4_6 B sg13_lv_pmos ad=1.8p pd=5.72u as=1.8p ps=5.72u w=5u l=0.13u
X32 S3_6 G D2_6 B sg13_lv_pmos ad=1.8p pd=5.72u as=1.8p ps=5.72u w=5u l=0.13u
X33 S9_0 G D8_0 B sg13_lv_pmos ad=1.8p pd=5.72u as=1.8p ps=5.72u w=5u l=0.13u
X34 D8_3 G S7_3 B sg13_lv_pmos ad=1.8p pd=5.72u as=1.8p ps=5.72u w=5u l=0.13u
X35 S3_3 G D2_3 B sg13_lv_pmos ad=1.8p pd=5.72u as=1.8p ps=5.72u w=5u l=0.13u
X36 a_778_n4308# G S9_1 B sg13_lv_pmos ad=3.4p pd=11.36u as=1.8p ps=5.72u w=5u l=0.13u
X37 S1_1 G D0_1 B sg13_lv_pmos ad=1.8p pd=5.72u as=3.4p ps=11.36u w=5u l=0.13u
X38 a_778_1132# G S9_6 B sg13_lv_pmos ad=3.4p pd=11.36u as=1.8p ps=5.72u w=5u l=0.13u
X39 D6_0 G S5_0 B sg13_lv_pmos ad=1.8p pd=5.72u as=1.8p ps=5.72u w=5u l=0.13u
X40 S1_6 G D0_6 B sg13_lv_pmos ad=1.8p pd=5.72u as=3.4p ps=11.36u w=5u l=0.13u
X41 D6_8 G S5_8 B sg13_lv_pmos ad=1.8p pd=5.72u as=1.8p ps=5.72u w=5u l=0.13u
X42 D6_7 G S5_7 B sg13_lv_pmos ad=1.8p pd=5.72u as=1.8p ps=5.72u w=5u l=0.13u
X43 S7_4 G D6_4 B sg13_lv_pmos ad=1.8p pd=5.72u as=1.8p ps=5.72u w=5u l=0.13u
X44 D4_4 G S3_4 B sg13_lv_pmos ad=1.8p pd=5.72u as=1.8p ps=5.72u w=5u l=0.13u
X45 S1_5 G D0_5 B sg13_lv_pmos ad=1.8p pd=5.72u as=3.4p ps=11.36u w=5u l=0.13u
X46 S5_2 G D4_2 B sg13_lv_pmos ad=1.8p pd=5.72u as=1.8p ps=5.72u w=5u l=0.13u
X47 D2_5 G S1_5 B sg13_lv_pmos ad=1.8p pd=5.72u as=1.8p ps=5.72u w=5u l=0.13u
X48 S9_2 G D8_2 B sg13_lv_pmos ad=1.8p pd=5.72u as=1.8p ps=5.72u w=5u l=0.13u
X49 D2_9 G S1_9 B sg13_lv_pmos ad=1.8p pd=5.72u as=1.8p ps=5.72u w=5u l=0.13u
X50 S5_3 G D4_3 B sg13_lv_pmos ad=1.8p pd=5.72u as=1.8p ps=5.72u w=5u l=0.13u
X51 S9_3 G D8_3 B sg13_lv_pmos ad=1.8p pd=5.72u as=1.8p ps=5.72u w=5u l=0.13u
X52 S3_5 G D2_5 B sg13_lv_pmos ad=1.8p pd=5.72u as=1.8p ps=5.72u w=5u l=0.13u
X53 D8_8 G S7_8 B sg13_lv_pmos ad=1.8p pd=5.72u as=1.8p ps=5.72u w=5u l=0.13u
X54 S7_0 G D6_0 B sg13_lv_pmos ad=1.8p pd=5.72u as=1.8p ps=5.72u w=5u l=0.13u
X55 D8_7 G S7_7 B sg13_lv_pmos ad=1.8p pd=5.72u as=1.8p ps=5.72u w=5u l=0.13u
X56 D4_0 G S3_0 B sg13_lv_pmos ad=1.8p pd=5.72u as=1.8p ps=5.72u w=5u l=0.13u
X57 D6_2 G S5_2 B sg13_lv_pmos ad=1.8p pd=5.72u as=1.8p ps=5.72u w=5u l=0.13u
X58 S5_8 G D4_8 B sg13_lv_pmos ad=1.8p pd=5.72u as=1.8p ps=5.72u w=5u l=0.13u
X59 S3_8 G D2_8 B sg13_lv_pmos ad=1.8p pd=5.72u as=1.8p ps=5.72u w=5u l=0.13u
X60 D8_1 G S7_1 B sg13_lv_pmos ad=1.8p pd=5.72u as=1.8p ps=5.72u w=5u l=0.13u
X61 D6_3 G S5_3 B sg13_lv_pmos ad=1.8p pd=5.72u as=1.8p ps=5.72u w=5u l=0.13u
X62 D2_4 G S1_4 B sg13_lv_pmos ad=1.8p pd=5.72u as=1.8p ps=5.72u w=5u l=0.13u
X63 S3_1 G D2_1 B sg13_lv_pmos ad=1.8p pd=5.72u as=1.8p ps=5.72u w=5u l=0.13u
X64 D4_5 G S3_5 B sg13_lv_pmos ad=1.8p pd=5.72u as=1.8p ps=5.72u w=5u l=0.13u
X65 S5_7 G D4_7 B sg13_lv_pmos ad=1.8p pd=5.72u as=1.8p ps=5.72u w=5u l=0.13u
X66 S3_7 G D2_7 B sg13_lv_pmos ad=1.8p pd=5.72u as=1.8p ps=5.72u w=5u l=0.13u
X67 a_778_3308# G S9_8 B sg13_lv_pmos ad=3.4p pd=11.36u as=1.8p ps=5.72u w=5u l=0.13u
X68 a_778_2220# G S9_7 B sg13_lv_pmos ad=3.4p pd=11.36u as=1.8p ps=5.72u w=5u l=0.13u
X69 S1_8 G D0_8 B sg13_lv_pmos ad=1.8p pd=5.72u as=3.4p ps=11.36u w=5u l=0.13u
X70 D2_0 G S1_0 B sg13_lv_pmos ad=1.8p pd=5.72u as=1.8p ps=5.72u w=5u l=0.13u
X71 S1_7 G D0_7 B sg13_lv_pmos ad=1.8p pd=5.72u as=3.4p ps=11.36u w=5u l=0.13u
X72 S7_9 G D6_9 B sg13_lv_pmos ad=1.8p pd=5.72u as=1.8p ps=5.72u w=5u l=0.13u
X73 D4_9 G S3_9 B sg13_lv_pmos ad=1.8p pd=5.72u as=1.8p ps=5.72u w=5u l=0.13u
X74 D2_6 G S1_6 B sg13_lv_pmos ad=1.8p pd=5.72u as=1.8p ps=5.72u w=5u l=0.13u
X75 S9_9 G D8_9 B sg13_lv_pmos ad=1.8p pd=5.72u as=1.8p ps=5.72u w=5u l=0.13u
X76 S7_2 G D6_2 B sg13_lv_pmos ad=1.8p pd=5.72u as=1.8p ps=5.72u w=5u l=0.13u
X77 D4_2 G S3_2 B sg13_lv_pmos ad=1.8p pd=5.72u as=1.8p ps=5.72u w=5u l=0.13u
X78 S7_3 G D6_3 B sg13_lv_pmos ad=1.8p pd=5.72u as=1.8p ps=5.72u w=5u l=0.13u
X79 a_778_44# G S9_5 B sg13_lv_pmos ad=3.4p pd=11.36u as=1.8p ps=5.72u w=5u l=0.13u
X80 S5_1 G D4_1 B sg13_lv_pmos ad=1.8p pd=5.72u as=1.8p ps=5.72u w=5u l=0.13u
X81 D4_3 G S3_3 B sg13_lv_pmos ad=1.8p pd=5.72u as=1.8p ps=5.72u w=5u l=0.13u
X82 a_778_n1044# G S9_4 B sg13_lv_pmos ad=3.4p pd=11.36u as=1.8p ps=5.72u w=5u l=0.13u
X83 S9_1 G D8_1 B sg13_lv_pmos ad=1.8p pd=5.72u as=1.8p ps=5.72u w=5u l=0.13u
X84 S1_4 G D0_4 B sg13_lv_pmos ad=1.8p pd=5.72u as=3.4p ps=11.36u w=5u l=0.13u
X85 S9_5 G D8_5 B sg13_lv_pmos ad=1.8p pd=5.72u as=1.8p ps=5.72u w=5u l=0.13u
X86 D8_5 G S7_5 B sg13_lv_pmos ad=1.8p pd=5.72u as=1.8p ps=5.72u w=5u l=0.13u
X87 D6_1 G S5_1 B sg13_lv_pmos ad=1.8p pd=5.72u as=1.8p ps=5.72u w=5u l=0.13u
X88 D2_2 G S1_2 B sg13_lv_pmos ad=1.8p pd=5.72u as=1.8p ps=5.72u w=5u l=0.13u
X89 a_778_n5396# G S9_0 B sg13_lv_pmos ad=3.4p pd=11.36u as=1.8p ps=5.72u w=5u l=0.13u
X90 S5_5 G D4_5 B sg13_lv_pmos ad=1.8p pd=5.72u as=1.8p ps=5.72u w=5u l=0.13u
X91 S7_6 G D6_6 B sg13_lv_pmos ad=1.8p pd=5.72u as=1.8p ps=5.72u w=5u l=0.13u
X92 S1_0 G D0_0 B sg13_lv_pmos ad=1.8p pd=5.72u as=3.4p ps=11.36u w=5u l=0.13u
X93 D2_3 G S1_3 B sg13_lv_pmos ad=1.8p pd=5.72u as=1.8p ps=5.72u w=5u l=0.13u
X94 S7_5 G D6_5 B sg13_lv_pmos ad=1.8p pd=5.72u as=1.8p ps=5.72u w=5u l=0.13u
X95 D4_6 G S3_6 B sg13_lv_pmos ad=1.8p pd=5.72u as=1.8p ps=5.72u w=5u l=0.13u
X96 D6_9 G S5_9 B sg13_lv_pmos ad=1.8p pd=5.72u as=1.8p ps=5.72u w=5u l=0.13u
X97 S9_6 G D8_6 B sg13_lv_pmos ad=1.8p pd=5.72u as=1.8p ps=5.72u w=5u l=0.13u
X98 D2_8 G S1_8 B sg13_lv_pmos ad=1.8p pd=5.72u as=1.8p ps=5.72u w=5u l=0.13u
X99 D2_7 G S1_7 B sg13_lv_pmos ad=1.8p pd=5.72u as=1.8p ps=5.72u w=5u l=0.13u
.ends

.subckt sg13cmos5l_inv_2 Y A VDD VSS
X0 Y A VSS VSS sg13_lv_nmos ad=0.1406p pd=1.12u as=0.2516p ps=2.16u w=0.74u l=0.13u
X1 Y A VDD VDD sg13_lv_pmos ad=0.2128p pd=1.5u as=0.3808p ps=2.92u w=1.12u l=0.13u
X2 VSS A Y VSS sg13_lv_nmos ad=0.2516p pd=2.16u as=0.1406p ps=1.12u w=0.74u l=0.13u
X3 VDD A Y VDD sg13_lv_pmos ad=0.3864p pd=2.93u as=0.2128p ps=1.5u w=1.12u l=0.13u
.ends

.subckt sg13cmos5l_inv_16 Y A VDD VSS
X0 Y A VDD VDD sg13_lv_pmos ad=0.2128p pd=1.5u as=0.2128p ps=1.5u w=1.12u l=0.13u
X1 Y A VSS VSS sg13_lv_nmos ad=0.1406p pd=1.12u as=0.1406p ps=1.12u w=0.74u l=0.13u
X2 VDD A Y VDD sg13_lv_pmos ad=0.2128p pd=1.5u as=0.2128p ps=1.5u w=1.12u l=0.13u
X3 Y A VDD VDD sg13_lv_pmos ad=0.2128p pd=1.5u as=0.2128p ps=1.5u w=1.12u l=0.13u
X4 VSS A Y VSS sg13_lv_nmos ad=0.1406p pd=1.12u as=0.1406p ps=1.12u w=0.74u l=0.13u
X5 VDD A Y VDD sg13_lv_pmos ad=0.2128p pd=1.5u as=0.2128p ps=1.5u w=1.12u l=0.13u
X6 Y A VSS VSS sg13_lv_nmos ad=0.1406p pd=1.12u as=0.1406p ps=1.12u w=0.74u l=0.13u
X7 Y A VDD VDD sg13_lv_pmos ad=0.2128p pd=1.5u as=0.2128p ps=1.5u w=1.12u l=0.13u
X8 VSS A Y VSS sg13_lv_nmos ad=0.1406p pd=1.12u as=0.1406p ps=1.12u w=0.74u l=0.13u
X9 VDD A Y VDD sg13_lv_pmos ad=0.2128p pd=1.5u as=0.2128p ps=1.5u w=1.12u l=0.13u
X10 Y A VSS VSS sg13_lv_nmos ad=0.1406p pd=1.12u as=0.1406p ps=1.12u w=0.74u l=0.13u
X11 VSS A Y VSS sg13_lv_nmos ad=0.1406p pd=1.12u as=0.1406p ps=1.12u w=0.74u l=0.13u
X12 Y A VDD VDD sg13_lv_pmos ad=0.2128p pd=1.5u as=0.2128p ps=1.5u w=1.12u l=0.13u
X13 Y A VSS VSS sg13_lv_nmos ad=0.1406p pd=1.12u as=0.1406p ps=1.12u w=0.74u l=0.13u
X14 VDD A Y VDD sg13_lv_pmos ad=0.2128p pd=1.5u as=0.2128p ps=1.5u w=1.12u l=0.13u
X15 Y A VDD VDD sg13_lv_pmos ad=0.2128p pd=1.5u as=0.2128p ps=1.5u w=1.12u l=0.13u
X16 VSS A Y VSS sg13_lv_nmos ad=0.1406p pd=1.12u as=0.1406p ps=1.12u w=0.74u l=0.13u
X17 VDD A Y VDD sg13_lv_pmos ad=0.2128p pd=1.5u as=0.2128p ps=1.5u w=1.12u l=0.13u
X18 Y A VSS VSS sg13_lv_nmos ad=0.1406p pd=1.12u as=0.1406p ps=1.12u w=0.74u l=0.13u
X19 Y A VDD VDD sg13_lv_pmos ad=0.2128p pd=1.5u as=0.2128p ps=1.5u w=1.12u l=0.13u
X20 VSS A Y VSS sg13_lv_nmos ad=0.2516p pd=2.16u as=0.1406p ps=1.12u w=0.74u l=0.13u
X21 VDD A Y VDD sg13_lv_pmos ad=0.4368p pd=3.02u as=0.2128p ps=1.5u w=1.12u l=0.13u
X22 Y A VSS VSS sg13_lv_nmos ad=0.1406p pd=1.12u as=0.2516p ps=2.16u w=0.74u l=0.13u
X23 VSS A Y VSS sg13_lv_nmos ad=0.1406p pd=1.12u as=0.1406p ps=1.12u w=0.74u l=0.13u
X24 Y A VDD VDD sg13_lv_pmos ad=0.2128p pd=1.5u as=0.3808p ps=2.92u w=1.12u l=0.13u
X25 VDD A Y VDD sg13_lv_pmos ad=0.2128p pd=1.5u as=0.2128p ps=1.5u w=1.12u l=0.13u
X26 Y A VSS VSS sg13_lv_nmos ad=0.1406p pd=1.12u as=0.1406p ps=1.12u w=0.74u l=0.13u
X27 Y A VDD VDD sg13_lv_pmos ad=0.2128p pd=1.5u as=0.2128p ps=1.5u w=1.12u l=0.13u
X28 VSS A Y VSS sg13_lv_nmos ad=0.1406p pd=1.12u as=0.1406p ps=1.12u w=0.74u l=0.13u
X29 Y A VSS VSS sg13_lv_nmos ad=0.1406p pd=1.12u as=0.1406p ps=1.12u w=0.74u l=0.13u
X30 VDD A Y VDD sg13_lv_pmos ad=0.2128p pd=1.5u as=0.2128p ps=1.5u w=1.12u l=0.13u
X31 VSS A Y VSS sg13_lv_nmos ad=0.1406p pd=1.12u as=0.1406p ps=1.12u w=0.74u l=0.13u
.ends

.subckt sg13cmos5l_inv_1 Y A VDD VSS
X0 Y A VSS VSS sg13_lv_nmos ad=0.2516p pd=2.16u as=0.2516p ps=2.16u w=0.74u l=0.13u
X1 Y A VDD VDD sg13_lv_pmos ad=0.3808p pd=2.92u as=0.3808p ps=2.92u w=1.12u l=0.13u
.ends

.subckt sg13cmos5l_inv_8 Y A VDD VSS
X0 VSS A Y VSS sg13_lv_nmos ad=0.2516p pd=2.16u as=0.1443p ps=1.13u w=0.74u l=0.13u
X1 VDD A Y VDD sg13_lv_pmos ad=0.3808p pd=2.92u as=0.2184p ps=1.51u w=1.12u l=0.13u
X2 Y A VSS VSS sg13_lv_nmos ad=0.1406p pd=1.12u as=0.2516p ps=2.16u w=0.74u l=0.13u
X3 Y A VDD VDD sg13_lv_pmos ad=0.2128p pd=1.5u as=0.3808p ps=2.92u w=1.12u l=0.13u
X4 VSS A Y VSS sg13_lv_nmos ad=0.1406p pd=1.12u as=0.1406p ps=1.12u w=0.74u l=0.13u
X5 VDD A Y VDD sg13_lv_pmos ad=0.2128p pd=1.5u as=0.2128p ps=1.5u w=1.12u l=0.13u
X6 Y A VSS VSS sg13_lv_nmos ad=0.1406p pd=1.12u as=0.1406p ps=1.12u w=0.74u l=0.13u
X7 VSS A Y VSS sg13_lv_nmos ad=0.1406p pd=1.12u as=0.1406p ps=1.12u w=0.74u l=0.13u
X8 Y A VDD VDD sg13_lv_pmos ad=0.2128p pd=1.5u as=0.2128p ps=1.5u w=1.12u l=0.13u
X9 VDD A Y VDD sg13_lv_pmos ad=0.2128p pd=1.5u as=0.2128p ps=1.5u w=1.12u l=0.13u
X10 Y A VSS VSS sg13_lv_nmos ad=0.1406p pd=1.12u as=0.1406p ps=1.12u w=0.74u l=0.13u
X11 Y A VDD VDD sg13_lv_pmos ad=0.2128p pd=1.5u as=0.2128p ps=1.5u w=1.12u l=0.13u
X12 VSS A Y VSS sg13_lv_nmos ad=0.1406p pd=1.12u as=0.1406p ps=1.12u w=0.74u l=0.13u
X13 VDD A Y VDD sg13_lv_pmos ad=0.2128p pd=1.5u as=0.2128p ps=1.5u w=1.12u l=0.13u
X14 Y A VSS VSS sg13_lv_nmos ad=0.1443p pd=1.13u as=0.1406p ps=1.12u w=0.74u l=0.13u
X15 Y A VDD VDD sg13_lv_pmos ad=0.2184p pd=1.51u as=0.2128p ps=1.5u w=1.12u l=0.13u
.ends

.subckt gate_drive_1v2 in out dvss dvdd
Xsg13cmos5l_inv_2_0 sg13cmos5l_inv_8_0/A sg13cmos5l_inv_2_0/A dvdd dvss sg13cmos5l_inv_2
Xsg13cmos5l_antennanp_0 in dvdd dvss sg13cmos5l_antennanp
Xsg13cmos5l_inv_16_0 sg13cmos5l_inv_16_0/Y sg13cmos5l_inv_8_0/Y dvdd dvss sg13cmos5l_inv_16
Xsg13cmos5l_inv_1_0 sg13cmos5l_inv_2_0/A in dvdd dvss sg13cmos5l_inv_1
Xsg13cmos5l_decap_4_0 dvdd dvss sg13cmos5l_decap_4
Xsg13cmos5l_decap_4_1 dvdd dvss sg13cmos5l_decap_4
Xsg13cmos5l_inv_8_0 sg13cmos5l_inv_8_0/Y sg13cmos5l_inv_8_0/A dvdd dvss sg13cmos5l_inv_8
X0 dvdd sg13cmos5l_inv_16_0/Y out dvdd sg13_lv_pmos ad=0.2128p pd=1.5u as=0.2128p ps=1.5u w=1.12u l=0.13u
X1 out sg13cmos5l_inv_16_0/Y dvss dvss sg13_lv_nmos ad=0.1406p pd=1.12u as=0.1406p ps=1.12u w=0.74u l=0.13u
X2 out sg13cmos5l_inv_16_0/Y dvdd dvdd sg13_lv_pmos ad=0.2128p pd=1.5u as=0.2128p ps=1.5u w=1.12u l=0.13u
X3 dvss sg13cmos5l_inv_16_0/Y out dvss sg13_lv_nmos ad=0.1406p pd=1.12u as=0.1406p ps=1.12u w=0.74u l=0.13u
X4 out sg13cmos5l_inv_16_0/Y dvdd dvdd sg13_lv_pmos ad=0.2128p pd=1.5u as=0.2128p ps=1.5u w=1.12u l=0.13u
X5 out sg13cmos5l_inv_16_0/Y dvss dvss sg13_lv_nmos ad=0.1406p pd=1.12u as=0.2516p ps=2.16u w=0.74u l=0.13u
X6 out sg13cmos5l_inv_16_0/Y dvss dvss sg13_lv_nmos ad=0.1406p pd=1.12u as=0.1406p ps=1.12u w=0.74u l=0.13u
X7 out sg13cmos5l_inv_16_0/Y dvdd dvdd sg13_lv_pmos ad=0.2128p pd=1.5u as=0.4368p ps=3.02u w=1.12u l=0.13u
X8 out sg13cmos5l_inv_16_0/Y dvdd dvdd sg13_lv_pmos ad=0.2128p pd=1.5u as=0.2128p ps=1.5u w=1.12u l=0.13u
X9 dvdd sg13cmos5l_inv_16_0/Y out dvdd sg13_lv_pmos ad=0.2128p pd=1.5u as=0.2128p ps=1.5u w=1.12u l=0.13u
X10 dvss sg13cmos5l_inv_16_0/Y out dvss sg13_lv_nmos ad=0.1406p pd=1.12u as=0.1406p ps=1.12u w=0.74u l=0.13u
X11 out sg13cmos5l_inv_16_0/Y dvss dvss sg13_lv_nmos ad=0.1406p pd=1.12u as=0.1406p ps=1.12u w=0.74u l=0.13u
X12 dvss sg13cmos5l_inv_16_0/Y out dvss sg13_lv_nmos ad=0.1406p pd=1.12u as=0.1406p ps=1.12u w=0.74u l=0.13u
X13 dvdd sg13cmos5l_inv_16_0/Y out dvdd sg13_lv_pmos ad=0.2128p pd=1.5u as=0.2128p ps=1.5u w=1.12u l=0.13u
X14 out sg13cmos5l_inv_16_0/Y dvdd dvdd sg13_lv_pmos ad=0.2128p pd=1.5u as=0.2128p ps=1.5u w=1.12u l=0.13u
X15 out sg13cmos5l_inv_16_0/Y dvss dvss sg13_lv_nmos ad=0.1406p pd=1.12u as=0.1406p ps=1.12u w=0.74u l=0.13u
X16 dvss sg13cmos5l_inv_16_0/Y out dvss sg13_lv_nmos ad=0.1406p pd=1.12u as=0.1406p ps=1.12u w=0.74u l=0.13u
X17 dvdd sg13cmos5l_inv_16_0/Y out dvdd sg13_lv_pmos ad=0.2128p pd=1.5u as=0.2128p ps=1.5u w=1.12u l=0.13u
X18 out sg13cmos5l_inv_16_0/Y dvdd dvdd sg13_lv_pmos ad=0.2128p pd=1.5u as=0.2128p ps=1.5u w=1.12u l=0.13u
X19 dvdd sg13cmos5l_inv_16_0/Y out dvdd sg13_lv_pmos ad=0.2128p pd=1.5u as=0.2128p ps=1.5u w=1.12u l=0.13u
X20 dvss sg13cmos5l_inv_16_0/Y out dvss sg13_lv_nmos ad=0.1406p pd=1.12u as=0.1406p ps=1.12u w=0.74u l=0.13u
X21 dvss sg13cmos5l_inv_16_0/Y out dvss sg13_lv_nmos ad=0.2516p pd=2.16u as=0.1406p ps=1.12u w=0.74u l=0.13u
X22 out sg13cmos5l_inv_16_0/Y dvss dvss sg13_lv_nmos ad=0.1406p pd=1.12u as=0.1406p ps=1.12u w=0.74u l=0.13u
X23 dvdd sg13cmos5l_inv_16_0/Y out dvdd sg13_lv_pmos ad=0.2128p pd=1.5u as=0.2128p ps=1.5u w=1.12u l=0.13u
X24 dvdd sg13cmos5l_inv_16_0/Y out dvdd sg13_lv_pmos ad=0.3808p pd=2.92u as=0.2128p ps=1.5u w=1.12u l=0.13u
X25 dvss sg13cmos5l_inv_16_0/Y out dvss sg13_lv_nmos ad=0.1406p pd=1.12u as=0.1406p ps=1.12u w=0.74u l=0.13u
X26 out sg13cmos5l_inv_16_0/Y dvdd dvdd sg13_lv_pmos ad=0.2128p pd=1.5u as=0.2128p ps=1.5u w=1.12u l=0.13u
X27 dvss sg13cmos5l_inv_16_0/Y out dvss sg13_lv_nmos ad=0.1406p pd=1.12u as=0.1406p ps=1.12u w=0.74u l=0.13u
X28 dvdd sg13cmos5l_inv_16_0/Y out dvdd sg13_lv_pmos ad=0.2128p pd=1.5u as=0.2128p ps=1.5u w=1.12u l=0.13u
X29 out sg13cmos5l_inv_16_0/Y dvss dvss sg13_lv_nmos ad=0.1406p pd=1.12u as=0.1406p ps=1.12u w=0.74u l=0.13u
X30 out sg13cmos5l_inv_16_0/Y dvss dvss sg13_lv_nmos ad=0.1406p pd=1.12u as=0.1406p ps=1.12u w=0.74u l=0.13u
X31 dvdd sg13cmos5l_inv_16_0/Y out dvdd sg13_lv_pmos ad=0.2128p pd=1.5u as=0.2128p ps=1.5u w=1.12u l=0.13u
X32 out sg13cmos5l_inv_16_0/Y dvss dvss sg13_lv_nmos ad=0.1406p pd=1.12u as=0.1406p ps=1.12u w=0.74u l=0.13u
X33 out sg13cmos5l_inv_16_0/Y dvdd dvdd sg13_lv_pmos ad=0.2128p pd=1.5u as=0.2128p ps=1.5u w=1.12u l=0.13u
X34 out sg13cmos5l_inv_16_0/Y dvdd dvdd sg13_lv_pmos ad=0.2128p pd=1.5u as=0.2128p ps=1.5u w=1.12u l=0.13u
X35 dvss sg13cmos5l_inv_16_0/Y out dvss sg13_lv_nmos ad=0.1406p pd=1.12u as=0.1406p ps=1.12u w=0.74u l=0.13u
X36 dvdd sg13cmos5l_inv_16_0/Y out dvdd sg13_lv_pmos ad=0.2128p pd=1.5u as=0.2128p ps=1.5u w=1.12u l=0.13u
X37 out sg13cmos5l_inv_16_0/Y dvdd dvdd sg13_lv_pmos ad=0.2128p pd=1.5u as=0.2128p ps=1.5u w=1.12u l=0.13u
X38 out sg13cmos5l_inv_16_0/Y dvss dvss sg13_lv_nmos ad=0.1406p pd=1.12u as=0.1406p ps=1.12u w=0.74u l=0.13u
X39 dvss sg13cmos5l_inv_16_0/Y out dvss sg13_lv_nmos ad=0.1406p pd=1.12u as=0.1406p ps=1.12u w=0.74u l=0.13u
X40 out sg13cmos5l_inv_16_0/Y dvdd dvdd sg13_lv_pmos ad=0.2128p pd=1.5u as=0.2128p ps=1.5u w=1.12u l=0.13u
X41 out sg13cmos5l_inv_16_0/Y dvss dvss sg13_lv_nmos ad=0.1406p pd=1.12u as=0.1406p ps=1.12u w=0.74u l=0.13u
X42 dvss sg13cmos5l_inv_16_0/Y out dvss sg13_lv_nmos ad=0.1406p pd=1.12u as=0.1406p ps=1.12u w=0.74u l=0.13u
X43 dvdd sg13cmos5l_inv_16_0/Y out dvdd sg13_lv_pmos ad=0.2128p pd=1.5u as=0.2128p ps=1.5u w=1.12u l=0.13u
X44 out sg13cmos5l_inv_16_0/Y dvss dvss sg13_lv_nmos ad=0.1406p pd=1.12u as=0.1406p ps=1.12u w=0.74u l=0.13u
X45 out sg13cmos5l_inv_16_0/Y dvdd dvdd sg13_lv_pmos ad=0.2128p pd=1.5u as=0.2128p ps=1.5u w=1.12u l=0.13u
X46 dvdd sg13cmos5l_inv_16_0/Y out dvdd sg13_lv_pmos ad=0.2128p pd=1.5u as=0.2128p ps=1.5u w=1.12u l=0.13u
X47 dvss sg13cmos5l_inv_16_0/Y out dvss sg13_lv_nmos ad=0.1406p pd=1.12u as=0.1406p ps=1.12u w=0.74u l=0.13u
X48 out sg13cmos5l_inv_16_0/Y dvdd dvdd sg13_lv_pmos ad=0.2128p pd=1.5u as=0.2128p ps=1.5u w=1.12u l=0.13u
X49 out sg13cmos5l_inv_16_0/Y dvss dvss sg13_lv_nmos ad=0.1406p pd=1.12u as=0.1406p ps=1.12u w=0.74u l=0.13u
X50 dvss sg13cmos5l_inv_16_0/Y out dvss sg13_lv_nmos ad=0.1406p pd=1.12u as=0.1406p ps=1.12u w=0.74u l=0.13u
X51 dvdd sg13cmos5l_inv_16_0/Y out dvdd sg13_lv_pmos ad=0.2128p pd=1.5u as=0.2128p ps=1.5u w=1.12u l=0.13u
X52 out sg13cmos5l_inv_16_0/Y dvss dvss sg13_lv_nmos ad=0.1406p pd=1.12u as=0.1406p ps=1.12u w=0.74u l=0.13u
X53 dvdd sg13cmos5l_inv_16_0/Y out dvdd sg13_lv_pmos ad=0.2128p pd=1.5u as=0.2128p ps=1.5u w=1.12u l=0.13u
X54 out sg13cmos5l_inv_16_0/Y dvdd dvdd sg13_lv_pmos ad=0.2128p pd=1.5u as=0.2128p ps=1.5u w=1.12u l=0.13u
X55 out sg13cmos5l_inv_16_0/Y dvdd dvdd sg13_lv_pmos ad=0.2128p pd=1.5u as=0.2128p ps=1.5u w=1.12u l=0.13u
X56 dvss sg13cmos5l_inv_16_0/Y out dvss sg13_lv_nmos ad=0.1406p pd=1.12u as=0.1406p ps=1.12u w=0.74u l=0.13u
X57 dvdd sg13cmos5l_inv_16_0/Y out dvdd sg13_lv_pmos ad=0.2128p pd=1.5u as=0.2128p ps=1.5u w=1.12u l=0.13u
X58 dvss sg13cmos5l_inv_16_0/Y out dvss sg13_lv_nmos ad=0.1406p pd=1.12u as=0.1406p ps=1.12u w=0.74u l=0.13u
X59 out sg13cmos5l_inv_16_0/Y dvss dvss sg13_lv_nmos ad=0.1406p pd=1.12u as=0.1406p ps=1.12u w=0.74u l=0.13u
X60 dvss sg13cmos5l_inv_16_0/Y out dvss sg13_lv_nmos ad=0.1406p pd=1.12u as=0.1406p ps=1.12u w=0.74u l=0.13u
X61 dvdd sg13cmos5l_inv_16_0/Y out dvdd sg13_lv_pmos ad=0.2128p pd=1.5u as=0.2128p ps=1.5u w=1.12u l=0.13u
X62 out sg13cmos5l_inv_16_0/Y dvdd dvdd sg13_lv_pmos ad=0.2128p pd=1.5u as=0.2128p ps=1.5u w=1.12u l=0.13u
X63 out sg13cmos5l_inv_16_0/Y dvss dvss sg13_lv_nmos ad=0.1406p pd=1.12u as=0.1406p ps=1.12u w=0.74u l=0.13u
X64 dvss sg13cmos5l_inv_16_0/Y out dvss sg13_lv_nmos ad=0.1406p pd=1.12u as=0.1406p ps=1.12u w=0.74u l=0.13u
X65 dvdd sg13cmos5l_inv_16_0/Y out dvdd sg13_lv_pmos ad=0.2128p pd=1.5u as=0.2128p ps=1.5u w=1.12u l=0.13u
X66 out sg13cmos5l_inv_16_0/Y dvss dvss sg13_lv_nmos ad=0.1406p pd=1.12u as=0.1406p ps=1.12u w=0.74u l=0.13u
X67 out sg13cmos5l_inv_16_0/Y dvdd dvdd sg13_lv_pmos ad=0.2128p pd=1.5u as=0.2128p ps=1.5u w=1.12u l=0.13u
X68 dvdd sg13cmos5l_inv_16_0/Y out dvdd sg13_lv_pmos ad=0.2128p pd=1.5u as=0.2128p ps=1.5u w=1.12u l=0.13u
X69 dvss sg13cmos5l_inv_16_0/Y out dvss sg13_lv_nmos ad=0.1406p pd=1.12u as=0.1406p ps=1.12u w=0.74u l=0.13u
X70 out sg13cmos5l_inv_16_0/Y dvdd dvdd sg13_lv_pmos ad=0.2128p pd=1.5u as=0.2128p ps=1.5u w=1.12u l=0.13u
X71 out sg13cmos5l_inv_16_0/Y dvss dvss sg13_lv_nmos ad=0.1406p pd=1.12u as=0.1406p ps=1.12u w=0.74u l=0.13u
.ends

.subckt power_stage1v2 enable DVDD_OUT DVDD_IN DVSS
Xsg13_lv_pmos_5MXUJM_0[0] DVDD_IN DVDD_IN gate_drive_1v2_0/out DVDD_IN DVDD_IN DVDD_IN
+ DVDD_IN DVDD_IN DVDD_IN DVDD_IN DVDD_IN DVDD_IN DVDD_OUT DVDD_OUT DVDD_OUT DVDD_OUT
+ DVDD_OUT DVDD_OUT DVDD_OUT DVDD_OUT DVDD_OUT DVDD_OUT DVDD_IN DVDD_IN DVDD_IN DVDD_IN
+ DVDD_IN DVDD_IN DVDD_IN DVDD_IN DVDD_IN DVDD_IN DVDD_OUT DVDD_OUT DVDD_OUT DVDD_OUT
+ DVDD_OUT DVDD_OUT DVDD_OUT DVDD_OUT DVDD_OUT DVDD_OUT DVDD_IN DVDD_IN DVDD_IN DVDD_IN
+ DVDD_IN DVDD_IN DVDD_IN DVDD_IN DVDD_IN DVDD_IN DVDD_OUT DVDD_OUT DVDD_OUT DVDD_OUT
+ DVDD_OUT DVDD_OUT DVDD_OUT DVDD_OUT DVDD_OUT DVDD_OUT DVDD_IN DVDD_IN DVDD_IN DVDD_IN
+ DVDD_IN DVDD_IN DVDD_IN DVDD_IN DVDD_IN DVDD_IN DVDD_OUT DVDD_OUT DVDD_OUT DVDD_OUT
+ DVDD_OUT DVDD_OUT DVDD_OUT DVDD_OUT DVDD_OUT DVDD_OUT DVDD_IN DVDD_IN DVDD_IN DVDD_IN
+ DVDD_IN DVDD_IN DVDD_IN DVDD_IN DVDD_IN DVDD_IN DVDD_OUT DVDD_OUT DVDD_OUT DVDD_OUT
+ DVDD_OUT DVDD_OUT DVDD_OUT DVDD_OUT DVDD_OUT DVDD_OUT DVDD_IN DVDD_IN DVDD_IN DVDD_IN
+ DVDD_IN DVDD_IN DVDD_IN DVDD_IN DVDD_IN DVDD_IN sg13_lv_pmos_5MXUJM
Xsg13_lv_pmos_5MXUJM_0[1] DVDD_IN DVDD_IN gate_drive_1v2_0/out DVDD_IN DVDD_IN DVDD_IN
+ DVDD_IN DVDD_IN DVDD_IN DVDD_IN DVDD_IN DVDD_IN DVDD_OUT DVDD_OUT DVDD_OUT DVDD_OUT
+ DVDD_OUT DVDD_OUT DVDD_OUT DVDD_OUT DVDD_OUT DVDD_OUT DVDD_IN DVDD_IN DVDD_IN DVDD_IN
+ DVDD_IN DVDD_IN DVDD_IN DVDD_IN DVDD_IN DVDD_IN DVDD_OUT DVDD_OUT DVDD_OUT DVDD_OUT
+ DVDD_OUT DVDD_OUT DVDD_OUT DVDD_OUT DVDD_OUT DVDD_OUT DVDD_IN DVDD_IN DVDD_IN DVDD_IN
+ DVDD_IN DVDD_IN DVDD_IN DVDD_IN DVDD_IN DVDD_IN DVDD_OUT DVDD_OUT DVDD_OUT DVDD_OUT
+ DVDD_OUT DVDD_OUT DVDD_OUT DVDD_OUT DVDD_OUT DVDD_OUT DVDD_IN DVDD_IN DVDD_IN DVDD_IN
+ DVDD_IN DVDD_IN DVDD_IN DVDD_IN DVDD_IN DVDD_IN DVDD_OUT DVDD_OUT DVDD_OUT DVDD_OUT
+ DVDD_OUT DVDD_OUT DVDD_OUT DVDD_OUT DVDD_OUT DVDD_OUT DVDD_IN DVDD_IN DVDD_IN DVDD_IN
+ DVDD_IN DVDD_IN DVDD_IN DVDD_IN DVDD_IN DVDD_IN DVDD_OUT DVDD_OUT DVDD_OUT DVDD_OUT
+ DVDD_OUT DVDD_OUT DVDD_OUT DVDD_OUT DVDD_OUT DVDD_OUT DVDD_IN DVDD_IN DVDD_IN DVDD_IN
+ DVDD_IN DVDD_IN DVDD_IN DVDD_IN DVDD_IN DVDD_IN sg13_lv_pmos_5MXUJM
Xsg13_lv_pmos_5MXUJM_0[2] DVDD_IN DVDD_IN gate_drive_1v2_0/out DVDD_IN DVDD_IN DVDD_IN
+ DVDD_IN DVDD_IN DVDD_IN DVDD_IN DVDD_IN DVDD_IN DVDD_OUT DVDD_OUT DVDD_OUT DVDD_OUT
+ DVDD_OUT DVDD_OUT DVDD_OUT DVDD_OUT DVDD_OUT DVDD_OUT DVDD_IN DVDD_IN DVDD_IN DVDD_IN
+ DVDD_IN DVDD_IN DVDD_IN DVDD_IN DVDD_IN DVDD_IN DVDD_OUT DVDD_OUT DVDD_OUT DVDD_OUT
+ DVDD_OUT DVDD_OUT DVDD_OUT DVDD_OUT DVDD_OUT DVDD_OUT DVDD_IN DVDD_IN DVDD_IN DVDD_IN
+ DVDD_IN DVDD_IN DVDD_IN DVDD_IN DVDD_IN DVDD_IN DVDD_OUT DVDD_OUT DVDD_OUT DVDD_OUT
+ DVDD_OUT DVDD_OUT DVDD_OUT DVDD_OUT DVDD_OUT DVDD_OUT DVDD_IN DVDD_IN DVDD_IN DVDD_IN
+ DVDD_IN DVDD_IN DVDD_IN DVDD_IN DVDD_IN DVDD_IN DVDD_OUT DVDD_OUT DVDD_OUT DVDD_OUT
+ DVDD_OUT DVDD_OUT DVDD_OUT DVDD_OUT DVDD_OUT DVDD_OUT DVDD_IN DVDD_IN DVDD_IN DVDD_IN
+ DVDD_IN DVDD_IN DVDD_IN DVDD_IN DVDD_IN DVDD_IN DVDD_OUT DVDD_OUT DVDD_OUT DVDD_OUT
+ DVDD_OUT DVDD_OUT DVDD_OUT DVDD_OUT DVDD_OUT DVDD_OUT DVDD_IN DVDD_IN DVDD_IN DVDD_IN
+ DVDD_IN DVDD_IN DVDD_IN DVDD_IN DVDD_IN DVDD_IN sg13_lv_pmos_5MXUJM
Xsg13_lv_pmos_5MXUJM_0[3] DVDD_IN DVDD_IN gate_drive_1v2_0/out DVDD_IN DVDD_IN DVDD_IN
+ DVDD_IN DVDD_IN DVDD_IN DVDD_IN DVDD_IN DVDD_IN DVDD_OUT DVDD_OUT DVDD_OUT DVDD_OUT
+ DVDD_OUT DVDD_OUT DVDD_OUT DVDD_OUT DVDD_OUT DVDD_OUT DVDD_IN DVDD_IN DVDD_IN DVDD_IN
+ DVDD_IN DVDD_IN DVDD_IN DVDD_IN DVDD_IN DVDD_IN DVDD_OUT DVDD_OUT DVDD_OUT DVDD_OUT
+ DVDD_OUT DVDD_OUT DVDD_OUT DVDD_OUT DVDD_OUT DVDD_OUT DVDD_IN DVDD_IN DVDD_IN DVDD_IN
+ DVDD_IN DVDD_IN DVDD_IN DVDD_IN DVDD_IN DVDD_IN DVDD_OUT DVDD_OUT DVDD_OUT DVDD_OUT
+ DVDD_OUT DVDD_OUT DVDD_OUT DVDD_OUT DVDD_OUT DVDD_OUT DVDD_IN DVDD_IN DVDD_IN DVDD_IN
+ DVDD_IN DVDD_IN DVDD_IN DVDD_IN DVDD_IN DVDD_IN DVDD_OUT DVDD_OUT DVDD_OUT DVDD_OUT
+ DVDD_OUT DVDD_OUT DVDD_OUT DVDD_OUT DVDD_OUT DVDD_OUT DVDD_IN DVDD_IN DVDD_IN DVDD_IN
+ DVDD_IN DVDD_IN DVDD_IN DVDD_IN DVDD_IN DVDD_IN DVDD_OUT DVDD_OUT DVDD_OUT DVDD_OUT
+ DVDD_OUT DVDD_OUT DVDD_OUT DVDD_OUT DVDD_OUT DVDD_OUT DVDD_IN DVDD_IN DVDD_IN DVDD_IN
+ DVDD_IN DVDD_IN DVDD_IN DVDD_IN DVDD_IN DVDD_IN sg13_lv_pmos_5MXUJM
Xsg13_lv_pmos_5MXUJM_0[4] DVDD_IN DVDD_IN gate_drive_1v2_0/out DVDD_IN DVDD_IN DVDD_IN
+ DVDD_IN DVDD_IN DVDD_IN DVDD_IN DVDD_IN DVDD_IN DVDD_OUT DVDD_OUT DVDD_OUT DVDD_OUT
+ DVDD_OUT DVDD_OUT DVDD_OUT DVDD_OUT DVDD_OUT DVDD_OUT DVDD_IN DVDD_IN DVDD_IN DVDD_IN
+ DVDD_IN DVDD_IN DVDD_IN DVDD_IN DVDD_IN DVDD_IN DVDD_OUT DVDD_OUT DVDD_OUT DVDD_OUT
+ DVDD_OUT DVDD_OUT DVDD_OUT DVDD_OUT DVDD_OUT DVDD_OUT DVDD_IN DVDD_IN DVDD_IN DVDD_IN
+ DVDD_IN DVDD_IN DVDD_IN DVDD_IN DVDD_IN DVDD_IN DVDD_OUT DVDD_OUT DVDD_OUT DVDD_OUT
+ DVDD_OUT DVDD_OUT DVDD_OUT DVDD_OUT DVDD_OUT DVDD_OUT DVDD_IN DVDD_IN DVDD_IN DVDD_IN
+ DVDD_IN DVDD_IN DVDD_IN DVDD_IN DVDD_IN DVDD_IN DVDD_OUT DVDD_OUT DVDD_OUT DVDD_OUT
+ DVDD_OUT DVDD_OUT DVDD_OUT DVDD_OUT DVDD_OUT DVDD_OUT DVDD_IN DVDD_IN DVDD_IN DVDD_IN
+ DVDD_IN DVDD_IN DVDD_IN DVDD_IN DVDD_IN DVDD_IN DVDD_OUT DVDD_OUT DVDD_OUT DVDD_OUT
+ DVDD_OUT DVDD_OUT DVDD_OUT DVDD_OUT DVDD_OUT DVDD_OUT DVDD_IN DVDD_IN DVDD_IN DVDD_IN
+ DVDD_IN DVDD_IN DVDD_IN DVDD_IN DVDD_IN DVDD_IN sg13_lv_pmos_5MXUJM
Xgate_drive_1v2_0 enable gate_drive_1v2_0/out DVSS DVDD_IN gate_drive_1v2
.ends

.subckt sg13cmos5l_buf_8 X A VDD VSS
X0 VSS A a_27_118# VSS sg13_lv_nmos ad=0.1406p pd=1.12u as=0.1406p ps=1.12u w=0.74u l=0.13u
X1 VSS A a_27_118# VSS sg13_lv_nmos ad=0.1406p pd=1.12u as=0.2553p ps=2.17u w=0.74u l=0.13u
X2 VDD A a_27_118# VDD sg13_lv_pmos ad=0.2128p pd=1.5u as=0.2128p ps=1.5u w=1.12u l=0.13u
X3 X a_27_118# VSS VSS sg13_lv_nmos ad=0.1406p pd=1.12u as=0.1406p ps=1.12u w=0.74u l=0.13u
X4 VDD A a_27_118# VDD sg13_lv_pmos ad=0.2128p pd=1.5u as=0.3808p ps=2.92u w=1.12u l=0.13u
X5 X a_27_118# VDD VDD sg13_lv_pmos ad=0.2128p pd=1.5u as=0.2128p ps=1.5u w=1.12u l=0.13u
X6 VSS a_27_118# X VSS sg13_lv_nmos ad=0.1406p pd=1.12u as=0.1406p ps=1.12u w=0.74u l=0.13u
X7 VDD a_27_118# X VDD sg13_lv_pmos ad=0.2128p pd=1.5u as=0.2128p ps=1.5u w=1.12u l=0.13u
X8 X a_27_118# VSS VSS sg13_lv_nmos ad=0.1406p pd=1.12u as=0.1406p ps=1.12u w=0.74u l=0.13u
X9 X a_27_118# VDD VDD sg13_lv_pmos ad=0.2128p pd=1.5u as=0.2128p ps=1.5u w=1.12u l=0.13u
X10 VSS a_27_118# X VSS sg13_lv_nmos ad=0.1406p pd=1.12u as=0.1406p ps=1.12u w=0.74u l=0.13u
X11 X a_27_118# VSS VSS sg13_lv_nmos ad=0.1406p pd=1.12u as=0.1406p ps=1.12u w=0.74u l=0.13u
X12 VDD a_27_118# X VDD sg13_lv_pmos ad=0.2128p pd=1.5u as=0.2128p ps=1.5u w=1.12u l=0.13u
X13 X a_27_118# VDD VDD sg13_lv_pmos ad=0.2128p pd=1.5u as=0.2128p ps=1.5u w=1.12u l=0.13u
X14 VSS a_27_118# X VSS sg13_lv_nmos ad=0.1406p pd=1.12u as=0.1406p ps=1.12u w=0.74u l=0.13u
X15 VDD a_27_118# X VDD sg13_lv_pmos ad=0.2128p pd=1.5u as=0.2128p ps=1.5u w=1.12u l=0.13u
X16 X a_27_118# VSS VSS sg13_lv_nmos ad=0.1406p pd=1.12u as=0.1406p ps=1.12u w=0.74u l=0.13u
X17 VSS a_27_118# X VSS sg13_lv_nmos ad=0.2516p pd=2.16u as=0.1406p ps=1.12u w=0.74u l=0.13u
X18 X a_27_118# VDD VDD sg13_lv_pmos ad=0.2128p pd=1.5u as=0.2128p ps=1.5u w=1.12u l=0.13u
X19 VDD a_27_118# X VDD sg13_lv_pmos ad=0.3864p pd=2.93u as=0.2128p ps=1.5u w=1.12u l=0.13u
X20 a_27_118# A VSS VSS sg13_lv_nmos ad=0.1406p pd=1.12u as=0.1406p ps=1.12u w=0.74u l=0.13u
X21 a_27_118# A VDD VDD sg13_lv_pmos ad=0.2128p pd=1.5u as=0.2128p ps=1.5u w=1.12u l=0.13u
.ends

.subckt sg13cmos5l_decap_8 VDD VSS
X0 VSS VDD VSS VSS sg13_lv_nmos ad=0.1428p pd=1.52u as=0 ps=0 w=0.42u l=1u
X1 VDD VSS VDD VDD sg13_lv_pmos ad=0.19p pd=1.38u as=0 ps=0 w=1u l=1u
X2 VSS VDD VSS VSS sg13_lv_nmos ad=79.8f pd=0.8u as=0 ps=0 w=0.42u l=1u
X3 VDD VSS VDD VDD sg13_lv_pmos ad=0.34p pd=2.68u as=0 ps=0 w=1u l=1u
.ends

.subckt sg13cmos5l_mux2_1 X A0 A1 S VDD VSS
X0 a_559_412# A1 a_382_118# VDD sg13_lv_pmos ad=0.2975p pd=1.595u as=0.2225p ps=1.445u w=1u l=0.13u
X1 VDD S a_59_156# VDD sg13_lv_pmos ad=0.253p pd=1.53u as=0.2856p ps=2.36u w=0.84u l=0.13u
X2 VSS S a_59_156# VSS sg13_lv_nmos ad=0.18945p pd=1.27u as=0.187p ps=1.78u w=0.55u l=0.13u
X3 X a_382_118# VSS VSS sg13_lv_nmos ad=0.4033p pd=2.57u as=0.148p ps=1.14u w=0.74u l=0.13u
X4 X a_382_118# VDD VDD sg13_lv_pmos ad=0.6048p pd=3.32u as=0.2198p ps=1.52u w=1.12u l=0.13u
X5 a_285_118# S VSS VSS sg13_lv_nmos ad=0.13135p pd=1.095u as=0.18945p ps=1.27u w=0.74u l=0.13u
X6 a_285_412# S VDD VDD sg13_lv_pmos ad=0.3325p pd=1.665u as=0.253p ps=1.53u w=1u l=0.13u
X7 VSS a_59_156# a_496_118# VSS sg13_lv_nmos ad=0.148p pd=1.14u as=0.3367p ps=1.65u w=0.74u l=0.13u
X8 VDD a_59_156# a_559_412# VDD sg13_lv_pmos ad=0.2198p pd=1.52u as=0.2975p ps=1.595u w=1u l=0.13u
X9 a_382_118# A1 a_285_118# VSS sg13_lv_nmos ad=0.1628p pd=1.18u as=0.13135p ps=1.095u w=0.74u l=0.13u
X10 a_496_118# A0 a_382_118# VSS sg13_lv_nmos ad=0.3367p pd=1.65u as=0.1628p ps=1.18u w=0.74u l=0.13u
X11 a_382_118# A0 a_285_412# VDD sg13_lv_pmos ad=0.2225p pd=1.445u as=0.3325p ps=1.665u w=1u l=0.13u
.ends

.subckt sg13cmos5l_buf_1 X A VDD VSS
X0 X a_40_152# VSS VSS sg13_lv_nmos ad=0.2886p pd=2.26u as=0.14875p ps=1.16u w=0.74u l=0.13u
X1 X a_40_152# VDD VDD sg13_lv_pmos ad=0.42p pd=2.99u as=0.2114p ps=1.54u w=1.12u l=0.13u
X2 VDD A a_40_152# VDD sg13_lv_pmos ad=0.2114p pd=1.54u as=0.2856p ps=2.36u w=0.84u l=0.13u
X3 VSS A a_40_152# VSS sg13_lv_nmos ad=0.14875p pd=1.16u as=0.187p ps=1.78u w=0.55u l=0.13u
.ends

.subckt sg13cmos5l_buf_4 X A VDD VSS
X0 X a_111_82# VSS VSS sg13_lv_nmos ad=0.1406p pd=1.12u as=0.2516p ps=2.16u w=0.74u l=0.13u
X1 X a_111_82# VDD VDD sg13_lv_pmos ad=0.2128p pd=1.5u as=0.3808p ps=2.92u w=1.12u l=0.13u
X2 VSS a_111_82# X VSS sg13_lv_nmos ad=0.1406p pd=1.12u as=0.1406p ps=1.12u w=0.74u l=0.13u
X3 VDD a_111_82# X VDD sg13_lv_pmos ad=0.2128p pd=1.5u as=0.2128p ps=1.5u w=1.12u l=0.13u
X4 X a_111_82# VSS VSS sg13_lv_nmos ad=0.1406p pd=1.12u as=0.1406p ps=1.12u w=0.74u l=0.13u
X5 VSS a_111_82# X VSS sg13_lv_nmos ad=0.3293p pd=1.63u as=0.1406p ps=1.12u w=0.74u l=0.13u
X6 X a_111_82# VDD VDD sg13_lv_pmos ad=0.2128p pd=1.5u as=0.2128p ps=1.5u w=1.12u l=0.13u
X7 VDD a_111_82# X VDD sg13_lv_pmos ad=0.203p pd=1.5u as=0.2128p ps=1.5u w=1.12u l=0.13u
X8 a_111_82# A VSS VSS sg13_lv_nmos ad=0.2516p pd=2.16u as=0.3293p ps=1.63u w=0.74u l=0.13u
X9 a_111_82# A VDD VDD sg13_lv_pmos ad=0.1596p pd=1.22u as=0.203p ps=1.5u w=0.84u l=0.13u
X10 VDD A a_111_82# VDD sg13_lv_pmos ad=0.2856p pd=2.36u as=0.1596p ps=1.22u w=0.84u l=0.13u
.ends

.subckt sg13cmos5l_dlhrq_1 Q D GATE RESET_B VDD VSS
X0 a_815_103# a_264_468# a_689_103# VSS sg13_lv_nmos ad=47.25f pd=0.645u as=0.15175p ps=1.14u w=0.42u l=0.13u
X1 a_689_103# a_264_468# a_614_436# VDD sg13_lv_pmos ad=0.1897p pd=1.42u as=0.1375p ps=1.275u w=1u l=0.13u
X2 a_1095_118# a_689_103# a_860_67# VSS sg13_lv_nmos ad=88.8f pd=0.98u as=0.2516p ps=2.16u w=0.74u l=0.13u
X3 a_860_67# a_689_103# VDD VDD sg13_lv_pmos ad=0.19p pd=1.38u as=0.20165p ps=1.615u w=1u l=0.13u
X4 a_805_552# a_409_103# a_689_103# VDD sg13_lv_pmos ad=0.11025p pd=0.945u as=0.1897p ps=1.42u w=0.42u l=0.13u
X5 VDD RESET_B a_860_67# VDD sg13_lv_pmos ad=0.2038p pd=1.5u as=0.19p ps=1.38u w=1u l=0.13u
X6 VSS RESET_B a_1095_118# VSS sg13_lv_nmos ad=0.1406p pd=1.12u as=88.8f ps=0.98u w=0.74u l=0.13u
X7 Q a_860_67# VSS VSS sg13_lv_nmos ad=0.2516p pd=2.16u as=0.1406p ps=1.12u w=0.74u l=0.13u
X8 VSS D a_45_156# VSS sg13_lv_nmos ad=0.14875p pd=1.16u as=0.3025p ps=2.2u w=0.55u l=0.13u
X9 VDD a_264_468# a_409_103# VDD sg13_lv_pmos ad=0.2015p pd=1.415u as=0.2856p ps=2.36u w=0.84u l=0.13u
X10 VDD D a_45_156# VDD sg13_lv_pmos ad=0.1596p pd=1.22u as=0.2856p ps=2.36u w=0.84u l=0.13u
X11 Q a_860_67# VDD VDD sg13_lv_pmos ad=0.4368p pd=3.02u as=0.2038p ps=1.5u w=1.12u l=0.13u
X12 VDD a_860_67# a_805_552# VDD sg13_lv_pmos ad=0.20165p pd=1.615u as=0.11025p ps=0.945u w=0.42u l=0.13u
X13 a_264_468# GATE VDD VDD sg13_lv_pmos ad=0.46837p pd=3u as=0.1596p ps=1.22u w=0.84u l=0.13u
X14 a_614_436# a_45_156# VDD VDD sg13_lv_pmos ad=0.1375p pd=1.275u as=0.2015p ps=1.415u w=1u l=0.13u
X15 VSS a_860_67# a_815_103# VSS sg13_lv_nmos ad=0.1428p pd=1.52u as=47.25f ps=0.645u w=0.42u l=0.13u
X16 a_264_468# GATE VSS VSS sg13_lv_nmos ad=0.2516p pd=2.16u as=0.14875p ps=1.16u w=0.74u l=0.13u
X17 a_689_103# a_409_103# a_611_103# VSS sg13_lv_nmos ad=0.15175p pd=1.14u as=83.2f ps=0.9u w=0.64u l=0.13u
X18 VSS a_264_468# a_409_103# VSS sg13_lv_nmos ad=0.1393p pd=1.155u as=0.3458p ps=2.7u w=0.74u l=0.13u
X19 a_611_103# a_45_156# VSS VSS sg13_lv_nmos ad=83.2f pd=0.9u as=0.1393p ps=1.155u w=0.64u l=0.13u
.ends

.subckt sg13cmos5l_and2_1 X A B VDD VSS
X0 X a_45_160# VDD VDD sg13_lv_pmos ad=0.3808p pd=2.92u as=0.1918p ps=1.5u w=1.12u l=0.13u
X1 X a_45_160# VSS VSS sg13_lv_nmos ad=0.2516p pd=2.16u as=0.1331p ps=1.12u w=0.74u l=0.13u
X2 a_45_160# A VDD VDD sg13_lv_pmos ad=0.1596p pd=1.22u as=0.2856p ps=2.36u w=0.84u l=0.13u
X3 VDD B a_45_160# VDD sg13_lv_pmos ad=0.1918p pd=1.5u as=0.1596p ps=1.22u w=0.84u l=0.13u
X4 a_139_160# A a_45_160# VSS sg13_lv_nmos ad=0.1216p pd=1.02u as=0.2176p ps=1.96u w=0.64u l=0.13u
X5 VSS B a_139_160# VSS sg13_lv_nmos ad=0.1331p pd=1.12u as=0.1216p ps=1.02u w=0.64u l=0.13u
.ends

.subckt sg13cmos5l_nor3_1 Y A B C VDD VSS
X0 Y A VSS VSS sg13_lv_nmos ad=0.1694p pd=1.21u as=0.2618p ps=2.22u w=0.77u l=0.13u
X1 a_165_412# A VDD VDD sg13_lv_pmos ad=0.2464p pd=1.56u as=0.3808p ps=2.92u w=1.12u l=0.13u
X2 VSS B Y VSS sg13_lv_nmos ad=0.1463p pd=1.15u as=0.1694p ps=1.21u w=0.77u l=0.13u
X3 Y C VSS VSS sg13_lv_nmos ad=0.2618p pd=2.22u as=0.1463p ps=1.15u w=0.77u l=0.13u
X4 a_279_412# B a_165_412# VDD sg13_lv_pmos ad=0.2128p pd=1.5u as=0.2464p ps=1.56u w=1.12u l=0.13u
X5 Y C a_279_412# VDD sg13_lv_pmos ad=0.3808p pd=2.92u as=0.2128p ps=1.5u w=1.12u l=0.13u
.ends

.subckt sg13cmos5l_dlygate4sd3_1 X A VDD VSS
X0 VDD A a_56_118# VDD sg13_lv_pmos ad=0.1523p pd=1.38u as=0.1428p ps=1.52u w=0.42u l=0.13u
X1 VSS a_326_118# a_438_182# VSS sg13_lv_nmos ad=0.1426p pd=1.16u as=0.1428p ps=1.52u w=0.42u l=0.5u
X2 VDD a_326_118# a_438_182# VDD sg13_lv_pmos ad=0.2254p pd=1.53u as=0.34p ps=2.68u w=1u l=0.5u
X3 X a_438_182# VDD VDD sg13_lv_pmos ad=0.4256p pd=3u as=0.2254p ps=1.53u w=1.12u l=0.13u
X4 a_326_118# a_56_118# VDD VDD sg13_lv_pmos ad=0.34p pd=2.68u as=0.1523p ps=1.38u w=1u l=0.5u
X5 VSS A a_56_118# VSS sg13_lv_nmos ad=79.8f pd=0.8u as=0.1428p ps=1.52u w=0.42u l=0.13u
X6 X a_438_182# VSS VSS sg13_lv_nmos ad=0.2516p pd=2.16u as=0.1426p ps=1.16u w=0.74u l=0.13u
X7 a_326_118# a_56_118# VSS VSS sg13_lv_nmos ad=0.1428p pd=1.52u as=79.8f ps=0.8u w=0.42u l=0.5u
.ends

.subckt sg13cmos5l_nand4_1 Y A B C D VDD VSS
X0 Y D VDD VDD sg13_lv_pmos ad=0.2128p pd=1.5u as=0.3808p ps=2.92u w=1.12u l=0.13u
X1 VDD C Y VDD sg13_lv_pmos ad=0.2128p pd=1.5u as=0.2128p ps=1.5u w=1.12u l=0.13u
X2 Y B VDD VDD sg13_lv_pmos ad=0.2128p pd=1.5u as=0.2128p ps=1.5u w=1.12u l=0.13u
X3 VDD A Y VDD sg13_lv_pmos ad=0.3808p pd=2.92u as=0.2128p ps=1.5u w=1.12u l=0.13u
X4 a_146_122# D VSS VSS sg13_lv_nmos ad=0.1406p pd=1.12u as=0.2516p ps=2.16u w=0.74u l=0.13u
X5 a_248_122# C a_146_122# VSS sg13_lv_nmos ad=0.1406p pd=1.12u as=0.1406p ps=1.12u w=0.74u l=0.13u
X6 a_350_122# B a_248_122# VSS sg13_lv_nmos ad=0.1406p pd=1.12u as=0.1406p ps=1.12u w=0.74u l=0.13u
X7 Y A a_350_122# VSS sg13_lv_nmos ad=0.2516p pd=2.16u as=0.1406p ps=1.12u w=0.74u l=0.13u
.ends

.subckt sg13cmos5l_xor2_1 X A B VDD VSS
X0 VSS a_209_168# X VSS sg13_lv_nmos ad=0.3108p pd=2.32u as=0.1628p ps=1.18u w=0.74u l=0.13u
X1 VDD A a_380_412# VDD sg13_lv_pmos ad=0.2128p pd=1.5u as=0.3808p ps=2.92u w=1.12u l=0.13u
X2 a_380_412# B VDD VDD sg13_lv_pmos ad=0.2128p pd=1.5u as=0.2128p ps=1.5u w=1.12u l=0.13u
X3 X a_209_168# a_380_412# VDD sg13_lv_pmos ad=0.3808p pd=2.92u as=0.2128p ps=1.5u w=1.12u l=0.13u
X4 a_177_436# A VDD VDD sg13_lv_pmos ad=0.1225p pd=1.245u as=0.36p ps=2.72u w=1u l=0.13u
X5 a_209_168# A VSS VSS sg13_lv_nmos ad=0.17462p pd=1.185u as=0.374p ps=2.46u w=0.55u l=0.13u
X6 a_209_168# B a_177_436# VDD sg13_lv_pmos ad=0.34p pd=2.68u as=0.1225p ps=1.245u w=1u l=0.13u
X7 VSS B a_209_168# VSS sg13_lv_nmos ad=0.15245p pd=1.17u as=0.17462p ps=1.185u w=0.55u l=0.13u
X8 a_474_130# A VSS VSS sg13_lv_nmos ad=88.8f pd=0.98u as=0.15245p ps=1.17u w=0.74u l=0.13u
X9 X B a_474_130# VSS sg13_lv_nmos ad=0.1628p pd=1.18u as=88.8f ps=0.98u w=0.74u l=0.13u
.ends

.subckt sg13cmos5l_nand2b_1 Y A_N B VDD VSS
X0 VDD a_27_156# Y VDD sg13_lv_pmos ad=0.3808p pd=2.92u as=0.2128p ps=1.5u w=1.12u l=0.13u
X1 a_229_118# B VSS VSS sg13_lv_nmos ad=0.1406p pd=1.12u as=0.14505p ps=1.15u w=0.74u l=0.13u
X2 VDD A_N a_27_156# VDD sg13_lv_pmos ad=0.2198p pd=1.53u as=0.2856p ps=2.36u w=0.84u l=0.13u
X3 Y B VDD VDD sg13_lv_pmos ad=0.2128p pd=1.5u as=0.2198p ps=1.53u w=1.12u l=0.13u
X4 Y a_27_156# a_229_118# VSS sg13_lv_nmos ad=0.333p pd=2.38u as=0.1406p ps=1.12u w=0.74u l=0.13u
X5 VSS A_N a_27_156# VSS sg13_lv_nmos ad=0.14505p pd=1.15u as=0.187p ps=1.78u w=0.55u l=0.13u
.ends

.subckt sg13cmos5l_lgcp_1 GCLK CLK GATE VDD VSS
X0 a_357_380# a_363_86# VDD VDD sg13_lv_pmos ad=0.2856p pd=2.36u as=1.30835p ps=9.07u w=0.84u l=0.13u
X1 VSS CLK a_363_86# VSS sg13_lv_nmos ad=0.1371p pd=1.12u as=0.2516p ps=2.16u w=0.74u l=0.13u
X2 GCLK a_1034_435# VSS VSS sg13_lv_nmos ad=0.2516p pd=2.16u as=0.2516p ps=2.16u w=0.74u l=0.13u
X3 a_521_166# a_357_380# a_134_80# VSS sg13_lv_nmos ad=54.6f pd=0.68u as=0.141p ps=1.17u w=0.42u l=0.13u
X4 a_1028_158# CLK VSS VSS sg13_lv_nmos ad=71.99999f pd=0.865u as=0.1371p ps=1.12u w=0.64u l=0.13u
X5 VDD a_66_116# a_528_550# VDD sg13_lv_pmos ad=1.30835p pd=9.07u as=54.6f ps=0.68u w=0.42u l=0.13u
X6 GCLK a_1034_435# VDD VDD sg13_lv_pmos ad=0.3808p pd=2.92u as=0.3129p ps=1.75u w=1.12u l=0.13u
X7 a_357_380# a_363_86# VSS VSS sg13_lv_nmos ad=0.2516p pd=2.16u as=0.13557p ps=1.215u w=0.74u l=0.13u
X8 a_1034_435# a_66_116# a_1028_158# VSS sg13_lv_nmos ad=0.2176p pd=1.96u as=71.99999f ps=0.865u w=0.64u l=0.13u
X9 a_315_122# GATE VSS VSS sg13_lv_nmos ad=76.8f pd=0.88u as=0.23012p ps=1.445u w=0.64u l=0.13u
X10 a_134_80# a_357_380# a_302_434# VDD sg13_lv_pmos ad=0.20445p pd=1.58u as=0.145p ps=1.29u w=1u l=0.13u
X11 a_528_550# a_363_86# a_134_80# VDD sg13_lv_pmos ad=54.6f pd=0.68u as=0.20445p ps=1.58u w=0.42u l=0.13u
X12 VDD a_134_80# a_66_116# VDD sg13_lv_pmos ad=0.3102p pd=1.7u as=0.3808p ps=2.92u w=1.12u l=0.13u
X13 a_134_80# a_363_86# a_315_122# VSS sg13_lv_nmos ad=0.141p pd=1.17u as=76.8f ps=0.88u w=0.64u l=0.13u
X14 a_302_434# GATE VDD VDD sg13_lv_pmos ad=0.145p pd=1.29u as=0.3102p ps=1.7u w=1u l=0.13u
X15 VDD CLK a_363_86# VDD sg13_lv_pmos ad=0.1596p pd=1.22u as=0.2856p ps=2.36u w=0.84u l=0.13u
X16 VSS a_134_80# a_66_116# VSS sg13_lv_nmos ad=0.23012p pd=1.445u as=0.2516p ps=2.16u w=0.74u l=0.13u
X17 a_1034_435# CLK VDD VDD sg13_lv_pmos ad=0.1596p pd=1.22u as=0.1596p ps=1.22u w=0.84u l=0.13u
X18 VDD a_66_116# a_1034_435# VDD sg13_lv_pmos ad=0.3129p pd=1.75u as=0.1596p ps=1.22u w=0.84u l=0.13u
X19 VSS a_66_116# a_521_166# VSS sg13_lv_nmos ad=0.13557p pd=1.215u as=54.6f ps=0.68u w=0.42u l=0.13u
.ends

.subckt sg13cmos5l_or4_1 X A B C D VDD VSS
X0 VSS A a_72_436# VSS sg13_lv_nmos ad=0.14135p pd=1.14u as=0.1045p ps=0.93u w=0.55u l=0.13u
X1 a_166_436# D a_72_436# VDD sg13_lv_pmos ad=0.19p pd=1.38u as=0.34p ps=2.68u w=1u l=0.13u
X2 a_268_436# C a_166_436# VDD sg13_lv_pmos ad=0.2925p pd=1.585u as=0.19p ps=1.38u w=1u l=0.13u
X3 a_411_436# B a_268_436# VDD sg13_lv_pmos ad=0.19p pd=1.38u as=0.2925p ps=1.585u w=1u l=0.13u
X4 X a_72_436# VSS VSS sg13_lv_nmos ad=0.2516p pd=2.16u as=0.14135p ps=1.14u w=0.74u l=0.13u
X5 a_72_436# D VSS VSS sg13_lv_nmos ad=0.1045p pd=0.93u as=0.187p ps=1.78u w=0.55u l=0.13u
X6 VDD A a_411_436# VDD sg13_lv_pmos ad=0.2144p pd=1.52u as=0.19p ps=1.38u w=1u l=0.13u
X7 X a_72_436# VDD VDD sg13_lv_pmos ad=0.3808p pd=2.92u as=0.2144p ps=1.52u w=1.12u l=0.13u
X8 VSS C a_72_436# VSS sg13_lv_nmos ad=0.16755p pd=1.165u as=0.1045p ps=0.93u w=0.55u l=0.13u
X9 a_72_436# B VSS VSS sg13_lv_nmos ad=0.1045p pd=0.93u as=0.16755p ps=1.165u w=0.55u l=0.13u
.ends

.subckt sg13cmos5l_dfrbpq_1 Q CLK D RESET_B VDD VSS
X0 a_550_127# RESET_B VSS VSS sg13_lv_nmos ad=37.8f pd=0.6u as=0.1701p ps=1.65u w=0.42u l=0.13u
X1 a_298_337# a_741_93# a_681_505# VDD sg13_lv_pmos ad=79.8f pd=0.8u as=63f ps=0.72u w=0.42u l=0.13u
X2 a_1840_334# a_1583_191# a_2002_114# VSS sg13_lv_nmos ad=0.1428p pd=1.52u as=37.8f ps=0.6u w=0.42u l=0.13u
X3 a_38_114# a_843_236# a_298_337# VDD sg13_lv_pmos ad=0.1428p pd=1.52u as=79.8f ps=0.8u w=0.42u l=0.13u
X4 a_741_93# CLK VSS VSS sg13_lv_nmos ad=0.2516p pd=2.16u as=2.26778p ps=14.665u w=0.74u l=0.13u
X5 a_38_114# D VDD VDD sg13_lv_pmos ad=79.8f pd=0.8u as=0.1428p ps=1.52u w=0.42u l=0.13u
X6 a_741_93# CLK VDD VDD sg13_lv_pmos ad=0.4088p pd=2.97u as=1.12285p ps=7.26u w=1.12u l=0.13u
X7 VSS a_741_93# a_843_236# VSS sg13_lv_nmos ad=2.26778p pd=14.665u as=0.2516p ps=2.16u w=0.74u l=0.13u
X8 VSS a_1840_334# a_1489_191# VSS sg13_lv_nmos ad=79.8f pd=0.8u as=0.1428p ps=1.52u w=0.42u l=0.13u
X9 VDD RESET_B a_38_114# VDD sg13_lv_pmos ad=0.36237p pd=2.605u as=79.8f ps=0.8u w=0.42u l=0.13u
X10 a_324_432# a_298_337# VSS VSS sg13_lv_nmos ad=0.2516p pd=2.16u as=0.1626p ps=1.415u w=0.74u l=0.13u
X11 VDD a_741_93# a_843_236# VDD sg13_lv_pmos ad=1.12285p pd=7.26u as=0.3864p ps=2.93u w=1.12u l=0.13u
X12 a_2002_114# RESET_B VSS VSS sg13_lv_nmos ad=37.8f pd=0.6u as=79.8f ps=0.8u w=0.42u l=0.13u
X13 VDD a_1583_191# a_2250_412# VDD sg13_lv_pmos ad=0.2128p pd=1.5u as=0.3864p ps=2.93u w=1.12u l=0.13u
X14 Q a_2250_412# VDD VDD sg13_lv_pmos ad=0.3808p pd=2.92u as=0.2128p ps=1.5u w=1.12u l=0.13u
X15 a_132_114# D a_38_114# VSS sg13_lv_nmos ad=60.89999f pd=0.71u as=0.1428p ps=1.52u w=0.42u l=0.13u
X16 a_1785_429# a_843_236# a_1583_191# VDD sg13_lv_pmos ad=93.45f pd=0.865u as=0.2048p ps=1.63u w=0.42u l=0.13u
X17 VDD a_1583_191# a_1840_334# VDD sg13_lv_pmos ad=1.12285p pd=7.26u as=79.8f ps=0.8u w=0.42u l=0.13u
X18 a_1583_191# a_741_93# a_324_432# VDD sg13_lv_pmos ad=0.2048p pd=1.63u as=0.34p ps=2.68u w=1u l=0.13u
X19 a_1583_191# a_741_93# a_1489_191# VSS sg13_lv_nmos ad=0.12665p pd=1.145u as=0.1428p ps=1.52u w=0.42u l=0.13u
X20 VDD a_1840_334# a_1785_429# VDD sg13_lv_pmos ad=1.12285p pd=7.26u as=93.45f ps=0.865u w=0.42u l=0.13u
X21 a_1840_334# RESET_B VDD VDD sg13_lv_pmos ad=79.8f pd=0.8u as=1.12285p ps=7.26u w=0.42u l=0.13u
X22 a_324_432# a_843_236# a_1583_191# VSS sg13_lv_nmos ad=0.3473p pd=2.71u as=0.12665p ps=1.145u w=0.74u l=0.13u
X23 a_298_337# a_741_93# a_38_114# VSS sg13_lv_nmos ad=79.8f pd=0.8u as=0.1296p ps=1.52u w=0.42u l=0.13u
X24 a_612_127# a_324_432# a_550_127# VSS sg13_lv_nmos ad=0.1428p pd=1.52u as=37.8f ps=0.6u w=0.42u l=0.13u
X25 a_681_505# a_324_432# VDD VDD sg13_lv_pmos ad=63f pd=0.72u as=0.1563p ps=1.22u w=0.42u l=0.13u
X26 a_612_127# a_843_236# a_298_337# VSS sg13_lv_nmos ad=0.2373p pd=1.97u as=79.8f ps=0.8u w=0.42u l=0.13u
X27 VSS a_1583_191# a_2250_412# VSS sg13_lv_nmos ad=0.1406p pd=1.12u as=0.2516p ps=2.16u w=0.74u l=0.13u
X28 a_324_432# a_298_337# VDD VDD sg13_lv_pmos ad=0.34p pd=2.68u as=0.36237p ps=2.605u w=1u l=0.13u
X29 Q a_2250_412# VSS VSS sg13_lv_nmos ad=0.2516p pd=2.16u as=0.1406p ps=1.12u w=0.74u l=0.13u
X30 VDD RESET_B a_298_337# VDD sg13_lv_pmos ad=0.1563p pd=1.22u as=0.147p ps=1.54u w=0.42u l=0.13u
X31 VSS RESET_B a_132_114# VSS sg13_lv_nmos ad=0.1626p pd=1.415u as=60.89999f ps=0.71u w=0.42u l=0.13u
.ends

.subckt user_project_control analog_ena[0] analog_ena[1] analog_ena[2] analog_ena[3]
+ clk dig_ena dig_in[0] dig_in[10] dig_in[11] dig_in[12] dig_in[13] dig_in[14] dig_in[15]
+ dig_in[16] dig_in[17] dig_in[18] dig_in[19] dig_in[1] dig_in[20] dig_in[21] dig_in[22]
+ dig_in[23] dig_in[2] dig_in[3] dig_in[4] dig_in[5] dig_in[6] dig_in[7] dig_in[8]
+ dig_in[9] dig_out[0] dig_out[10] dig_out[11] dig_out[1] dig_out[2] dig_out[3] dig_out[4]
+ dig_out[5] dig_out[6] dig_out[7] dig_out[8] dig_out[9] dig_out_relay[0] dig_out_relay[10]
+ dig_out_relay[11] dig_out_relay[1] dig_out_relay[2] dig_out_relay[3] dig_out_relay[4]
+ dig_out_relay[5] dig_out_relay[6] dig_out_relay[7] dig_out_relay[8] dig_out_relay[9]
+ enable ibias_ena[0] ibias_ena[1] power_1v2_ena power_3v3_ena proj_1v2_ena proj_3v3_ena
+ proj_addr[0] proj_addr[1] proj_addr[2] proj_addr[3] proj_addr[4] proj_analog_ena[0]
+ proj_analog_ena[1] proj_analog_ena[2] proj_analog_ena[3] proj_clk proj_dig_in[0]
+ proj_dig_in[10] proj_dig_in[11] proj_dig_in[12] proj_dig_in[13] proj_dig_in[14]
+ proj_dig_in[15] proj_dig_in[16] proj_dig_in[17] proj_dig_in[18] proj_dig_in[19]
+ proj_dig_in[1] proj_dig_in[20] proj_dig_in[21] proj_dig_in[22] proj_dig_in[23] proj_dig_in[2]
+ proj_dig_in[3] proj_dig_in[4] proj_dig_in[5] proj_dig_in[6] proj_dig_in[7] proj_dig_in[8]
+ proj_dig_in[9] proj_dig_out[0] proj_dig_out[10] proj_dig_out[11] proj_dig_out[1]
+ proj_dig_out[2] proj_dig_out[3] proj_dig_out[4] proj_dig_out[5] proj_dig_out[6]
+ proj_dig_out[7] proj_dig_out[8] proj_dig_out[9] proj_ena proj_ibias_ena[0] proj_ibias_ena[1]
+ proj_reset proj_sel[0] proj_sel[1] proj_sel[2] proj_sel[3] proj_sel[4] proj_vbias_ena
+ reset vbias_ena vddd vssd
Xuserbuffers\[1\] proj_dig_in[1] userbuffers\[1\]/A vddd vssd sg13cmos5l_buf_8
XFILLER_10_158 vddd vssd sg13cmos5l_decap_8
XFILLER_12_21 vddd vssd sg13cmos5l_decap_8
Xtiedowns\[31\] dig_in[7] vddd vssd sg13cmos5l_antennanp
XFILLER_2_198 vddd vssd sg13cmos5l_decap_8
X_49_ _49_/X proj_dig_out[10] dig_out_relay[10] _50_/S vddd vssd sg13cmos5l_mux2_1
Xfanout7 fanout7/X fanout8/X vddd vssd sg13cmos5l_buf_1
Xoutbuffers\[6\] dig_out[6] _45_/X vddd vssd sg13cmos5l_buf_4
XFILLER_11_0 vddd vssd sg13cmos5l_decap_8
Xtiedowns\[61\] proj_sel[0] vddd vssd sg13cmos5l_antennanp
XFILLER_13_112 vddd vssd sg13cmos5l_decap_8
XFILLER_8_193 vddd vssd sg13cmos5l_decap_8
Xuserbuffers\[12\] proj_dig_in[12] userbuffers\[12\]/A vddd vssd sg13cmos5l_buf_8
XFILLER_10_137 vddd vssd sg13cmos5l_decap_8
XFILLER_12_77 vddd vssd sg13cmos5l_decap_8
XFILLER_12_99 vddd vssd sg13cmos5l_decap_8
Xdig_in_gen\[9\].dig_in_latch userbuffers\[9\]/A dig_in[9] _14_/A fanout6/X vddd vssd
+ sg13cmos5l_dlhrq_1
Xtiedowns\[24\] dig_in[0] vddd vssd sg13cmos5l_antennanp
X_48_ _48_/X proj_dig_out[9] dig_out_relay[9] _50_/S vddd vssd sg13cmos5l_mux2_1
Xtiedowns\[8\] proj_dig_out[8] vddd vssd sg13cmos5l_antennanp
Xfanout8 fanout8/X _26_/Y vddd vssd sg13cmos5l_buf_1
Xswitchbuffers\[2\] proj_ibias_ena[1] _37_/X vddd vssd sg13cmos5l_buf_4
XFILLER_9_117 vddd vssd sg13cmos5l_decap_8
Xtiedowns\[54\] analog_ena[1] vddd vssd sg13cmos5l_antennanp
Xdig_in_gen\[12\].dig_in_latch userbuffers\[12\]/A dig_in[12] _14_/A fanout5/X vddd
+ vssd sg13cmos5l_dlhrq_1
XFILLER_3_47 vddd vssd sg13cmos5l_decap_8
XFILLER_10_116 vddd vssd sg13cmos5l_decap_8
XFILLER_12_56 vddd vssd sg13cmos5l_decap_8
XFILLER_2_101 vddd vssd sg13cmos5l_decap_4
Xtiedowns\[17\] dig_out_relay[5] vddd vssd sg13cmos5l_antennanp
XFILLER_9_46 vddd vssd sg13cmos5l_decap_8
X_47_ _47_/X proj_dig_out[8] dig_out_relay[8] _50_/S vddd vssd sg13cmos5l_mux2_1
Xfanout9 fanout9/X fanout9/A vddd vssd sg13cmos5l_buf_1
XFILLER_1_0 vddd vssd sg13cmos5l_decap_8
XFILLER_13_147 vddd vssd sg13cmos5l_decap_8
Xtiedowns\[47\] dig_in[23] vddd vssd sg13cmos5l_antennanp
XFILLER_5_198 vddd vssd sg13cmos5l_decap_8
X_46_ _46_/X proj_dig_out[7] dig_out_relay[7] _50_/S vddd vssd sg13cmos5l_mux2_1
Xdig_in_gen\[5\].dig_in_latch userbuffers\[5\]/A dig_in[5] fanout12/X fanout6/X vddd
+ vssd sg13cmos5l_dlhrq_1
X_29_ _29_/X analog_ena[2] _37_/B vddd vssd sg13cmos5l_and2_1
XFILLER_0_200 vddd vssd sg13cmos5l_decap_4
Xoutbuffers\[4\] dig_out[4] _43_/X vddd vssd sg13cmos5l_buf_4
XFILLER_12_14 vddd vssd sg13cmos5l_decap_8
XFILLER_5_177 vddd vssd sg13cmos5l_decap_4
Xuserbuffers\[10\] proj_dig_in[10] userbuffers\[10\]/A vddd vssd sg13cmos5l_buf_8
X_45_ _45_/X proj_dig_out[6] dig_out_relay[6] _50_/S vddd vssd sg13cmos5l_mux2_1
Xtiedowns\[22\] dig_out_relay[10] vddd vssd sg13cmos5l_antennanp
Xclkload0 clkload0/X clkload0/A vddd vssd sg13cmos5l_buf_4
X_28_ _28_/X analog_ena[1] _37_/B vddd vssd sg13cmos5l_and2_1
Xtiedowns\[6\] proj_dig_out[6] vddd vssd sg13cmos5l_antennanp
XFILLER_6_49 vddd vssd sg13cmos5l_decap_4
XFILLER_13_7 vddd vssd sg13cmos5l_decap_8
Xswitchbuffers\[0\] proj_vbias_ena _35_/X vddd vssd sg13cmos5l_buf_4
XFILLER_13_105 vddd vssd sg13cmos5l_decap_8
Xtiedowns\[52\] ibias_ena[1] vddd vssd sg13cmos5l_antennanp
XFILLER_5_112 vddd vssd sg13cmos5l_decap_8
XFILLER_13_91 vddd vssd sg13cmos5l_decap_8
X_44_ _44_/X proj_dig_out[5] dig_out_relay[5] _44_/S vddd vssd sg13cmos5l_mux2_1
Xtiedowns\[15\] dig_out_relay[3] vddd vssd sg13cmos5l_antennanp
X_27_ _27_/X analog_ena[0] _37_/B vddd vssd sg13cmos5l_and2_1
Xdig_in_gen\[1\].dig_in_latch userbuffers\[1\]/A dig_in[1] fanout12/X fanout6/X vddd
+ vssd sg13cmos5l_dlhrq_1
XFILLER_10_81 vddd vssd sg13cmos5l_decap_8
XFILLER_7_82 vddd vssd sg13cmos5l_decap_4
XFILLER_8_121 vddd vssd sg13cmos5l_decap_8
XFILLER_12_150 vddd vssd sg13cmos5l_decap_8
XFILLER_10_109 vddd vssd sg13cmos5l_decap_8
Xtiedowns\[45\] dig_in[21] vddd vssd sg13cmos5l_antennanp
XFILLER_4_50 vddd vssd sg13cmos5l_decap_4
XFILLER_9_39 vddd vssd sg13cmos5l_decap_8
XFILLER_13_70 vddd vssd sg13cmos5l_decap_8
X_43_ _43_/X proj_dig_out[4] dig_out_relay[4] _44_/S vddd vssd sg13cmos5l_mux2_1
X_26_ _26_/Y _38_/B _38_/C _38_/D vddd vssd sg13cmos5l_nor3_1
Xhold14 hold16/A hold15/X vddd vssd sg13cmos5l_dlygate4sd3_1
XFILLER_10_60 vddd vssd sg13cmos5l_decap_8
Xuserbuffers\[8\] proj_dig_in[8] userbuffers\[8\]/A vddd vssd sg13cmos5l_buf_8
Xuserbuffers\[26\] proj_clk clockgate/GCLK vddd vssd sg13cmos5l_buf_8
XFILLER_12_28 vddd vssd sg13cmos5l_decap_4
Xdig_in_gen\[19\].dig_in_latch userbuffers\[19\]/A dig_in[19] fanout10/X _36_/B vddd
+ vssd sg13cmos5l_dlhrq_1
Xoutbuffers\[2\] dig_out[2] _41_/X vddd vssd sg13cmos5l_buf_4
Xtiedowns\[38\] dig_in[14] vddd vssd sg13cmos5l_antennanp
XFILLER_4_191 vddd vssd sg13cmos5l_decap_8
XFILLER_1_194 vddd vssd sg13cmos5l_decap_8
X_42_ _42_/X proj_dig_out[3] dig_out_relay[3] _44_/S vddd vssd sg13cmos5l_mux2_1
X_25_ _38_/D _25_/A _25_/B _25_/C _25_/D vddd vssd sg13cmos5l_nand4_1
Xtiedowns\[20\] dig_out_relay[8] vddd vssd sg13cmos5l_antennanp
Xhold15 hold15/X _51_/Q vddd vssd sg13cmos5l_dlygate4sd3_1
Xtiedowns\[4\] proj_dig_out[4] vddd vssd sg13cmos5l_antennanp
XFILLER_11_7 vddd vssd sg13cmos5l_decap_4
Xtiedowns\[68\] proj_addr[2] vddd vssd sg13cmos5l_antennanp
Xclkbuf_0_clk clkbuf_0_clk/X clk vddd vssd sg13cmos5l_buf_8
Xuserbuffers\[19\] proj_dig_in[19] userbuffers\[19\]/A vddd vssd sg13cmos5l_buf_8
XFILLER_13_119 vddd vssd sg13cmos5l_decap_8
XFILLER_5_126 vddd vssd sg13cmos5l_decap_8
Xtiedowns\[50\] vbias_ena vddd vssd sg13cmos5l_antennanp
X_41_ _41_/X proj_dig_out[2] dig_out_relay[2] _44_/S vddd vssd sg13cmos5l_mux2_1
X_24_ _38_/C _24_/A _24_/B _24_/C _24_/D vddd vssd sg13cmos5l_nand4_1
Xhold16 _52_/D hold16/A vddd vssd sg13cmos5l_dlygate4sd3_1
Xtiedowns\[13\] dig_out_relay[1] vddd vssd sg13cmos5l_antennanp
XFILLER_10_95 vddd vssd sg13cmos5l_decap_8
Xclkbuf_regs_0_clk clkbuf_regs_0_clk/X clk vddd vssd sg13cmos5l_buf_8
Xdig_in_gen\[22\].dig_in_latch userbuffers\[22\]/A dig_in[22] fanout9/X fanout8/X
+ vddd vssd sg13cmos5l_dlhrq_1
Xtiedowns\[43\] dig_in[19] vddd vssd sg13cmos5l_antennanp
Xdig_in_gen\[15\].dig_in_latch userbuffers\[15\]/A dig_in[15] fanout9/X fanout5/X
+ vddd vssd sg13cmos5l_dlhrq_1
XFILLER_8_0 vddd vssd sg13cmos5l_decap_8
XFILLER_13_84 vddd vssd sg13cmos5l_decap_8
X_40_ _40_/X proj_dig_out[1] dig_out_relay[1] _50_/S vddd vssd sg13cmos5l_mux2_1
X_23_ _38_/B proj_addr[0] proj_sel[0] vddd vssd sg13cmos5l_xor2_1
XFILLER_10_74 vddd vssd sg13cmos5l_decap_8
XFILLER_7_75 vddd vssd sg13cmos5l_decap_8
Xuserbuffers\[6\] proj_dig_in[6] userbuffers\[6\]/A vddd vssd sg13cmos5l_buf_8
XFILLER_8_114 vddd vssd sg13cmos5l_decap_8
Xuserbuffers\[24\] proj_reset _52_/Q vddd vssd sg13cmos5l_buf_8
XFILLER_7_191 vddd vssd sg13cmos5l_decap_8
XFILLER_4_43 vddd vssd sg13cmos5l_decap_8
Xoutbuffers\[0\] dig_out[0] _39_/X vddd vssd sg13cmos5l_buf_4
XFILLER_13_63 vddd vssd sg13cmos5l_decap_8
Xtiedowns\[36\] dig_in[12] vddd vssd sg13cmos5l_antennanp
X_22_ _24_/D proj_sel[2] proj_addr[2] vddd vssd sg13cmos5l_nand2b_1
XFILLER_10_53 vddd vssd sg13cmos5l_decap_8
Xdig_in_gen\[8\].dig_in_latch userbuffers\[8\]/A dig_in[8] _14_/A fanout6/X vddd vssd
+ sg13cmos5l_dlhrq_1
Xtiedowns\[2\] proj_dig_out[2] vddd vssd sg13cmos5l_antennanp
Xtiedowns\[66\] proj_addr[0] vddd vssd sg13cmos5l_antennanp
Xuserbuffers\[17\] proj_dig_in[17] userbuffers\[17\]/A vddd vssd sg13cmos5l_buf_8
Xfanout10 fanout10/X fanout9/A vddd vssd sg13cmos5l_buf_1
XFILLER_13_42 vddd vssd sg13cmos5l_decap_8
Xtiedowns\[29\] dig_in[5] vddd vssd sg13cmos5l_antennanp
X_21_ _25_/D proj_addr[4] proj_sel[4] vddd vssd sg13cmos5l_nand2b_1
Xdig_in_gen\[11\].dig_in_latch userbuffers\[11\]/A dig_in[11] _14_/A fanout5/X vddd
+ vssd sg13cmos5l_dlhrq_1
Xswitchbuffers\[7\] proj_1v2_ena _31_/X vddd vssd sg13cmos5l_buf_4
Xtiedowns\[11\] proj_dig_out[11] vddd vssd sg13cmos5l_antennanp
Xtiedowns\[59\] fanout9/X vddd vssd sg13cmos5l_antennanp
XFILLER_5_119 vddd vssd sg13cmos5l_decap_8
Xfanout11 _14_/A fanout9/A vddd vssd sg13cmos5l_buf_1
XFILLER_13_21 vddd vssd sg13cmos5l_decap_8
XFILLER_13_98 vddd vssd sg13cmos5l_decap_8
XFILLER_6_0 vddd vssd sg13cmos5l_decap_8
Xtiedowns\[41\] dig_in[17] vddd vssd sg13cmos5l_antennanp
X_20_ _24_/C proj_sel[4] proj_addr[4] vddd vssd sg13cmos5l_nand2b_1
XFILLER_10_88 vddd vssd sg13cmos5l_decap_8
XFILLER_12_157 vddd vssd sg13cmos5l_decap_4
XFILLER_8_128 vddd vssd sg13cmos5l_decap_8
Xdig_in_gen\[4\].dig_in_latch userbuffers\[4\]/A dig_in[4] fanout12/X fanout7/X vddd
+ vssd sg13cmos5l_dlhrq_1
Xuserbuffers\[4\] proj_dig_in[4] userbuffers\[4\]/A vddd vssd sg13cmos5l_buf_8
Xuserbuffers\[22\] proj_dig_in[22] userbuffers\[22\]/A vddd vssd sg13cmos5l_buf_8
Xfanout12 fanout12/X fanout9/A vddd vssd sg13cmos5l_buf_1
XFILLER_13_77 vddd vssd sg13cmos5l_decap_8
Xtiedowns\[34\] dig_in[10] vddd vssd sg13cmos5l_antennanp
XFILLER_10_67 vddd vssd sg13cmos5l_decap_8
Xclockgate clockgate/GCLK clockgate/CLK _36_/B vddd vssd sg13cmos5l_lgcp_1
Xoutbuffers\[9\] dig_out[9] _48_/X vddd vssd sg13cmos5l_buf_4
Xtiedowns\[0\] proj_dig_out[0] vddd vssd sg13cmos5l_antennanp
Xtiedowns\[64\] proj_sel[3] vddd vssd sg13cmos5l_antennanp
XFILLER_4_110 vddd vssd sg13cmos5l_decap_8
XFILLER_4_198 vddd vssd sg13cmos5l_decap_8
Xuserbuffers\[15\] proj_dig_in[15] userbuffers\[15\]/A vddd vssd sg13cmos5l_buf_8
Xfanout13 fanout9/A dig_ena vddd vssd sg13cmos5l_buf_1
XFILLER_13_56 vddd vssd sg13cmos5l_decap_8
Xtiedowns\[27\] dig_in[3] vddd vssd sg13cmos5l_antennanp
Xoutbuffers\[10\] dig_out[10] _49_/X vddd vssd sg13cmos5l_buf_4
XFILLER_10_46 vddd vssd sg13cmos5l_decap_8
Xswitchbuffers\[5\] proj_analog_ena[2] _29_/X vddd vssd sg13cmos5l_buf_4
Xtiedowns\[57\] reset vddd vssd sg13cmos5l_antennanp
Xdig_in_gen\[0\].dig_in_latch userbuffers\[0\]/A dig_in[0] _14_/A fanout6/X vddd vssd
+ sg13cmos5l_dlhrq_1
XFILLER_13_35 vddd vssd sg13cmos5l_decap_8
XFILLER_4_0 vddd vssd sg13cmos5l_decap_8
XFILLER_7_131 vddd vssd sg13cmos5l_decap_8
XFILLER_4_178 vddd vssd sg13cmos5l_decap_4
XFILLER_13_14 vddd vssd sg13cmos5l_decap_8
XFILLER_8_7 vddd vssd sg13cmos5l_decap_8
Xuserbuffers\[2\] proj_dig_in[2] userbuffers\[2\]/A vddd vssd sg13cmos5l_buf_8
Xuserbuffers\[20\] proj_dig_in[20] userbuffers\[20\]/A vddd vssd sg13cmos5l_buf_8
Xdig_in_gen\[18\].dig_in_latch userbuffers\[18\]/A dig_in[18] fanout10/X fanout5/X
+ vddd vssd sg13cmos5l_dlhrq_1
Xtiedowns\[32\] dig_in[8] vddd vssd sg13cmos5l_antennanp
XFILLER_12_106 vddd vssd sg13cmos5l_decap_4
XFILLER_7_110 vddd vssd sg13cmos5l_decap_8
XFILLER_7_198 vddd vssd sg13cmos5l_decap_8
Xoutbuffers\[7\] dig_out[7] _46_/X vddd vssd sg13cmos5l_buf_4
XFILLER_12_0 vddd vssd sg13cmos5l_decap_8
Xtiedowns\[62\] proj_sel[1] vddd vssd sg13cmos5l_antennanp
XFILLER_0_193 vddd vssd sg13cmos5l_decap_8
Xuserbuffers\[13\] proj_dig_in[13] userbuffers\[13\]/A vddd vssd sg13cmos5l_buf_8
Xtiedowns\[25\] dig_in[1] vddd vssd sg13cmos5l_antennanp
XFILLER_2_94 vddd vssd sg13cmos5l_decap_8
Xtiedowns\[9\] proj_dig_out[9] vddd vssd sg13cmos5l_antennanp
XFILLER_11_92 vddd vssd sg13cmos5l_decap_8
Xswitchbuffers\[3\] proj_analog_ena[0] _27_/X vddd vssd sg13cmos5l_buf_4
XFILLER_11_162 vddd vssd sg13cmos5l_decap_8
XFILLER_11_195 vddd vssd sg13cmos5l_decap_8
XFILLER_8_71 vddd vssd sg13cmos5l_decap_4
XFILLER_4_29 vddd vssd sg13cmos5l_decap_4
XFILLER_4_103 vddd vssd sg13cmos5l_decap_8
XFILLER_3_191 vddd vssd sg13cmos5l_decap_8
XFILLER_13_49 vddd vssd sg13cmos5l_decap_8
Xtiedowns\[55\] analog_ena[2] vddd vssd sg13cmos5l_antennanp
Xdig_in_gen\[21\].dig_in_latch userbuffers\[21\]/A dig_in[21] fanout9/X _36_/B vddd
+ vssd sg13cmos5l_dlhrq_1
XFILLER_10_39 vddd vssd sg13cmos5l_decap_8
Xtiedowns\[18\] dig_out_relay[6] vddd vssd sg13cmos5l_antennanp
Xdig_in_gen\[14\].dig_in_latch userbuffers\[14\]/A dig_in[14] fanout9/X fanout5/X
+ vddd vssd sg13cmos5l_dlhrq_1
XFILLER_2_0 vddd vssd sg13cmos5l_decap_8
XFILLER_11_71 vddd vssd sg13cmos5l_decap_8
XFILLER_11_141 vddd vssd sg13cmos5l_decap_8
XFILLER_8_50 vddd vssd sg13cmos5l_decap_8
XFILLER_13_28 vddd vssd sg13cmos5l_decap_8
Xtiedowns\[48\] power_1v2_ena vddd vssd sg13cmos5l_antennanp
Xuserbuffers\[0\] proj_dig_in[0] userbuffers\[0\]/A vddd vssd sg13cmos5l_buf_8
Xtiedowns\[30\] dig_in[6] vddd vssd sg13cmos5l_antennanp
XFILLER_11_50 vddd vssd sg13cmos5l_decap_8
X_39_ _39_/X proj_dig_out[0] dig_out_relay[0] _50_/S vddd vssd sg13cmos5l_mux2_1
Xclkbuf_1_0__f_clk clkload0/A clkbuf_0_clk/X vddd vssd sg13cmos5l_buf_8
XFILLER_7_179 vddd vssd sg13cmos5l_decap_4
XFILLER_7_124 vddd vssd sg13cmos5l_decap_8
Xoutbuffers\[5\] dig_out[5] _44_/X vddd vssd sg13cmos5l_buf_4
Xdig_in_gen\[7\].dig_in_latch userbuffers\[7\]/A dig_in[7] _14_/A fanout6/X vddd vssd
+ sg13cmos5l_dlhrq_1
XFILLER_10_0 vddd vssd sg13cmos5l_decap_8
Xtiedowns\[60\] clkload0/A vddd vssd sg13cmos5l_antennanp
Xuserbuffers\[11\] proj_dig_in[11] userbuffers\[11\]/A vddd vssd sg13cmos5l_buf_8
Xtiedowns\[23\] dig_out_relay[11] vddd vssd sg13cmos5l_antennanp
X_38_ _38_/X _38_/A _38_/B _38_/C _38_/D vddd vssd sg13cmos5l_or4_1
Xtiedowns\[7\] proj_dig_out[7] vddd vssd sg13cmos5l_antennanp
Xdig_in_gen\[10\].dig_in_latch userbuffers\[10\]/A dig_in[10] _14_/A fanout5/X vddd
+ vssd sg13cmos5l_dlhrq_1
XFILLER_7_103 vddd vssd sg13cmos5l_decap_8
Xswitchbuffers\[1\] proj_ibias_ena[0] _36_/X vddd vssd sg13cmos5l_buf_4
XFILLER_4_117 vddd vssd sg13cmos5l_decap_8
XFILLER_5_64 vddd vssd sg13cmos5l_decap_4
XFILLER_0_142 vddd vssd sg13cmos5l_decap_8
XFILLER_0_186 vddd vssd sg13cmos5l_decap_8
Xtiedowns\[53\] analog_ena[0] vddd vssd sg13cmos5l_antennanp
XFILLER_2_65 vddd vssd sg13cmos5l_decap_8
Xtiedowns\[16\] dig_out_relay[4] vddd vssd sg13cmos5l_antennanp
XFILLER_11_85 vddd vssd sg13cmos5l_decap_8
X_37_ _37_/X ibias_ena[1] _37_/B vddd vssd sg13cmos5l_and2_1
XFILLER_0_0 vddd vssd sg13cmos5l_decap_8
XFILLER_11_155 vddd vssd sg13cmos5l_decap_8
XFILLER_6_192 vddd vssd sg13cmos5l_decap_8
XFILLER_8_64 vddd vssd sg13cmos5l_decap_8
XFILLER_0_121 vddd vssd sg13cmos5l_decap_8
Xtiedowns\[46\] dig_in[22] vddd vssd sg13cmos5l_antennanp
Xdig_in_gen\[3\].dig_in_latch userbuffers\[3\]/A dig_in[3] fanout12/X fanout6/X vddd
+ vssd sg13cmos5l_dlhrq_1
XFILLER_4_7 vddd vssd sg13cmos5l_decap_8
XFILLER_11_64 vddd vssd sg13cmos5l_decap_8
X_36_ _36_/X ibias_ena[0] _36_/B vddd vssd sg13cmos5l_and2_1
XFILLER_7_138 vddd vssd sg13cmos5l_decap_4
XFILLER_11_134 vddd vssd sg13cmos5l_decap_8
XFILLER_8_43 vddd vssd sg13cmos5l_decap_8
X_19_ _25_/C proj_sel[3] proj_addr[3] vddd vssd sg13cmos5l_nand2b_1
Xuserbuffers\[9\] proj_dig_in[9] userbuffers\[9\]/A vddd vssd sg13cmos5l_buf_8
XFILLER_8_200 vddd vssd sg13cmos5l_decap_4
Xoutbuffers\[3\] dig_out[3] _42_/X vddd vssd sg13cmos5l_buf_4
Xtiedowns\[39\] dig_in[15] vddd vssd sg13cmos5l_antennanp
Xclkbuf_0_clk_regs clkbuf_0_clk_regs/X clkbuf_regs_0_clk/X vddd vssd sg13cmos5l_buf_8
X_52_ _52_/Q _52_/CLK _52_/D enable vddd vssd sg13cmos5l_dfrbpq_1
XFILLER_11_43 vddd vssd sg13cmos5l_decap_8
X_35_ _35_/X vbias_ena _36_/B vddd vssd sg13cmos5l_and2_1
XFILLER_7_117 vddd vssd sg13cmos5l_decap_8
XFILLER_9_191 vddd vssd sg13cmos5l_decap_8
Xtiedowns\[21\] dig_out_relay[9] vddd vssd sg13cmos5l_antennanp
X_18_ _25_/B proj_addr[1] proj_sel[1] vddd vssd sg13cmos5l_nand2b_1
Xtiedowns\[5\] proj_dig_out[5] vddd vssd sg13cmos5l_antennanp
Xtiedowns\[69\] proj_addr[3] vddd vssd sg13cmos5l_antennanp
XFILLER_12_7 vddd vssd sg13cmos5l_decap_8
XFILLER_5_34 vddd vssd sg13cmos5l_decap_4
Xtiedowns\[51\] ibias_ena[0] vddd vssd sg13cmos5l_antennanp
X_51_ _51_/Q _51_/CLK _51_/D enable vddd vssd sg13cmos5l_dfrbpq_1
XFILLER_11_99 vddd vssd sg13cmos5l_decap_8
X_34_ _51_/D reset _37_/B vddd vssd sg13cmos5l_and2_1
Xtiedowns\[14\] dig_out_relay[2] vddd vssd sg13cmos5l_antennanp
X_17_ _25_/A proj_addr[2] proj_sel[2] vddd vssd sg13cmos5l_nand2b_1
XFILLER_10_191 vddd vssd sg13cmos5l_decap_8
XFILLER_3_198 vddd vssd sg13cmos5l_decap_8
XFILLER_0_102 vddd vssd sg13cmos5l_decap_8
XFILLER_0_135 vddd vssd sg13cmos5l_decap_8
Xtiedowns\[44\] dig_in[20] vddd vssd sg13cmos5l_antennanp
XFILLER_2_58 vddd vssd sg13cmos5l_decap_8
XFILLER_9_0 vddd vssd sg13cmos5l_decap_8
X_50_ _50_/X proj_dig_out[11] dig_out_relay[11] _50_/S vddd vssd sg13cmos5l_mux2_1
XFILLER_2_7 vddd vssd sg13cmos5l_decap_8
XFILLER_11_78 vddd vssd sg13cmos5l_decap_8
X_33_ _33_/X enable _36_/B vddd vssd sg13cmos5l_and2_1
XFILLER_11_148 vddd vssd sg13cmos5l_decap_8
X_16_ _24_/B proj_sel[1] proj_addr[1] vddd vssd sg13cmos5l_nand2b_1
XFILLER_6_185 vddd vssd sg13cmos5l_decap_8
XFILLER_8_57 vddd vssd sg13cmos5l_decap_8
Xdig_in_gen\[17\].dig_in_latch userbuffers\[17\]/A dig_in[17] fanout10/X fanout5/X
+ vddd vssd sg13cmos5l_dlhrq_1
XFILLER_3_177 vddd vssd sg13cmos5l_decap_4
XFILLER_3_100 vddd vssd sg13cmos5l_decap_8
XFILLER_0_114 vddd vssd sg13cmos5l_decap_8
Xclkbuf_1_1__f_clk clockgate/CLK clkbuf_0_clk/X vddd vssd sg13cmos5l_buf_8
Xuserbuffers\[7\] proj_dig_in[7] userbuffers\[7\]/A vddd vssd sg13cmos5l_buf_8
Xuserbuffers\[25\] proj_ena _33_/X vddd vssd sg13cmos5l_buf_8
Xoutbuffers\[1\] dig_out[1] _40_/X vddd vssd sg13cmos5l_buf_4
Xtiedowns\[37\] dig_in[13] vddd vssd sg13cmos5l_antennanp
XFILLER_11_57 vddd vssd sg13cmos5l_decap_8
X_32_ _32_/X power_3v3_ena _37_/B vddd vssd sg13cmos5l_and2_1
X_15_ _24_/A proj_addr[3] proj_sel[3] vddd vssd sg13cmos5l_nand2b_1
Xtiedowns\[3\] proj_dig_out[3] vddd vssd sg13cmos5l_antennanp
Xtiedowns\[67\] proj_addr[1] vddd vssd sg13cmos5l_antennanp
XFILLER_10_7 vddd vssd sg13cmos5l_decap_4
Xuserbuffers\[18\] proj_dig_in[18] userbuffers\[18\]/A vddd vssd sg13cmos5l_buf_8
XFILLER_6_80 vddd vssd sg13cmos5l_decap_4
XFILLER_11_25 vddd vssd sg13cmos5l_decap_8
X_31_ _31_/X power_1v2_ena _37_/B vddd vssd sg13cmos5l_and2_1
Xdig_in_gen\[20\].dig_in_latch userbuffers\[20\]/A dig_in[20] fanout9/X _36_/B vddd
+ vssd sg13cmos5l_dlhrq_1
Xswitchbuffers\[8\] proj_3v3_ena _32_/X vddd vssd sg13cmos5l_buf_4
X_14_ _38_/A _14_/A vddd vssd sg13cmos5l_inv_1
Xtiedowns\[12\] dig_out_relay[0] vddd vssd sg13cmos5l_antennanp
XFILLER_0_60 vddd vssd sg13cmos5l_decap_8
Xdig_in_gen\[13\].dig_in_latch userbuffers\[13\]/A dig_in[13] fanout9/X fanout5/X
+ vddd vssd sg13cmos5l_dlhrq_1
XFILLER_7_0 vddd vssd sg13cmos5l_decap_4
Xtiedowns\[42\] dig_in[18] vddd vssd sg13cmos5l_antennanp
X_30_ _30_/X analog_ena[3] _37_/B vddd vssd sg13cmos5l_and2_1
XFILLER_6_199 vddd vssd sg13cmos5l_decap_4
XFILLER_0_7 vddd vssd sg13cmos5l_decap_8
XFILLER_10_151 vddd vssd sg13cmos5l_decap_8
XFILLER_2_191 vddd vssd sg13cmos5l_decap_8
XFILLER_0_128 vddd vssd sg13cmos5l_decap_8
Xuserbuffers\[5\] proj_dig_in[5] userbuffers\[5\]/A vddd vssd sg13cmos5l_buf_8
Xuserbuffers\[23\] proj_dig_in[23] userbuffers\[23\]/A vddd vssd sg13cmos5l_buf_8
XFILLER_1_201 vddd vssd sg13cmos5l_decap_4
Xtiedowns\[35\] dig_in[11] vddd vssd sg13cmos5l_antennanp
Xdig_in_gen\[6\].dig_in_latch userbuffers\[6\]/A dig_in[6] fanout12/X fanout7/X vddd
+ vssd sg13cmos5l_dlhrq_1
XFILLER_10_130 vddd vssd sg13cmos5l_decap_8
XFILLER_6_123 vddd vssd sg13cmos5l_decap_8
XFILLER_6_178 vddd vssd sg13cmos5l_decap_8
XFILLER_12_70 vddd vssd sg13cmos5l_decap_8
XFILLER_0_95 vddd vssd sg13cmos5l_decap_8
Xfanout1 _50_/S _38_/X vddd vssd sg13cmos5l_buf_1
Xtiedowns\[1\] proj_dig_out[1] vddd vssd sg13cmos5l_antennanp
Xtiedowns\[65\] proj_sel[4] vddd vssd sg13cmos5l_antennanp
Xclkbuf_1_1__f_clk_regs _52_/CLK clkbuf_0_clk_regs/X vddd vssd sg13cmos5l_buf_8
Xuserbuffers\[16\] proj_dig_in[16] userbuffers\[16\]/A vddd vssd sg13cmos5l_buf_8
Xtiedowns\[28\] dig_in[4] vddd vssd sg13cmos5l_antennanp
XFILLER_13_161 vddd vssd sg13cmos5l_decap_4
XFILLER_9_110 vddd vssd sg13cmos5l_decap_8
XFILLER_9_198 vddd vssd sg13cmos5l_decap_8
Xoutbuffers\[11\] dig_out[11] _50_/X vddd vssd sg13cmos5l_buf_4
XFILLER_8_29 vddd vssd sg13cmos5l_decap_4
Xswitchbuffers\[6\] proj_analog_ena[3] _30_/X vddd vssd sg13cmos5l_buf_4
XFILLER_0_74 vddd vssd sg13cmos5l_decap_8
Xclkbuf_1_0__f_clk_regs _51_/CLK clkbuf_0_clk_regs/X vddd vssd sg13cmos5l_buf_8
Xtiedowns\[10\] proj_dig_out[10] vddd vssd sg13cmos5l_antennanp
Xfanout2 _44_/S _38_/X vddd vssd sg13cmos5l_buf_1
Xtiedowns\[58\] enable vddd vssd sg13cmos5l_antennanp
XFILLER_13_140 vddd vssd sg13cmos5l_decap_8
XFILLER_13_195 vddd vssd sg13cmos5l_decap_8
Xtiedowns\[40\] dig_in[16] vddd vssd sg13cmos5l_antennanp
Xdig_in_gen\[2\].dig_in_latch userbuffers\[2\]/A dig_in[2] fanout12/X fanout6/X vddd
+ vssd sg13cmos5l_dlhrq_1
XFILLER_5_0 vddd vssd sg13cmos5l_decap_8
XFILLER_10_198 vddd vssd sg13cmos5l_decap_8
XFILLER_5_191 vddd vssd sg13cmos5l_decap_8
XFILLER_0_53 vddd vssd sg13cmos5l_decap_8
Xfanout3 _37_/B _36_/B vddd vssd sg13cmos5l_buf_1
XFILLER_9_7 vddd vssd sg13cmos5l_decap_8
Xuserbuffers\[3\] proj_dig_in[3] userbuffers\[3\]/A vddd vssd sg13cmos5l_buf_8
Xtiedowns\[70\] proj_addr[4] vddd vssd sg13cmos5l_antennanp
Xuserbuffers\[21\] proj_dig_in[21] userbuffers\[21\]/A vddd vssd sg13cmos5l_buf_8
Xtiedowns\[33\] dig_in[9] vddd vssd sg13cmos5l_antennanp
XFILLER_10_144 vddd vssd sg13cmos5l_decap_8
XFILLER_3_107 vddd vssd sg13cmos5l_decap_8
Xfanout4 _36_/B fanout8/X vddd vssd sg13cmos5l_buf_1
Xoutbuffers\[8\] dig_out[8] _47_/X vddd vssd sg13cmos5l_buf_4
XFILLER_13_0 vddd vssd sg13cmos5l_decap_8
Xtiedowns\[63\] proj_sel[2] vddd vssd sg13cmos5l_antennanp
Xuserbuffers\[14\] proj_dig_in[14] userbuffers\[14\]/A vddd vssd sg13cmos5l_buf_8
XFILLER_9_124 vddd vssd sg13cmos5l_decap_8
XFILLER_9_157 vddd vssd sg13cmos5l_decap_8
XFILLER_6_116 vddd vssd sg13cmos5l_decap_8
XFILLER_10_123 vddd vssd sg13cmos5l_decap_8
XFILLER_12_63 vddd vssd sg13cmos5l_decap_8
Xtiedowns\[26\] dig_in[2] vddd vssd sg13cmos5l_antennanp
XFILLER_9_53 vddd vssd sg13cmos5l_decap_8
Xswitchbuffers\[4\] proj_analog_ena[1] _28_/X vddd vssd sg13cmos5l_buf_4
Xfanout5 fanout5/X fanout7/X vddd vssd sg13cmos5l_buf_1
Xtiedowns\[56\] analog_ena[3] vddd vssd sg13cmos5l_antennanp
XFILLER_13_154 vddd vssd sg13cmos5l_decap_8
XFILLER_10_102 vddd vssd sg13cmos5l_decap_8
Xtiedowns\[19\] dig_out_relay[7] vddd vssd sg13cmos5l_antennanp
XFILLER_3_0 vddd vssd sg13cmos5l_decap_4
Xdig_in_gen\[23\].dig_in_latch userbuffers\[23\]/A dig_in[23] fanout9/X fanout8/X
+ vddd vssd sg13cmos5l_dlhrq_1
XFILLER_0_67 vddd vssd sg13cmos5l_decap_8
XFILLER_9_76 vddd vssd sg13cmos5l_decap_8
Xfanout6 fanout6/X fanout7/X vddd vssd sg13cmos5l_buf_1
Xdig_in_gen\[16\].dig_in_latch userbuffers\[16\]/A dig_in[16] fanout10/X fanout7/X
+ vddd vssd sg13cmos5l_dlhrq_1
Xtiedowns\[49\] power_3v3_ena vddd vssd sg13cmos5l_antennanp
.ends

.subckt project_control_area dig_in[20] user_project_control_0/proj_analog_ena[3]
+ user_project_control_0/proj_analog_ena[2] dig_out[7] user_project_control_0/proj_sel[2]
+ user_project_control_0/dig_out_relay[0] dig_in[2] dig_in[21] user_project_control_0/dig_in[22]
+ dig_out[8] user_project_control_0/proj_sel[1] dig_in[3] dig_in[22] dig_out[9] user_project_control_0/analog_ena[2]
+ analog_bus3 dig_in[4] user_project_control_0/proj_analog_ena[1] dig_in[23] user_project_control_0/dig_out[3]
+ user_project_control_0/dig_out[11] user_project_control_0/dig_out[4] analog_bus2
+ dig_in[5] user_project_control_0/analog_ena[1] analog_bus1 user_project_control_0/dig_in[5]
+ dig_in[6] user_project_control_0/dig_in[21] user_project_control_0/dig_in[9] user_project_control_0/dig_out[8]
+ analog_bus0 user_project_control_0/dig_out[9] dig_in[7] user_project_control_0/dig_out_relay[11]
+ dig_in[8] user_project_control_0/proj_ibias_ena[0] user_project_control_0/proj_sel[0]
+ user_project_control_0/dig_in[1] dig_in[9] user_project_control_0/dig_in[17] user_project_control_0/dig_in[2]
+ user_project_control_0/proj_addr[0] dig_out[10] user_project_control_0/dig_ena dig_out[11]
+ user_project_control_0/dig_in[10] user_project_control_0/proj_addr[1] user_project_control_0/proj_addr[3]
+ user_project_control_0/dig_out[5] user_project_control_0/ibias_ena[1] user_project_control_0/dig_in[23]
+ ibias1 user_project_control_0/dig_out[10] vdd_3v3 user_project_control_0/dig_in[6]
+ ibias0 dig_in[10] user_project_control_0/dig_out_relay[2] user_project_control_0/vbias_ena
+ dig_in[11] m2_207925_559863# enable user_project_control_0/dig_out_relay[1] user_project_control_0/dig_out_relay[3]
+ dig_in[12] dig_in[13] user_project_control_0/power_3v3_ena user_project_control_0/dig_out_relay[4]
+ vbias dig_in[14] user_project_control_0/analog_ena[3] user_project_control_0/ibias_ena[0]
+ user_project_control_0/dig_out_relay[5] dig_in[15] user_project_control_0/dig_in[20]
+ power_stage2_0/DVDD user_project_control_0/dig_in[19] dig_in[16] user_project_control_0/dig_out_relay[6]
+ user_project_control_0/proj_sel[4] user_project_control_0/dig_out[6] power_stage2_0/DVSS
+ user_project_control_0/reset user_project_control_0/dig_in[12] dig_in[17] user_project_control_0/analog_ena[0]
+ user_project_control_0/power_1v2_ena dig_in[18] user_project_control_0/enable dig_in[19]
+ DVDD user_project_control_0/dig_out_relay[9] AVDD user_project_control_0/dig_in[14]
+ user_project_control_0/proj_ibias_ena[1] user_project_control_0/dig_out_relay[10]
+ user_project_control_0/dig_in[16] user_project_control_0/dig_in[18] dig_out[0] user_project_control_0/clk
+ reset dig_out[1] user_project_control_0/dig_out[2] user_project_control_0/dig_in[0]
+ dig_out[2] user_project_control_0/dig_out[7] user_project_control_0/dig_out[0] clk
+ user_project_control_0/dig_out[1] user_project_control_0/dig_in[7] dig_out[3] user_project_control_0/dig_in[8]
+ user_project_control_0/dig_in[11] user_project_control_0/dig_out_relay[7] dig_out[4]
+ user_project_control_0/dig_in[3] user_project_control_0/proj_vbias_ena user_project_control_0/proj_sel[3]
+ dig_out[5] user_project_control_0/dig_out_relay[8] user_project_control_0/dig_in[4]
+ dig_in[0] user_project_control_0/dig_in[15] user_project_control_0/proj_addr[4]
+ user_project_control_0/proj_analog_ena[0] user_project_control_0/dig_in[13] dig_out[6]
+ AVSS vdd_1v2 user_project_control_0/proj_addr[2] DVSS dig_in[1]
Xpower_stage2_0 AVDD power_stage2_0/enable AVSS vdd_3v3 power_stage2_0/DVSS power_stage2_0/DVDD
+ power_stage2
Xpower_stage1v2_0 power_stage1v2_0/enable vdd_1v2 DVDD DVSS power_stage1v2
Xuser_project_control_0 user_project_control_0/analog_ena[0] user_project_control_0/analog_ena[1]
+ user_project_control_0/analog_ena[2] user_project_control_0/analog_ena[3] user_project_control_0/clk
+ user_project_control_0/dig_ena user_project_control_0/dig_in[0] user_project_control_0/dig_in[10]
+ user_project_control_0/dig_in[11] user_project_control_0/dig_in[12] user_project_control_0/dig_in[13]
+ user_project_control_0/dig_in[14] user_project_control_0/dig_in[15] user_project_control_0/dig_in[16]
+ user_project_control_0/dig_in[17] user_project_control_0/dig_in[18] user_project_control_0/dig_in[19]
+ user_project_control_0/dig_in[1] user_project_control_0/dig_in[20] user_project_control_0/dig_in[21]
+ user_project_control_0/dig_in[22] user_project_control_0/dig_in[23] user_project_control_0/dig_in[2]
+ user_project_control_0/dig_in[3] user_project_control_0/dig_in[4] user_project_control_0/dig_in[5]
+ user_project_control_0/dig_in[6] user_project_control_0/dig_in[7] user_project_control_0/dig_in[8]
+ user_project_control_0/dig_in[9] user_project_control_0/dig_out[0] user_project_control_0/dig_out[10]
+ user_project_control_0/dig_out[11] user_project_control_0/dig_out[1] user_project_control_0/dig_out[2]
+ user_project_control_0/dig_out[3] user_project_control_0/dig_out[4] user_project_control_0/dig_out[5]
+ user_project_control_0/dig_out[6] user_project_control_0/dig_out[7] user_project_control_0/dig_out[8]
+ user_project_control_0/dig_out[9] user_project_control_0/dig_out_relay[0] user_project_control_0/dig_out_relay[10]
+ user_project_control_0/dig_out_relay[11] user_project_control_0/dig_out_relay[1]
+ user_project_control_0/dig_out_relay[2] user_project_control_0/dig_out_relay[3]
+ user_project_control_0/dig_out_relay[4] user_project_control_0/dig_out_relay[5]
+ user_project_control_0/dig_out_relay[6] user_project_control_0/dig_out_relay[7]
+ user_project_control_0/dig_out_relay[8] user_project_control_0/dig_out_relay[9]
+ user_project_control_0/enable user_project_control_0/ibias_ena[0] user_project_control_0/ibias_ena[1]
+ user_project_control_0/power_1v2_ena user_project_control_0/power_3v3_ena power_stage1v2_0/enable
+ power_stage2_0/enable user_project_control_0/proj_addr[0] user_project_control_0/proj_addr[1]
+ user_project_control_0/proj_addr[2] user_project_control_0/proj_addr[3] user_project_control_0/proj_addr[4]
+ user_project_control_0/proj_analog_ena[0] user_project_control_0/proj_analog_ena[1]
+ user_project_control_0/proj_analog_ena[2] user_project_control_0/proj_analog_ena[3]
+ clk dig_in[0] dig_in[10] dig_in[11] dig_in[12] dig_in[13] dig_in[14] dig_in[15]
+ dig_in[16] dig_in[17] dig_in[18] dig_in[19] dig_in[1] dig_in[20] dig_in[21] dig_in[22]
+ dig_in[23] dig_in[2] dig_in[3] dig_in[4] dig_in[5] dig_in[6] dig_in[7] dig_in[8]
+ dig_in[9] dig_out[0] dig_out[10] dig_out[11] dig_out[1] dig_out[2] dig_out[3] dig_out[4]
+ dig_out[5] dig_out[6] dig_out[7] dig_out[8] dig_out[9] enable user_project_control_0/proj_ibias_ena[0]
+ user_project_control_0/proj_ibias_ena[1] reset user_project_control_0/proj_sel[0]
+ user_project_control_0/proj_sel[1] user_project_control_0/proj_sel[2] user_project_control_0/proj_sel[3]
+ user_project_control_0/proj_sel[4] user_project_control_0/proj_vbias_ena user_project_control_0/reset
+ user_project_control_0/vbias_ena DVDD DVSS user_project_control
.ends

* Black-box entry subcircuit for slot3_wrapper abstract view
.subckt slot3_wrapper vss_3v3 s3_an[0] s3_an[1] s3_an_0_esd vbias dig_in[23] dig_in[22]
+ dig_in[21] dig_in[20] dig_in[19] dig_in[18] dig_in[17] dig_in[16] dig_in[15] dig_in[14]
+ dig_in[13] dig_in[12] dig_in[11] dig_in[10] dig_in[9] dig_in[8] dig_in[7] dig_in[6]
+ dig_in[5] dig_in[4] dig_in[3] dig_in[2] dig_in[1] dig_in[0] dig_out[11] dig_out[10]
+ dig_out[9] dig_out[8] dig_out[7] dig_out[6] dig_out[5] dig_out[4] dig_out[3] dig_out[2]
+ dig_out[1] dig_out[0] ibias0 ibias1 analog_bus3 analog_bus2 analog_bus1 analog_bus0
+ vss_1v2 vdd_1v2 vdd_3v3 enable clk reset
.ends

.subckt rhigh_MGZFWD B R1_0 R2_0 R1_1 R2_1 R1_2 R2_2 R1_3 R2_3 R1_4 R2_4 R1_5 R2_5
+ R1_6 R2_6 R1_7 R2_7 R1_8 R2_8 R1_9 R2_9 R1_10 R2_10 R1_11 R2_11 R1_12 R2_12 R1_13
+ R2_13 R1_14 R2_14 R1_15 R2_15 R1_16 R2_16 R1_17 R2_17 R1_18 R2_18 R1_19 R2_19 R1_20
+ R2_20 R1_21 R2_21 R1_22 R2_22 R1_23 R2_23 R1_24 R2_24 R1_25 R2_25 R1_26 R2_26 R1_27
+ R2_27 R1_28 R2_28 R1_29 R2_29 R1_30 R2_30 R1_31 R2_31 R1_32 R2_32 R1_33 R2_33 R1_34
+ R2_34 R1_35 R2_35 R1_36 R2_36 R1_37 R2_37 R1_38 R2_38 R1_39 R2_39 R1_40 R2_40 R1_41
+ R2_41 R1_42 R2_42 R1_43 R2_43 R1_44 R2_44 R1_45 R2_45 R1_46 R2_46 R1_47 R2_47 R1_48
+ R2_48 R1_49 R2_49 R1_50 R2_50 R1_51 R2_51 R1_52 R2_52 R1_53 R2_53
X0 R1_28 R2_28 B rhigh l=16.82u w=0.5u
X1 R1_44 R2_44 B rhigh l=16.82u w=0.5u
X2 R1_52 R2_52 B rhigh l=16.82u w=0.5u
X3 R1_18 R2_18 B rhigh l=16.82u w=0.5u
X4 R1_19 R2_19 B rhigh l=16.82u w=0.5u
X5 R1_29 R2_29 B rhigh l=16.82u w=0.5u
X6 R1_4 R2_4 B rhigh l=16.82u w=0.5u
X7 R1_17 R2_17 B rhigh l=16.82u w=0.5u
X8 R1_42 R2_42 B rhigh l=16.82u w=0.5u
X9 R1_2 R2_2 B rhigh l=16.82u w=0.5u
X10 R1_3 R2_3 B rhigh l=16.82u w=0.5u
X11 R1_13 R2_13 B rhigh l=16.82u w=0.5u
X12 R1_14 R2_14 B rhigh l=16.82u w=0.5u
X13 R1_12 R2_12 B rhigh l=16.82u w=0.5u
X14 R1_25 R2_25 B rhigh l=16.82u w=0.5u
X15 R1_26 R2_26 B rhigh l=16.82u w=0.5u
X16 R1_15 R2_15 B rhigh l=16.82u w=0.5u
X17 R1_16 R2_16 B rhigh l=16.82u w=0.5u
X18 R1_1 R2_1 B rhigh l=16.82u w=0.5u
X19 R1_45 R2_45 B rhigh l=16.82u w=0.5u
X20 R1_0 R2_0 B rhigh l=16.82u w=0.5u
X21 R1_30 R2_30 B rhigh l=16.82u w=0.5u
X22 R1_46 R2_46 B rhigh l=16.82u w=0.5u
X23 R1_31 R2_31 B rhigh l=16.82u w=0.5u
X24 R1_10 R2_10 B rhigh l=16.82u w=0.5u
X25 R1_11 R2_11 B rhigh l=16.82u w=0.5u
X26 R1_27 R2_27 B rhigh l=16.82u w=0.5u
X27 R1_32 R2_32 B rhigh l=16.82u w=0.5u
X28 R1_33 R2_33 B rhigh l=16.82u w=0.5u
X29 R1_34 R2_34 B rhigh l=16.82u w=0.5u
X30 R1_48 R2_48 B rhigh l=16.82u w=0.5u
X31 R1_23 R2_23 B rhigh l=16.82u w=0.5u
X32 R1_24 R2_24 B rhigh l=16.82u w=0.5u
X33 R1_49 R2_49 B rhigh l=16.82u w=0.5u
X34 R1_22 R2_22 B rhigh l=16.82u w=0.5u
X35 R1_47 R2_47 B rhigh l=16.82u w=0.5u
X36 R1_8 R2_8 B rhigh l=16.82u w=0.5u
X37 R1_9 R2_9 B rhigh l=16.82u w=0.5u
X38 R1_7 R2_7 B rhigh l=16.82u w=0.5u
X39 R1_35 R2_35 B rhigh l=16.82u w=0.5u
X40 R1_36 R2_36 B rhigh l=16.82u w=0.5u
X41 R1_50 R2_50 B rhigh l=16.82u w=0.5u
X42 R1_20 R2_20 B rhigh l=16.82u w=0.5u
X43 R1_21 R2_21 B rhigh l=16.82u w=0.5u
X44 R1_51 R2_51 B rhigh l=16.82u w=0.5u
X45 R1_6 R2_6 B rhigh l=16.82u w=0.5u
X46 R1_40 R2_40 B rhigh l=16.82u w=0.5u
X47 R1_5 R2_5 B rhigh l=16.82u w=0.5u
X48 R1_41 R2_41 B rhigh l=16.82u w=0.5u
X49 R1_37 R2_37 B rhigh l=16.82u w=0.5u
X50 R1_38 R2_38 B rhigh l=16.82u w=0.5u
X51 R1_39 R2_39 B rhigh l=16.82u w=0.5u
X52 R1_53 R2_53 B rhigh l=16.82u w=0.5u
X53 R1_43 R2_43 B rhigh l=16.82u w=0.5u
.ends

.subckt sg13_lv_nmos_5X2BDS B D0 G0 S1 G1 D2 G2 S3 G3 D4 G4 S5 G5 D6 G6 S7 G7 D8 G8
+ S9 G9 D10 G10 S11 G11 D12 G12 S13 G13 D14 S14 G14
X0 S3 G2 D2 B sg13_lv_nmos ad=61.8f pd=0.74u as=61.8f ps=0.74u w=0.24u l=0.13u
X1 S9 G8 D8 B sg13_lv_nmos ad=61.8f pd=0.74u as=61.8f ps=0.74u w=0.24u l=0.13u
X2 D8 G7 S7 B sg13_lv_nmos ad=61.8f pd=0.74u as=61.8f ps=0.74u w=0.24u l=0.13u
X3 D2 G1 S1 B sg13_lv_nmos ad=61.8f pd=0.74u as=61.8f ps=0.74u w=0.24u l=0.13u
X4 D10 G9 S9 B sg13_lv_nmos ad=61.8f pd=0.74u as=61.8f ps=0.74u w=0.24u l=0.13u
X5 S11 G10 D10 B sg13_lv_nmos ad=61.8f pd=0.74u as=61.8f ps=0.74u w=0.24u l=0.13u
X6 D12 G11 S11 B sg13_lv_nmos ad=61.8f pd=0.74u as=61.8f ps=0.74u w=0.24u l=0.13u
X7 S7 G6 D6 B sg13_lv_nmos ad=61.8f pd=0.74u as=61.8f ps=0.74u w=0.24u l=0.13u
X8 S1 G0 D0 B sg13_lv_nmos ad=61.8f pd=0.74u as=0.1068p ps=1.34u w=0.24u l=0.13u
X9 D6 G5 S5 B sg13_lv_nmos ad=61.8f pd=0.74u as=61.8f ps=0.74u w=0.24u l=0.13u
X10 S13 G12 D12 B sg13_lv_nmos ad=61.8f pd=0.74u as=61.8f ps=0.74u w=0.24u l=0.13u
X11 D14 G13 S13 B sg13_lv_nmos ad=61.8f pd=0.74u as=61.8f ps=0.74u w=0.24u l=0.13u
X12 S5 G4 D4 B sg13_lv_nmos ad=61.8f pd=0.74u as=61.8f ps=0.74u w=0.24u l=0.13u
X13 S14 G14 D14 B sg13_lv_nmos ad=0.1068p pd=1.34u as=61.8f ps=0.74u w=0.24u l=0.13u
X14 D4 G3 S3 B sg13_lv_nmos ad=61.8f pd=0.74u as=61.8f ps=0.74u w=0.24u l=0.13u
.ends

.subckt sg13_lv_nmos_VHRE9V B D0 G0 S1 G1 D2 G2 S3 G3 D4 G4 S5 G5 D6 G6 S7 G7 a_370_n47#
X0 D6 G5 S5 B sg13_lv_nmos ad=89.3f pd=0.85u as=89.3f ps=0.85u w=0.47u l=0.13u
X1 S7 G6 D6 B sg13_lv_nmos ad=89.3f pd=0.85u as=89.3f ps=0.85u w=0.47u l=0.13u
X2 a_370_n47# G7 S7 B sg13_lv_nmos ad=0.1598p pd=1.62u as=89.3f ps=0.85u w=0.47u l=0.13u
X3 D4 G3 S3 B sg13_lv_nmos ad=89.3f pd=0.85u as=89.3f ps=0.85u w=0.47u l=0.13u
X4 S5 G4 D4 B sg13_lv_nmos ad=89.3f pd=0.85u as=89.3f ps=0.85u w=0.47u l=0.13u
X5 S3 G2 D2 B sg13_lv_nmos ad=89.3f pd=0.85u as=89.3f ps=0.85u w=0.47u l=0.13u
X6 D2 G1 S1 B sg13_lv_nmos ad=89.3f pd=0.85u as=89.3f ps=0.85u w=0.47u l=0.13u
X7 S1 G0 D0 B sg13_lv_nmos ad=89.3f pd=0.85u as=0.1598p ps=1.62u w=0.47u l=0.13u
.ends

.subckt sg13_lv_pmos_4AKZGL B D0 G0 S1 G1 D2 G2 S3 G3 D4 G4 S5 G5 D6 G6 S7 G7 D8 G8
+ S9 G9 D10 G10 S11 G11 D12 G12 S13 G13 D14 S14 G14
X0 S3 G2 D2 B sg13_lv_pmos ad=61.8f pd=0.74u as=61.8f ps=0.74u w=0.24u l=0.13u
X1 S9 G8 D8 B sg13_lv_pmos ad=61.8f pd=0.74u as=61.8f ps=0.74u w=0.24u l=0.13u
X2 D8 G7 S7 B sg13_lv_pmos ad=61.8f pd=0.74u as=61.8f ps=0.74u w=0.24u l=0.13u
X3 D2 G1 S1 B sg13_lv_pmos ad=61.8f pd=0.74u as=61.8f ps=0.74u w=0.24u l=0.13u
X4 D10 G9 S9 B sg13_lv_pmos ad=61.8f pd=0.74u as=61.8f ps=0.74u w=0.24u l=0.13u
X5 S11 G10 D10 B sg13_lv_pmos ad=61.8f pd=0.74u as=61.8f ps=0.74u w=0.24u l=0.13u
X6 D12 G11 S11 B sg13_lv_pmos ad=61.8f pd=0.74u as=61.8f ps=0.74u w=0.24u l=0.13u
X7 S7 G6 D6 B sg13_lv_pmos ad=61.8f pd=0.74u as=61.8f ps=0.74u w=0.24u l=0.13u
X8 S1 G0 D0 B sg13_lv_pmos ad=61.8f pd=0.74u as=0.1068p ps=1.34u w=0.24u l=0.13u
X9 D6 G5 S5 B sg13_lv_pmos ad=61.8f pd=0.74u as=61.8f ps=0.74u w=0.24u l=0.13u
X10 S13 G12 D12 B sg13_lv_pmos ad=61.8f pd=0.74u as=61.8f ps=0.74u w=0.24u l=0.13u
X11 S5 G4 D4 B sg13_lv_pmos ad=61.8f pd=0.74u as=61.8f ps=0.74u w=0.24u l=0.13u
X12 D14 G13 S13 B sg13_lv_pmos ad=61.8f pd=0.74u as=61.8f ps=0.74u w=0.24u l=0.13u
X13 S14 G14 D14 B sg13_lv_pmos ad=0.1068p pd=1.34u as=61.8f ps=0.74u w=0.24u l=0.13u
X14 D4 G3 S3 B sg13_lv_pmos ad=61.8f pd=0.74u as=61.8f ps=0.74u w=0.24u l=0.13u
.ends

.subckt sg13_lv_pmos_JRRYKH B D0 G0 S1 G1 D2 G2 S3 G3 D4 G4 S5 G5 D6 G6 S7 G7 D8 G8
+ S9 G9 D10 S10 G10
X0 S1 G0 D0 B sg13_lv_pmos ad=61.8f pd=0.74u as=0.1068p ps=1.34u w=0.24u l=0.13u
X1 S7 G6 D6 B sg13_lv_pmos ad=61.8f pd=0.74u as=61.8f ps=0.74u w=0.24u l=0.13u
X2 D6 G5 S5 B sg13_lv_pmos ad=61.8f pd=0.74u as=61.8f ps=0.74u w=0.24u l=0.13u
X3 D8 G7 S7 B sg13_lv_pmos ad=61.8f pd=0.74u as=61.8f ps=0.74u w=0.24u l=0.13u
X4 S9 G8 D8 B sg13_lv_pmos ad=61.8f pd=0.74u as=61.8f ps=0.74u w=0.24u l=0.13u
X5 D10 G9 S9 B sg13_lv_pmos ad=61.8f pd=0.74u as=61.8f ps=0.74u w=0.24u l=0.13u
X6 S5 G4 D4 B sg13_lv_pmos ad=61.8f pd=0.74u as=61.8f ps=0.74u w=0.24u l=0.13u
X7 D4 G3 S3 B sg13_lv_pmos ad=61.8f pd=0.74u as=61.8f ps=0.74u w=0.24u l=0.13u
X8 S10 G10 D10 B sg13_lv_pmos ad=0.1068p pd=1.34u as=61.8f ps=0.74u w=0.24u l=0.13u
X9 S3 G2 D2 B sg13_lv_pmos ad=61.8f pd=0.74u as=61.8f ps=0.74u w=0.24u l=0.13u
X10 D2 G1 S1 B sg13_lv_pmos ad=61.8f pd=0.74u as=61.8f ps=0.74u w=0.24u l=0.13u
.ends

.subckt por_stepdown vref nbias vpb vfb vcap vss vdd1v2
Xsg13_lv_nmos_5X2BDS_0 vss vss vss sg13_lv_nmos_5X2BDS_0/S9 sg13_lv_nmos_5X2BDS_0/S9
+ sg13_lv_nmos_5X2BDS_1/G9 sg13_lv_nmos_5X2BDS_0/S9 sg13_lv_nmos_5X2BDS_0/S9 sg13_lv_nmos_5X2BDS_0/S9
+ sg13_lv_nmos_5X2BDS_1/G9 sg13_lv_nmos_5X2BDS_0/S9 sg13_lv_nmos_5X2BDS_0/S9 sg13_lv_nmos_5X2BDS_0/S9
+ sg13_lv_nmos_5X2BDS_1/G9 sg13_lv_nmos_5X2BDS_0/S9 sg13_lv_nmos_5X2BDS_0/S9 sg13_lv_nmos_5X2BDS_0/S9
+ sg13_lv_nmos_5X2BDS_1/G9 sg13_lv_nmos_5X2BDS_0/S9 sg13_lv_nmos_5X2BDS_0/S9 sg13_lv_nmos_5X2BDS_0/S9
+ sg13_lv_nmos_5X2BDS_1/G9 sg13_lv_nmos_5X2BDS_0/S9 sg13_lv_nmos_5X2BDS_0/S9 sg13_lv_nmos_5X2BDS_0/S9
+ sg13_lv_nmos_5X2BDS_1/G9 sg13_lv_nmos_5X2BDS_0/S9 sg13_lv_nmos_5X2BDS_0/S9 vss sg13_lv_nmos_5X2BDS_1/D14
+ sg13_lv_pmos_JRRYKH_1/S9 sg13_lv_nmos_5X2BDS_0/S9 sg13_lv_nmos_5X2BDS
Xsg13_lv_nmos_5X2BDS_1 vss vss vss vss sg13_lv_nmos_5X2BDS_1/G9 sg13_lv_nmos_5X2BDS_1/G9
+ sg13_lv_nmos_5X2BDS_1/G9 vss sg13_lv_nmos_5X2BDS_1/G9 sg13_lv_nmos_5X2BDS_1/G9 sg13_lv_nmos_5X2BDS_1/G9
+ vss sg13_lv_nmos_5X2BDS_1/G9 sg13_lv_nmos_5X2BDS_1/G9 sg13_lv_nmos_5X2BDS_1/G9 vss
+ sg13_lv_nmos_5X2BDS_1/G9 sg13_lv_nmos_5X2BDS_1/G9 sg13_lv_nmos_5X2BDS_1/G9 vss sg13_lv_nmos_5X2BDS_1/G9
+ sg13_lv_nmos_5X2BDS_1/G9 sg13_lv_nmos_5X2BDS_1/G9 vss sg13_lv_nmos_5X2BDS_1/G9 sg13_lv_nmos_5X2BDS_1/G9
+ sg13_lv_nmos_5X2BDS_1/G9 vss sg13_lv_nmos_5X2BDS_1/G9 sg13_lv_nmos_5X2BDS_1/D14
+ vss vss sg13_lv_nmos_5X2BDS
Xsg13_lv_nmos_VHRE9V_0 vss nbias vref vref vref nbias vref vref vref nbias vref vref
+ vref nbias vref vref vref nbias sg13_lv_nmos_VHRE9V
Xsg13_lv_nmos_VHRE9V_1 vss nbias nbias vss nbias nbias nbias vss nbias nbias nbias
+ vss nbias nbias nbias vss nbias nbias sg13_lv_nmos_VHRE9V
Xsg13_lv_pmos_4AKZGL_0 vdd1v2 vdd1v2 vdd1v2 vdd1v2 vpb sg13_lv_pmos_4AKZGL_1/D8 vpb
+ vdd1v2 vpb sg13_lv_pmos_4AKZGL_1/D8 vpb vdd1v2 vpb sg13_lv_pmos_4AKZGL_1/D8 vpb
+ vdd1v2 vpb sg13_lv_pmos_4AKZGL_1/D8 vpb vdd1v2 vpb sg13_lv_pmos_4AKZGL_1/D8 vpb
+ vdd1v2 vpb sg13_lv_pmos_4AKZGL_1/D8 vpb vdd1v2 vpb sg13_lv_pmos_4AKZGL_1/D14 vdd1v2
+ vdd1v2 sg13_lv_pmos_4AKZGL
Xsg13_lv_pmos_JRRYKH_0 vdd1v2 vdd1v2 vdd1v2 vdd1v2 sg13_lv_pmos_JRRYKH_1/D8 sg13_lv_pmos_JRRYKH_1/D8
+ sg13_lv_pmos_JRRYKH_1/D8 vdd1v2 sg13_lv_pmos_JRRYKH_1/D8 sg13_lv_pmos_JRRYKH_1/D8
+ sg13_lv_pmos_JRRYKH_1/D8 vdd1v2 sg13_lv_pmos_JRRYKH_1/D8 sg13_lv_pmos_JRRYKH_1/D8
+ sg13_lv_pmos_JRRYKH_1/D8 vdd1v2 sg13_lv_pmos_JRRYKH_1/D8 sg13_lv_pmos_JRRYKH_1/D8
+ sg13_lv_pmos_JRRYKH_1/D8 vdd1v2 sg13_lv_pmos_JRRYKH_1/D8 sg13_lv_pmos_JRRYKH_1/D10
+ vdd1v2 vdd1v2 sg13_lv_pmos_JRRYKH
Xsg13_lv_pmos_4AKZGL_1 vdd1v2 vdd1v2 vdd1v2 vfb vfb sg13_lv_pmos_4AKZGL_1/D8 vfb vfb
+ vfb sg13_lv_pmos_4AKZGL_1/D8 vfb vfb vfb sg13_lv_pmos_4AKZGL_1/D8 vfb vfb vfb sg13_lv_pmos_4AKZGL_1/D8
+ vfb vfb vfb sg13_lv_pmos_4AKZGL_1/D8 vfb vfb vfb sg13_lv_pmos_4AKZGL_1/D8 vfb vfb
+ vdd1v2 sg13_lv_pmos_4AKZGL_1/D14 sg13_lv_nmos_5X2BDS_0/S9 vfb sg13_lv_pmos_4AKZGL
Xsg13_lv_pmos_JRRYKH_1 vdd1v2 vdd1v2 vdd1v2 sg13_lv_pmos_JRRYKH_1/S9 sg13_lv_pmos_JRRYKH_1/S9
+ sg13_lv_pmos_JRRYKH_1/D8 sg13_lv_pmos_JRRYKH_1/S9 sg13_lv_pmos_JRRYKH_1/S9 sg13_lv_pmos_JRRYKH_1/S9
+ sg13_lv_pmos_JRRYKH_1/D8 sg13_lv_pmos_JRRYKH_1/S9 sg13_lv_pmos_JRRYKH_1/S9 sg13_lv_pmos_JRRYKH_1/S9
+ sg13_lv_pmos_JRRYKH_1/D8 sg13_lv_pmos_JRRYKH_1/S9 sg13_lv_pmos_JRRYKH_1/S9 sg13_lv_pmos_JRRYKH_1/S9
+ sg13_lv_pmos_JRRYKH_1/D8 sg13_lv_pmos_JRRYKH_1/S9 sg13_lv_pmos_JRRYKH_1/S9 vdd1v2
+ sg13_lv_pmos_JRRYKH_1/D10 vcap sg13_lv_pmos_JRRYKH_1/S9 sg13_lv_pmos_JRRYKH
.ends

.subckt cap_cmomf_MKAUQG c1 c2
X0 c1 c2 cap_cmomf mm_ok=1 subblock=0 mmax=4 mmin=1 l=20u w=20u
.ends

.subckt cap_cmomf_7YMNSS c1 c2
X0 c1 c2 cap_cmomf mm_ok=1 subblock=0 mmax=4 mmin=3 l=14u w=50u
.ends

.subckt dantenna_WMFCS7 D2 D1
X0 D2 D1 dantenna l=0.78u w=0.78u
.ends

.subckt sg13_lv_pmos_KE4EUN B D S G
X0 S G D B sg13_lv_pmos ad=0.476p pd=3.48u as=0.476p ps=3.48u w=1.4u l=0.26u
.ends

.subckt sg13_lv_pmos_KPMAU6 B D0 G0 S1 G1 D2 G2 S3 G3 a_166_n16#
X0 D2 G1 S1 B sg13_lv_pmos ad=66.49999f pd=0.73u as=66.49999f ps=0.73u w=0.35u l=0.13u
X1 S3 G2 D2 B sg13_lv_pmos ad=66.49999f pd=0.73u as=66.49999f ps=0.73u w=0.35u l=0.13u
X2 S1 G0 D0 B sg13_lv_pmos ad=66.49999f pd=0.73u as=0.119p ps=1.38u w=0.35u l=0.13u
X3 a_166_n16# G3 S3 B sg13_lv_pmos ad=0.119p pd=1.38u as=66.49999f ps=0.73u w=0.35u l=0.13u
.ends

.subckt sg13_lv_pmos_RWAJH3 B D S G
X0 S G D B sg13_lv_pmos ad=0.119p pd=1.38u as=0.119p ps=1.38u w=0.35u l=0.13u
.ends

.subckt sg13_lv_nmos_LT8DKY B D0 G0 S1 G1 a_64_n54#
X0 S1 G0 D0 B sg13_lv_nmos ad=66.49999f pd=0.73u as=0.119p ps=1.38u w=0.35u l=0.13u
X1 a_64_n54# G1 S1 B sg13_lv_nmos ad=0.119p pd=1.38u as=66.49999f ps=0.73u w=0.35u l=0.13u
.ends

.subckt sg13_lv_nmos_GT3QPP B D S G
X0 S G D B sg13_lv_nmos ad=0.952p pd=6.28u as=0.952p ps=6.28u w=2.8u l=0.26u
.ends

.subckt por_1v2_schmitt_inv vdd1v2 in out vss
Xsg13_lv_pmos_KE4EUN_0 vdd1v2 sg13_lv_pmos_RWAJH3_0/D vss out sg13_lv_pmos_KE4EUN
Xsg13_lv_pmos_KPMAU6_0 vdd1v2 vdd1v2 in sg13_lv_pmos_RWAJH3_0/D in vdd1v2 in sg13_lv_pmos_RWAJH3_0/D
+ in vdd1v2 sg13_lv_pmos_KPMAU6
Xsg13_lv_pmos_RWAJH3_0 vdd1v2 sg13_lv_pmos_RWAJH3_0/D out in sg13_lv_pmos_RWAJH3
Xsg13_lv_nmos_LT8DKY_0 vss vss in sg13_lv_nmos_GT3QPP_0/D in vss sg13_lv_nmos_LT8DKY
Xsg13_lv_nmos_LT8DKY_1 vss sg13_lv_nmos_GT3QPP_0/D in out in sg13_lv_nmos_GT3QPP_0/D
+ sg13_lv_nmos_LT8DKY
Xsg13_lv_nmos_GT3QPP_0 vss sg13_lv_nmos_GT3QPP_0/D vdd1v2 out sg13_lv_nmos_GT3QPP
.ends

.subckt cap_cmomf_T2STT2 sub c1 c2
X0 c1 c2 cap_cmomf mm_ok=1 subblock=1 mmax=4 mmin=1 l=14u w=50u
.ends

.subckt sg13_lv_nmos_AGXAPYY B D0 G0 S1 G1 D2 G2 S3 G3 D4 G4 S5 G5 D6 G6 S7 G7 D8
+ G8 S9 G9 D10 G10 S11 G11 D12 G12 S13 G13 D14 G14 S15 G15 D16 G16 S17 G17 D18 G18
+ S19 G19 D20 G20 S21 G21 D22 G22 S23 G23 D24 G24 S25 G25 a_1288_n47#
X0 D6 G5 S5 B sg13_lv_nmos ad=89.3f pd=0.85u as=89.3f ps=0.85u w=0.47u l=0.13u
X1 S3 G2 D2 B sg13_lv_nmos ad=89.3f pd=0.85u as=89.3f ps=0.85u w=0.47u l=0.13u
X2 D4 G3 S3 B sg13_lv_nmos ad=89.3f pd=0.85u as=89.3f ps=0.85u w=0.47u l=0.13u
X3 S5 G4 D4 B sg13_lv_nmos ad=89.3f pd=0.85u as=89.3f ps=0.85u w=0.47u l=0.13u
X4 D2 G1 S1 B sg13_lv_nmos ad=89.3f pd=0.85u as=89.3f ps=0.85u w=0.47u l=0.13u
X5 S1 G0 D0 B sg13_lv_nmos ad=89.3f pd=0.85u as=0.1598p ps=1.62u w=0.47u l=0.13u
X6 S15 G14 D14 B sg13_lv_nmos ad=89.3f pd=0.85u as=89.3f ps=0.85u w=0.47u l=0.13u
X7 D16 G15 S15 B sg13_lv_nmos ad=89.3f pd=0.85u as=89.3f ps=0.85u w=0.47u l=0.13u
X8 S17 G16 D16 B sg13_lv_nmos ad=89.3f pd=0.85u as=89.3f ps=0.85u w=0.47u l=0.13u
X9 D18 G17 S17 B sg13_lv_nmos ad=89.3f pd=0.85u as=89.3f ps=0.85u w=0.47u l=0.13u
X10 S13 G12 D12 B sg13_lv_nmos ad=89.3f pd=0.85u as=89.3f ps=0.85u w=0.47u l=0.13u
X11 S19 G18 D18 B sg13_lv_nmos ad=89.3f pd=0.85u as=89.3f ps=0.85u w=0.47u l=0.13u
X12 D20 G19 S19 B sg13_lv_nmos ad=89.3f pd=0.85u as=89.3f ps=0.85u w=0.47u l=0.13u
X13 S21 G20 D20 B sg13_lv_nmos ad=89.3f pd=0.85u as=89.3f ps=0.85u w=0.47u l=0.13u
X14 D14 G13 S13 B sg13_lv_nmos ad=89.3f pd=0.85u as=89.3f ps=0.85u w=0.47u l=0.13u
X15 D22 G21 S21 B sg13_lv_nmos ad=89.3f pd=0.85u as=89.3f ps=0.85u w=0.47u l=0.13u
X16 S23 G22 D22 B sg13_lv_nmos ad=89.3f pd=0.85u as=89.3f ps=0.85u w=0.47u l=0.13u
X17 D12 G11 S11 B sg13_lv_nmos ad=89.3f pd=0.85u as=89.3f ps=0.85u w=0.47u l=0.13u
X18 S11 G10 D10 B sg13_lv_nmos ad=89.3f pd=0.85u as=89.3f ps=0.85u w=0.47u l=0.13u
X19 S9 G8 D8 B sg13_lv_nmos ad=89.3f pd=0.85u as=89.3f ps=0.85u w=0.47u l=0.13u
X20 D10 G9 S9 B sg13_lv_nmos ad=89.3f pd=0.85u as=89.3f ps=0.85u w=0.47u l=0.13u
X21 D24 G23 S23 B sg13_lv_nmos ad=89.3f pd=0.85u as=89.3f ps=0.85u w=0.47u l=0.13u
X22 S25 G24 D24 B sg13_lv_nmos ad=89.3f pd=0.85u as=89.3f ps=0.85u w=0.47u l=0.13u
X23 D8 G7 S7 B sg13_lv_nmos ad=89.3f pd=0.85u as=89.3f ps=0.85u w=0.47u l=0.13u
X24 a_1288_n47# G25 S25 B sg13_lv_nmos ad=0.1598p pd=1.62u as=89.3f ps=0.85u w=0.47u l=0.13u
X25 S7 G6 D6 B sg13_lv_nmos ad=89.3f pd=0.85u as=89.3f ps=0.85u w=0.47u l=0.13u
.ends

.subckt sg13_lv_pmos_X27YSC B D0 G0 S1 G1 D2 G2 S3 G3 D4 G4 S5 G5 D6 G6 S7 G7 a_370_n47#
X0 D6 G5 S5 B sg13_lv_pmos ad=89.3f pd=0.85u as=89.3f ps=0.85u w=0.47u l=0.13u
X1 S7 G6 D6 B sg13_lv_pmos ad=89.3f pd=0.85u as=89.3f ps=0.85u w=0.47u l=0.13u
X2 a_370_n47# G7 S7 B sg13_lv_pmos ad=0.1598p pd=1.62u as=89.3f ps=0.85u w=0.47u l=0.13u
X3 D4 G3 S3 B sg13_lv_pmos ad=89.3f pd=0.85u as=89.3f ps=0.85u w=0.47u l=0.13u
X4 S5 G4 D4 B sg13_lv_pmos ad=89.3f pd=0.85u as=89.3f ps=0.85u w=0.47u l=0.13u
X5 S3 G2 D2 B sg13_lv_pmos ad=89.3f pd=0.85u as=89.3f ps=0.85u w=0.47u l=0.13u
X6 D2 G1 S1 B sg13_lv_pmos ad=89.3f pd=0.85u as=89.3f ps=0.85u w=0.47u l=0.13u
X7 S1 G0 D0 B sg13_lv_pmos ad=89.3f pd=0.85u as=0.1598p ps=1.62u w=0.47u l=0.13u
.ends

.subckt sg13_lv_nmos_AGXAPYX B D0 G0 S1 G1 D2 G2 S3 G3 D4 G4 S5 G5 D6 G6 S7 G7 D8
+ G8 S9 G9 D10 G10 S11 G11 D12 G12 S13 G13 D14 G14 S15 G15 D16 G16 S17 G17 D18 G18
+ S19 G19 D20 G20 S21 G21 D22 G22 S23 G23 D24 G24 S25 G25 a_1288_n47#
X0 D6 G5 S5 B sg13_lv_nmos ad=89.3f pd=0.85u as=89.3f ps=0.85u w=0.47u l=0.13u
X1 S3 G2 D2 B sg13_lv_nmos ad=89.3f pd=0.85u as=89.3f ps=0.85u w=0.47u l=0.13u
X2 D4 G3 S3 B sg13_lv_nmos ad=89.3f pd=0.85u as=89.3f ps=0.85u w=0.47u l=0.13u
X3 S5 G4 D4 B sg13_lv_nmos ad=89.3f pd=0.85u as=89.3f ps=0.85u w=0.47u l=0.13u
X4 D2 G1 S1 B sg13_lv_nmos ad=89.3f pd=0.85u as=89.3f ps=0.85u w=0.47u l=0.13u
X5 S1 G0 D0 B sg13_lv_nmos ad=89.3f pd=0.85u as=0.1598p ps=1.62u w=0.47u l=0.13u
X6 S15 G14 D14 B sg13_lv_nmos ad=89.3f pd=0.85u as=89.3f ps=0.85u w=0.47u l=0.13u
X7 D16 G15 S15 B sg13_lv_nmos ad=89.3f pd=0.85u as=89.3f ps=0.85u w=0.47u l=0.13u
X8 S17 G16 D16 B sg13_lv_nmos ad=89.3f pd=0.85u as=89.3f ps=0.85u w=0.47u l=0.13u
X9 D18 G17 S17 B sg13_lv_nmos ad=89.3f pd=0.85u as=89.3f ps=0.85u w=0.47u l=0.13u
X10 S13 G12 D12 B sg13_lv_nmos ad=89.3f pd=0.85u as=89.3f ps=0.85u w=0.47u l=0.13u
X11 S19 G18 D18 B sg13_lv_nmos ad=89.3f pd=0.85u as=89.3f ps=0.85u w=0.47u l=0.13u
X12 D20 G19 S19 B sg13_lv_nmos ad=89.3f pd=0.85u as=89.3f ps=0.85u w=0.47u l=0.13u
X13 S21 G20 D20 B sg13_lv_nmos ad=89.3f pd=0.85u as=89.3f ps=0.85u w=0.47u l=0.13u
X14 D14 G13 S13 B sg13_lv_nmos ad=89.3f pd=0.85u as=89.3f ps=0.85u w=0.47u l=0.13u
X15 D22 G21 S21 B sg13_lv_nmos ad=89.3f pd=0.85u as=89.3f ps=0.85u w=0.47u l=0.13u
X16 S23 G22 D22 B sg13_lv_nmos ad=89.3f pd=0.85u as=89.3f ps=0.85u w=0.47u l=0.13u
X17 D12 G11 S11 B sg13_lv_nmos ad=89.3f pd=0.85u as=89.3f ps=0.85u w=0.47u l=0.13u
X18 S11 G10 D10 B sg13_lv_nmos ad=89.3f pd=0.85u as=89.3f ps=0.85u w=0.47u l=0.13u
X19 S9 G8 D8 B sg13_lv_nmos ad=89.3f pd=0.85u as=89.3f ps=0.85u w=0.47u l=0.13u
X20 D10 G9 S9 B sg13_lv_nmos ad=89.3f pd=0.85u as=89.3f ps=0.85u w=0.47u l=0.13u
X21 D24 G23 S23 B sg13_lv_nmos ad=89.3f pd=0.85u as=89.3f ps=0.85u w=0.47u l=0.13u
X22 S25 G24 D24 B sg13_lv_nmos ad=89.3f pd=0.85u as=89.3f ps=0.85u w=0.47u l=0.13u
X23 D8 G7 S7 B sg13_lv_nmos ad=89.3f pd=0.85u as=89.3f ps=0.85u w=0.47u l=0.13u
X24 a_1288_n47# G25 S25 B sg13_lv_nmos ad=0.1598p pd=1.62u as=89.3f ps=0.85u w=0.47u l=0.13u
X25 S7 G6 D6 B sg13_lv_nmos ad=89.3f pd=0.85u as=89.3f ps=0.85u w=0.47u l=0.13u
.ends

.subckt por_amp vdd1v2 inp ena nbias out inn vss
Xsg13_lv_nmos_AGXAPYY_0 vss vss vss vss nbias sg13_lv_nmos_AGXAPYY_0/D8 ena sg13_lv_nmos_AGXAPYY_0/S7
+ ena sg13_lv_nmos_AGXAPYY_0/D8 nbias vss nbias sg13_lv_nmos_AGXAPYY_0/D8 ena sg13_lv_nmos_AGXAPYY_0/S7
+ ena sg13_lv_nmos_AGXAPYY_0/D8 nbias vss nbias sg13_lv_nmos_AGXAPYY_0/D8 ena sg13_lv_nmos_AGXAPYY_0/S7
+ ena sg13_lv_nmos_AGXAPYY_0/D8 nbias vss nbias sg13_lv_nmos_AGXAPYY_0/D8 ena sg13_lv_nmos_AGXAPYY_0/S7
+ ena sg13_lv_nmos_AGXAPYY_0/D8 nbias vss nbias sg13_lv_nmos_AGXAPYY_0/D8 ena sg13_lv_nmos_AGXAPYY_0/S7
+ ena sg13_lv_nmos_AGXAPYY_0/D8 nbias vss nbias sg13_lv_nmos_AGXAPYY_0/D8 ena sg13_lv_nmos_AGXAPYY_0/S7
+ ena sg13_lv_nmos_AGXAPYY_0/D8 nbias vss vss vss sg13_lv_nmos_AGXAPYY
Xsg13_lv_pmos_X27YSC_0 vdd1v2 vdd1v2 vdd1v2 vdd1v2 sg13_lv_pmos_X27YSC_1/G6 out sg13_lv_pmos_X27YSC_1/G6
+ vdd1v2 sg13_lv_pmos_X27YSC_1/G6 sg13_lv_pmos_X27YSC_1/G6 sg13_lv_pmos_X27YSC_1/G6
+ vdd1v2 sg13_lv_pmos_X27YSC_1/G6 out sg13_lv_pmos_X27YSC_1/G6 vdd1v2 vdd1v2 vdd1v2
+ sg13_lv_pmos_X27YSC
Xsg13_lv_pmos_X27YSC_1 vdd1v2 vdd1v2 vdd1v2 vdd1v2 sg13_lv_pmos_X27YSC_1/G6 sg13_lv_pmos_X27YSC_1/G6
+ sg13_lv_pmos_X27YSC_1/G6 vdd1v2 sg13_lv_pmos_X27YSC_1/G6 out sg13_lv_pmos_X27YSC_1/G6
+ vdd1v2 sg13_lv_pmos_X27YSC_1/G6 sg13_lv_pmos_X27YSC_1/G6 sg13_lv_pmos_X27YSC_1/G6
+ vdd1v2 vdd1v2 vdd1v2 sg13_lv_pmos_X27YSC
Xsg13_lv_nmos_AGXAPYX_0 vss vss vss sg13_lv_nmos_AGXAPYY_0/S7 inn out inn sg13_lv_nmos_AGXAPYY_0/S7
+ inp sg13_lv_pmos_X27YSC_1/G6 inp sg13_lv_nmos_AGXAPYY_0/S7 inn out inn sg13_lv_nmos_AGXAPYY_0/S7
+ inp sg13_lv_pmos_X27YSC_1/G6 inp sg13_lv_nmos_AGXAPYY_0/S7 inn out inn sg13_lv_nmos_AGXAPYY_0/S7
+ inp sg13_lv_pmos_X27YSC_1/G6 inp sg13_lv_nmos_AGXAPYY_0/S7 inn out inn sg13_lv_nmos_AGXAPYY_0/S7
+ inp sg13_lv_pmos_X27YSC_1/G6 inp sg13_lv_nmos_AGXAPYY_0/S7 inn out inn sg13_lv_nmos_AGXAPYY_0/S7
+ inp sg13_lv_pmos_X27YSC_1/G6 inp sg13_lv_nmos_AGXAPYY_0/S7 inn out inn sg13_lv_nmos_AGXAPYY_0/S7
+ inp sg13_lv_pmos_X27YSC_1/G6 inp sg13_lv_nmos_AGXAPYY_0/S7 vss vss sg13_lv_nmos_AGXAPYX
.ends

.subckt sg13cmos5l_buf_16 X A VDD VSS
X0 VDD a_116_82# X VDD sg13_lv_pmos ad=0.2128p pd=1.5u as=0.2128p ps=1.5u w=1.12u l=0.13u
X1 X a_116_82# VSS VSS sg13_lv_nmos ad=0.1406p pd=1.12u as=0.1406p ps=1.12u w=0.74u l=0.13u
X2 X a_116_82# VDD VDD sg13_lv_pmos ad=0.2128p pd=1.5u as=0.2128p ps=1.5u w=1.12u l=0.13u
X3 VSS a_116_82# X VSS sg13_lv_nmos ad=0.1406p pd=1.12u as=0.1406p ps=1.12u w=0.74u l=0.13u
X4 X a_116_82# VSS VSS sg13_lv_nmos ad=0.1406p pd=1.12u as=0.1406p ps=1.12u w=0.74u l=0.13u
X5 VDD a_116_82# X VDD sg13_lv_pmos ad=0.2128p pd=1.5u as=0.2128p ps=1.5u w=1.12u l=0.13u
X6 VSS a_116_82# X VSS sg13_lv_nmos ad=0.1406p pd=1.12u as=0.1406p ps=1.12u w=0.74u l=0.13u
X7 X a_116_82# VDD VDD sg13_lv_pmos ad=0.2128p pd=1.5u as=0.2128p ps=1.5u w=1.12u l=0.13u
X8 VDD a_116_82# X VDD sg13_lv_pmos ad=0.2128p pd=1.5u as=0.2128p ps=1.5u w=1.12u l=0.13u
X9 X a_116_82# VSS VSS sg13_lv_nmos ad=0.1406p pd=1.12u as=0.1406p ps=1.12u w=0.74u l=0.13u
X10 VSS A a_116_82# VSS sg13_lv_nmos ad=0.1406p pd=1.12u as=0.1406p ps=1.12u w=0.74u l=0.13u
X11 X a_116_82# VDD VDD sg13_lv_pmos ad=0.2128p pd=1.5u as=0.2128p ps=1.5u w=1.12u l=0.13u
X12 VDD A a_116_82# VDD sg13_lv_pmos ad=0.2128p pd=1.5u as=0.2128p ps=1.5u w=1.12u l=0.13u
X13 VSS a_116_82# X VSS sg13_lv_nmos ad=0.1406p pd=1.12u as=0.1406p ps=1.12u w=0.74u l=0.13u
X14 a_116_82# A VSS VSS sg13_lv_nmos ad=0.1406p pd=1.12u as=0.1406p ps=1.12u w=0.74u l=0.13u
X15 VDD a_116_82# X VDD sg13_lv_pmos ad=0.2128p pd=1.5u as=0.2128p ps=1.5u w=1.12u l=0.13u
X16 a_116_82# A VDD VDD sg13_lv_pmos ad=0.2128p pd=1.5u as=0.2128p ps=1.5u w=1.12u l=0.13u
X17 a_116_82# A VSS VSS sg13_lv_nmos ad=0.1406p pd=1.12u as=0.1406p ps=1.12u w=0.74u l=0.13u
X18 VSS A a_116_82# VSS sg13_lv_nmos ad=0.1406p pd=1.12u as=0.1406p ps=1.12u w=0.74u l=0.13u
X19 VSS A a_116_82# VSS sg13_lv_nmos ad=0.2516p pd=2.16u as=0.1406p ps=1.12u w=0.74u l=0.13u
X20 a_116_82# A VDD VDD sg13_lv_pmos ad=0.2128p pd=1.5u as=0.2128p ps=1.5u w=1.12u l=0.13u
X21 VDD A a_116_82# VDD sg13_lv_pmos ad=0.2128p pd=1.5u as=0.2128p ps=1.5u w=1.12u l=0.13u
X22 VDD A a_116_82# VDD sg13_lv_pmos ad=0.3808p pd=2.92u as=0.2128p ps=1.5u w=1.12u l=0.13u
X23 a_116_82# A VSS VSS sg13_lv_nmos ad=0.1406p pd=1.12u as=0.1406p ps=1.12u w=0.74u l=0.13u
X24 X a_116_82# VSS VSS sg13_lv_nmos ad=0.1406p pd=1.12u as=0.2516p ps=2.16u w=0.74u l=0.13u
X25 a_116_82# A VDD VDD sg13_lv_pmos ad=0.2128p pd=1.5u as=0.2128p ps=1.5u w=1.12u l=0.13u
X26 VSS a_116_82# X VSS sg13_lv_nmos ad=0.1406p pd=1.12u as=0.1406p ps=1.12u w=0.74u l=0.13u
X27 X a_116_82# VDD VDD sg13_lv_pmos ad=0.2128p pd=1.5u as=0.3976p ps=2.95u w=1.12u l=0.13u
X28 X a_116_82# VSS VSS sg13_lv_nmos ad=0.1406p pd=1.12u as=0.1406p ps=1.12u w=0.74u l=0.13u
X29 VDD a_116_82# X VDD sg13_lv_pmos ad=0.2128p pd=1.5u as=0.2128p ps=1.5u w=1.12u l=0.13u
X30 X a_116_82# VDD VDD sg13_lv_pmos ad=0.2128p pd=1.5u as=0.2128p ps=1.5u w=1.12u l=0.13u
X31 VSS a_116_82# X VSS sg13_lv_nmos ad=0.1406p pd=1.12u as=0.1406p ps=1.12u w=0.74u l=0.13u
X32 VDD a_116_82# X VDD sg13_lv_pmos ad=0.2128p pd=1.5u as=0.2128p ps=1.5u w=1.12u l=0.13u
X33 X a_116_82# VSS VSS sg13_lv_nmos ad=0.1406p pd=1.12u as=0.1406p ps=1.12u w=0.74u l=0.13u
X34 VSS a_116_82# X VSS sg13_lv_nmos ad=0.1406p pd=1.12u as=0.1406p ps=1.12u w=0.74u l=0.13u
X35 X a_116_82# VDD VDD sg13_lv_pmos ad=0.2128p pd=1.5u as=0.2128p ps=1.5u w=1.12u l=0.13u
X36 VDD a_116_82# X VDD sg13_lv_pmos ad=0.2128p pd=1.5u as=0.2128p ps=1.5u w=1.12u l=0.13u
X37 X a_116_82# VSS VSS sg13_lv_nmos ad=0.1406p pd=1.12u as=0.1406p ps=1.12u w=0.74u l=0.13u
X38 VSS a_116_82# X VSS sg13_lv_nmos ad=0.1406p pd=1.12u as=0.1406p ps=1.12u w=0.74u l=0.13u
X39 X a_116_82# VDD VDD sg13_lv_pmos ad=0.2128p pd=1.5u as=0.2128p ps=1.5u w=1.12u l=0.13u
X40 VDD a_116_82# X VDD sg13_lv_pmos ad=0.2128p pd=1.5u as=0.2128p ps=1.5u w=1.12u l=0.13u
X41 X a_116_82# VSS VSS sg13_lv_nmos ad=0.1406p pd=1.12u as=0.1406p ps=1.12u w=0.74u l=0.13u
X42 X a_116_82# VDD VDD sg13_lv_pmos ad=0.2128p pd=1.5u as=0.2128p ps=1.5u w=1.12u l=0.13u
X43 VSS a_116_82# X VSS sg13_lv_nmos ad=0.1406p pd=1.12u as=0.1406p ps=1.12u w=0.74u l=0.13u
.ends

.subckt sg13cmos5l_ocd_ip__por vdd1v2 ena por_unbuf porb por vss
Xrhigh_MGZFWD_0 vss rhigh_MGZFWD_0/R1_1 por_amp_0/inn rhigh_MGZFWD_0/R1_1 rhigh_MGZFWD_0/R2_2
+ rhigh_MGZFWD_0/R1_3 rhigh_MGZFWD_0/R2_2 rhigh_MGZFWD_0/R1_3 rhigh_MGZFWD_0/R2_4
+ rhigh_MGZFWD_0/R1_5 rhigh_MGZFWD_0/R2_4 rhigh_MGZFWD_0/R1_5 rhigh_MGZFWD_0/R2_6
+ rhigh_MGZFWD_0/R1_7 rhigh_MGZFWD_0/R2_6 rhigh_MGZFWD_0/R1_7 rhigh_MGZFWD_0/R2_8
+ rhigh_MGZFWD_0/R1_9 rhigh_MGZFWD_0/R2_8 rhigh_MGZFWD_0/R1_9 rhigh_MGZFWD_0/R2_9
+ rhigh_MGZFWD_0/R1_11 rhigh_MGZFWD_0/R2_9 rhigh_MGZFWD_0/R1_11 rhigh_MGZFWD_0/R2_12
+ rhigh_MGZFWD_0/R1_13 rhigh_MGZFWD_0/R2_12 rhigh_MGZFWD_0/R1_13 rhigh_MGZFWD_0/R2_14
+ rhigh_MGZFWD_0/R1_15 rhigh_MGZFWD_0/R2_14 rhigh_MGZFWD_0/R1_15 rhigh_MGZFWD_0/R2_16
+ rhigh_MGZFWD_0/R1_17 rhigh_MGZFWD_0/R2_16 rhigh_MGZFWD_0/R1_17 rhigh_MGZFWD_0/R2_18
+ rhigh_MGZFWD_0/R1_19 rhigh_MGZFWD_0/R2_18 rhigh_MGZFWD_0/R1_19 rhigh_MGZFWD_0/R2_20
+ rhigh_MGZFWD_0/R1_21 rhigh_MGZFWD_0/R2_20 rhigh_MGZFWD_0/R1_21 rhigh_MGZFWD_0/R2_22
+ rhigh_MGZFWD_0/R1_23 rhigh_MGZFWD_0/R2_22 rhigh_MGZFWD_0/R1_23 rhigh_MGZFWD_0/R2_24
+ rhigh_MGZFWD_0/R1_25 rhigh_MGZFWD_0/R2_24 rhigh_MGZFWD_0/R1_25 rhigh_MGZFWD_0/R2_26
+ rhigh_MGZFWD_0/R1_27 rhigh_MGZFWD_0/R2_26 rhigh_MGZFWD_0/R1_27 rhigh_MGZFWD_0/R2_28
+ rhigh_MGZFWD_0/R1_29 rhigh_MGZFWD_0/R2_28 rhigh_MGZFWD_0/R1_29 rhigh_MGZFWD_0/R2_30
+ rhigh_MGZFWD_0/R1_31 rhigh_MGZFWD_0/R2_30 rhigh_MGZFWD_0/R1_31 rhigh_MGZFWD_0/R2_32
+ rhigh_MGZFWD_0/R1_33 rhigh_MGZFWD_0/R2_32 rhigh_MGZFWD_0/R1_33 rhigh_MGZFWD_0/R2_34
+ rhigh_MGZFWD_0/R1_35 rhigh_MGZFWD_0/R2_34 rhigh_MGZFWD_0/R1_35 rhigh_MGZFWD_0/R2_36
+ rhigh_MGZFWD_0/R1_37 rhigh_MGZFWD_0/R2_36 rhigh_MGZFWD_0/R1_37 rhigh_MGZFWD_0/R2_38
+ rhigh_MGZFWD_0/R1_39 rhigh_MGZFWD_0/R2_38 rhigh_MGZFWD_0/R1_39 rhigh_MGZFWD_0/R2_40
+ rhigh_MGZFWD_0/R1_41 rhigh_MGZFWD_0/R2_40 rhigh_MGZFWD_0/R1_41 rhigh_MGZFWD_0/R2_42
+ rhigh_MGZFWD_0/R1_43 rhigh_MGZFWD_0/R2_42 rhigh_MGZFWD_0/R1_43 rhigh_MGZFWD_0/R2_44
+ rhigh_MGZFWD_0/R1_45 rhigh_MGZFWD_0/R2_44 rhigh_MGZFWD_0/R1_45 rhigh_MGZFWD_0/R2_46
+ rhigh_MGZFWD_0/R1_47 rhigh_MGZFWD_0/R2_46 rhigh_MGZFWD_0/R1_47 rhigh_MGZFWD_0/R2_48
+ rhigh_MGZFWD_0/R1_49 rhigh_MGZFWD_0/R2_48 rhigh_MGZFWD_0/R1_49 rhigh_MGZFWD_0/R2_50
+ rhigh_MGZFWD_0/R1_51 rhigh_MGZFWD_0/R2_50 rhigh_MGZFWD_0/R1_51 rhigh_MGZFWD_0/R2_52
+ rhigh_MGZFWD_0/R1_53 rhigh_MGZFWD_0/R2_52 rhigh_MGZFWD_0/R1_53 vdd1v2 rhigh_MGZFWD
Xrhigh_MGZFWD_1 vss por_amp_0/inp rhigh_MGZFWD_1/R2_1 rhigh_MGZFWD_1/R1_2 rhigh_MGZFWD_1/R2_1
+ rhigh_MGZFWD_1/R1_2 rhigh_MGZFWD_1/R2_3 rhigh_MGZFWD_1/R1_4 rhigh_MGZFWD_1/R2_3
+ rhigh_MGZFWD_1/R1_4 rhigh_MGZFWD_1/R2_5 rhigh_MGZFWD_1/R1_6 rhigh_MGZFWD_1/R2_5
+ rhigh_MGZFWD_1/R1_6 rhigh_MGZFWD_1/R2_7 rhigh_MGZFWD_1/R1_8 rhigh_MGZFWD_1/R2_7
+ rhigh_MGZFWD_1/R1_8 rhigh_MGZFWD_1/R2_9 rhigh_MGZFWD_1/R1_9 rhigh_MGZFWD_1/R2_9
+ rhigh_MGZFWD_1/R1_9 rhigh_MGZFWD_1/R2_11 rhigh_MGZFWD_1/R1_12 rhigh_MGZFWD_1/R2_11
+ rhigh_MGZFWD_1/R1_12 rhigh_MGZFWD_1/R2_13 rhigh_MGZFWD_1/R1_14 rhigh_MGZFWD_1/R2_13
+ rhigh_MGZFWD_1/R1_14 rhigh_MGZFWD_1/R2_15 rhigh_MGZFWD_1/R1_16 rhigh_MGZFWD_1/R2_15
+ rhigh_MGZFWD_1/R1_16 rhigh_MGZFWD_1/R2_17 rhigh_MGZFWD_1/R1_18 rhigh_MGZFWD_1/R2_17
+ rhigh_MGZFWD_1/R1_18 rhigh_MGZFWD_1/R2_19 rhigh_MGZFWD_1/R1_20 rhigh_MGZFWD_1/R2_19
+ rhigh_MGZFWD_1/R1_20 rhigh_MGZFWD_1/R2_21 rhigh_MGZFWD_1/R1_22 rhigh_MGZFWD_1/R2_21
+ rhigh_MGZFWD_1/R1_22 rhigh_MGZFWD_1/R2_23 rhigh_MGZFWD_1/R1_24 rhigh_MGZFWD_1/R2_23
+ rhigh_MGZFWD_1/R1_24 rhigh_MGZFWD_1/R2_25 rhigh_MGZFWD_1/R1_26 rhigh_MGZFWD_1/R2_25
+ rhigh_MGZFWD_1/R1_26 rhigh_MGZFWD_1/R2_27 rhigh_MGZFWD_1/R1_28 rhigh_MGZFWD_1/R2_27
+ rhigh_MGZFWD_1/R1_28 rhigh_MGZFWD_1/R2_29 rhigh_MGZFWD_1/R1_30 rhigh_MGZFWD_1/R2_29
+ rhigh_MGZFWD_1/R1_30 rhigh_MGZFWD_1/R2_31 rhigh_MGZFWD_1/R1_32 rhigh_MGZFWD_1/R2_31
+ rhigh_MGZFWD_1/R1_32 rhigh_MGZFWD_1/R2_33 rhigh_MGZFWD_1/R1_34 rhigh_MGZFWD_1/R2_33
+ rhigh_MGZFWD_1/R1_34 rhigh_MGZFWD_1/R2_35 rhigh_MGZFWD_1/R1_36 rhigh_MGZFWD_1/R2_35
+ rhigh_MGZFWD_1/R1_36 rhigh_MGZFWD_1/R2_37 rhigh_MGZFWD_1/R1_38 rhigh_MGZFWD_1/R2_37
+ rhigh_MGZFWD_1/R1_38 rhigh_MGZFWD_1/R2_39 rhigh_MGZFWD_1/R1_40 rhigh_MGZFWD_1/R2_39
+ rhigh_MGZFWD_1/R1_40 rhigh_MGZFWD_1/R2_41 rhigh_MGZFWD_1/R1_42 rhigh_MGZFWD_1/R2_41
+ rhigh_MGZFWD_1/R1_42 rhigh_MGZFWD_1/R2_43 rhigh_MGZFWD_1/R1_44 rhigh_MGZFWD_1/R2_43
+ rhigh_MGZFWD_1/R1_44 rhigh_MGZFWD_1/R2_45 rhigh_MGZFWD_1/R1_46 rhigh_MGZFWD_1/R2_45
+ rhigh_MGZFWD_1/R1_46 rhigh_MGZFWD_1/R2_47 rhigh_MGZFWD_1/R1_48 rhigh_MGZFWD_1/R2_47
+ rhigh_MGZFWD_1/R1_48 rhigh_MGZFWD_1/R2_49 rhigh_MGZFWD_1/R1_50 rhigh_MGZFWD_1/R2_49
+ rhigh_MGZFWD_1/R1_50 rhigh_MGZFWD_1/R2_51 rhigh_MGZFWD_1/R1_52 rhigh_MGZFWD_1/R2_51
+ rhigh_MGZFWD_1/R1_52 rhigh_MGZFWD_1/R2_53 vss rhigh_MGZFWD_1/R2_53 rhigh_MGZFWD
Xpor_stepdown_0 por_amp_0/inn por_amp_0/nbias por_amp_0/out por_amp_0/inp por_stepdown_0/vcap
+ vss vdd1v2 por_stepdown
Xcap_cmomf_MKAUQG_0[0] por_stepdown_0/vcap vss cap_cmomf_MKAUQG
Xcap_cmomf_MKAUQG_0[1] por_stepdown_0/vcap vss cap_cmomf_MKAUQG
Xcap_cmomf_MKAUQG_0[2] por_stepdown_0/vcap vss cap_cmomf_MKAUQG
Xcap_cmomf_MKAUQG_0[3] por_stepdown_0/vcap vss cap_cmomf_MKAUQG
Xcap_cmomf_MKAUQG_0[4] por_stepdown_0/vcap vss cap_cmomf_MKAUQG
Xcap_cmomf_MKAUQG_0[5] por_stepdown_0/vcap vss cap_cmomf_MKAUQG
Xcap_cmomf_MKAUQG_0[6] por_stepdown_0/vcap vss cap_cmomf_MKAUQG
Xcap_cmomf_MKAUQG_0[7] por_stepdown_0/vcap vss cap_cmomf_MKAUQG
Xcap_cmomf_MKAUQG_1[0] por_stepdown_0/vcap vss cap_cmomf_MKAUQG
Xcap_cmomf_MKAUQG_1[1] por_stepdown_0/vcap vss cap_cmomf_MKAUQG
Xcap_cmomf_MKAUQG_1[2] por_stepdown_0/vcap vss cap_cmomf_MKAUQG
Xcap_cmomf_MKAUQG_1[3] por_stepdown_0/vcap vss cap_cmomf_MKAUQG
Xcap_cmomf_MKAUQG_1[4] por_stepdown_0/vcap vss cap_cmomf_MKAUQG
Xcap_cmomf_MKAUQG_1[5] por_stepdown_0/vcap vss cap_cmomf_MKAUQG
Xcap_cmomf_MKAUQG_1[6] por_stepdown_0/vcap vss cap_cmomf_MKAUQG
Xcap_cmomf_MKAUQG_1[7] por_stepdown_0/vcap vss cap_cmomf_MKAUQG
Xcap_cmomf_7YMNSS_0 por_amp_0/inn por_amp_0/out cap_cmomf_7YMNSS
Xdantenna_WMFCS7_0 vss ena dantenna_WMFCS7
Xcap_cmomf_7YMNSS_1 vss vdd1v2 cap_cmomf_7YMNSS
Xpor_1v2_schmitt_inv_0 vdd1v2 por_stepdown_0/vcap por_unbuf vss por_1v2_schmitt_inv
Xcap_cmomf_T2STT2_0 vss vss por_stepdown_0/vcap cap_cmomf_T2STT2
Xcap_cmomf_T2STT2_1 vss por_stepdown_0/vcap vss cap_cmomf_T2STT2
Xsg13cmos5l_decap_4_0 vdd1v2 vss sg13cmos5l_decap_4
Xpor_amp_0 vdd1v2 por_amp_0/inp ena por_amp_0/nbias por_amp_0/out por_amp_0/inn vss
+ por_amp
Xsg13cmos5l_buf_16_0 por por_unbuf vdd1v2 vss sg13cmos5l_buf_16
Xsg13cmos5l_inv_4_0 sg13cmos5l_inv_4_0/Y por_unbuf vdd1v2 vss sg13cmos5l_inv_4
Xsg13cmos5l_buf_16_1 porb sg13cmos5l_inv_4_0/Y vdd1v2 vss sg13cmos5l_buf_16
.ends

* Black-box entry subcircuit for slot7_wrapper abstract view
.subckt slot7_wrapper vss_1v2 s7_an_0_vref s7_an_0_outp s7_an_0_outn s7_an_0_vcm s7_an_0_en_3v3
+ s7_an_0_en_3v3_b s7_an_0_iref s7_an_1_vinp s7_an_1_vinn s7_an_1_vref s7_an_1_iref
+ s7_an_1_en_3v3_b s7_an_1_en_3v3 vbias dig_in[23] dig_in[22] dig_in[21] dig_in[20]
+ dig_in[19] dig_in[18] dig_in[17] dig_in[16] dig_in[15] dig_in[14] dig_in[13] dig_in[12]
+ dig_in[11] dig_in[10] dig_in[9] dig_in[8] dig_in[7] dig_in[6] dig_in[5] dig_in[4]
+ dig_in[3] dig_in[2] dig_in[1] dig_in[0] dig_out[11] dig_out[10] dig_out[9] dig_out[8]
+ dig_out[7] dig_out[6] dig_out[5] dig_out[4] dig_out[3] dig_out[2] dig_out[1] dig_out[0]
+ ibias0 ibias1 analog_bus3 analog_bus2 analog_bus1 analog_bus0 vdd_1v2 vss_3v3 vdd_3v3
+ enable clk reset
.ends

* Black-box entry subcircuit for slot11_wrapper abstract view
.subckt slot11_wrapper vss_1v2 s11_an[0] s11_an_0_esd vbias dig_in[23] dig_in[22]
+ dig_in[21] dig_in[20] dig_in[19] dig_in[18] dig_in[17] dig_in[16] dig_in[15] dig_in[14]
+ dig_in[13] dig_in[12] dig_in[11] dig_in[10] dig_in[9] dig_in[8] dig_in[7] dig_in[6]
+ dig_in[5] dig_in[4] dig_in[3] dig_in[2] dig_in[1] dig_in[0] dig_out[11] dig_out[10]
+ dig_out[9] dig_out[8] dig_out[7] dig_out[6] dig_out[5] dig_out[4] dig_out[3] dig_out[2]
+ dig_out[1] dig_out[0] ibias0 ibias1 analog_bus3 analog_bus2 analog_bus1 analog_bus0
+ vdd_1v2 vss_3v3 vdd_3v3 enable clk reset
.ends

* Black-box entry subcircuit for slot15_wrapper abstract view
.subckt slot15_wrapper vss_3v3 s15_an[0] s15_an_0_esd vbias dig_in[23] dig_in[22]
+ dig_in[21] dig_in[20] dig_in[19] dig_in[18] dig_in[17] dig_in[16] dig_in[15] dig_in[14]
+ dig_in[13] dig_in[12] dig_in[11] dig_in[10] dig_in[9] dig_in[8] dig_in[7] dig_in[6]
+ dig_in[5] dig_in[4] dig_in[3] dig_in[2] dig_in[1] dig_in[0] dig_out[11] dig_out[10]
+ dig_out[9] dig_out[8] dig_out[7] dig_out[6] dig_out[5] dig_out[4] dig_out[3] dig_out[2]
+ dig_out[1] dig_out[0] ibias0 ibias1 analog_bus3 analog_bus2 analog_bus1 analog_bus0
+ vss_1v2 vdd_1v2 vdd_3v3 enable clk reset
.ends

.subckt RM_IHPSG13_1P_DLY_4 Z A VSS VDD
X0 VSS a_599_496# a_531_576# VSS sg13_lv_nmos ad=0.1577p pd=1.21u as=0.2822p ps=2.34u w=0.83u l=0.3u
X1 VSS a_89_496# a_21_576# VSS sg13_lv_nmos ad=0.1577p pd=1.21u as=0.2822p ps=2.34u w=0.83u l=0.3u
X2 a_2671_682# a_2461_102# a_2571_102# VSS sg13_lv_nmos ad=48f pd=0.62u as=0.102p ps=1.28u w=0.3u l=0.16u
X3 VSS a_2461_102# a_2671_682# VSS sg13_lv_nmos ad=57f pd=0.68u as=48f ps=0.62u w=0.3u l=0.16u
X4 a_3181_682# a_2971_102# a_3081_102# VSS sg13_lv_nmos ad=48f pd=0.62u as=0.102p ps=1.28u w=0.3u l=0.16u
X5 VSS a_2971_102# a_3181_682# VSS sg13_lv_nmos ad=57f pd=0.68u as=48f ps=0.62u w=0.3u l=0.16u
X6 a_2671_102# a_2461_102# a_2571_102# VDD sg13_lv_pmos ad=0.1152p pd=1.04u as=0.2448p ps=2.12u w=0.72u l=0.16u
X7 VDD a_2461_102# a_2671_102# VDD sg13_lv_pmos ad=0.1368p pd=1.1u as=0.1152p ps=1.04u w=0.72u l=0.16u
X8 a_3181_102# a_2971_102# a_3081_102# VDD sg13_lv_pmos ad=0.1152p pd=1.04u as=0.2448p ps=2.12u w=0.72u l=0.16u
X9 VDD a_2971_102# a_3181_102# VDD sg13_lv_pmos ad=0.1368p pd=1.1u as=0.1152p ps=1.04u w=0.72u l=0.16u
R0 m1_1341_104# a_2061_435# 0.253846
X10 VSS a_599_496# a_531_576# VSS sg13_lv_nmos ad=0.2822p pd=2.34u as=0.1577p ps=1.21u w=0.83u l=0.3u
X11 a_2875_682# a_2571_102# VSS VSS sg13_lv_nmos ad=48f pd=0.62u as=57f ps=0.68u w=0.3u l=0.16u
X12 a_3385_682# a_3081_102# VSS VSS sg13_lv_nmos ad=48f pd=0.62u as=57f ps=0.68u w=0.3u l=0.16u
X13 a_3481_102# a_3081_102# a_3385_682# VSS sg13_lv_nmos ad=0.102p pd=1.28u as=48f ps=0.62u w=0.3u l=0.16u
X14 a_2875_102# a_2571_102# VDD VDD sg13_lv_pmos ad=0.1152p pd=1.04u as=0.1368p ps=1.1u w=0.72u l=0.16u
X15 a_3385_102# a_3081_102# VDD VDD sg13_lv_pmos ad=0.1152p pd=1.04u as=0.1368p ps=1.1u w=0.72u l=0.16u
X16 a_531_576# a_599_496# VSS VSS sg13_lv_nmos ad=0.1577p pd=1.21u as=0.1577p ps=1.21u w=0.83u l=0.3u
X17 a_2971_102# a_2571_102# a_2875_682# VSS sg13_lv_nmos ad=0.102p pd=1.28u as=48f ps=0.62u w=0.3u l=0.16u
X18 a_89_496# a_21_576# VDD VDD sg13_lv_pmos ad=0.3078p pd=2u as=0.5508p ps=3.92u w=1.62u l=0.64u
X19 a_2971_102# a_2571_102# a_2875_102# VDD sg13_lv_pmos ad=0.2448p pd=2.12u as=0.1152p ps=1.04u w=0.72u l=0.16u
X20 a_3481_102# a_3081_102# a_3385_102# VDD sg13_lv_pmos ad=0.2448p pd=2.12u as=0.1152p ps=1.04u w=0.72u l=0.16u
R1 A m1_321_104# 0.253846
X21 a_3691_682# a_3481_102# a_3591_102# VSS sg13_lv_nmos ad=48f pd=0.62u as=0.102p ps=1.28u w=0.3u l=0.16u
X22 VSS a_3481_102# a_3691_682# VSS sg13_lv_nmos ad=57f pd=0.68u as=48f ps=0.62u w=0.3u l=0.16u
X23 VDD a_3481_102# a_3691_102# VDD sg13_lv_pmos ad=0.1368p pd=1.1u as=0.1152p ps=1.04u w=0.72u l=0.16u
X24 VDD a_1551_576# a_1619_496# VDD sg13_lv_pmos ad=0.5508p pd=3.92u as=0.3078p ps=2u w=1.62u l=0.64u
X25 a_3691_102# a_3481_102# a_3591_102# VDD sg13_lv_pmos ad=0.1152p pd=1.04u as=0.2448p ps=2.12u w=0.72u l=0.16u
X26 a_3895_682# a_3591_102# VSS VSS sg13_lv_nmos ad=48f pd=0.62u as=57f ps=0.68u w=0.3u l=0.16u
X27 Z a_3591_102# a_3895_682# VSS sg13_lv_nmos ad=0.102p pd=1.28u as=48f ps=0.62u w=0.3u l=0.16u
X28 a_3895_102# a_3591_102# VDD VDD sg13_lv_pmos ad=0.1152p pd=1.04u as=0.1368p ps=1.1u w=0.72u l=0.16u
X29 Z a_3591_102# a_3895_102# VDD sg13_lv_pmos ad=0.2448p pd=2.12u as=0.1152p ps=1.04u w=0.72u l=0.16u
X30 VSS a_1109_496# a_1041_576# VSS sg13_lv_nmos ad=0.2822p pd=2.34u as=0.1577p ps=1.21u w=0.83u l=0.3u
X31 VDD a_1041_576# a_1109_496# VDD sg13_lv_pmos ad=0.5508p pd=3.92u as=0.3078p ps=2u w=1.62u l=0.64u
X32 a_1619_496# a_1551_576# VDD VDD sg13_lv_pmos ad=0.3078p pd=2u as=0.5508p ps=3.92u w=1.62u l=0.64u
X33 a_1041_576# a_1109_496# VSS VSS sg13_lv_nmos ad=0.1577p pd=1.21u as=0.1577p ps=1.21u w=0.83u l=0.3u
R2 m1_321_104# m1_831_104# 0.253846
X34 VSS a_1109_496# a_1041_576# VSS sg13_lv_nmos ad=0.1577p pd=1.21u as=0.2822p ps=2.34u w=0.83u l=0.3u
X35 a_1109_496# a_1041_576# VDD VDD sg13_lv_pmos ad=0.3078p pd=2u as=0.5508p ps=3.92u w=1.62u l=0.64u
X36 VDD a_531_576# a_599_496# VDD sg13_lv_pmos ad=0.5508p pd=3.92u as=0.3078p ps=2u w=1.62u l=0.64u
X37 VSS a_1619_496# a_1551_576# VSS sg13_lv_nmos ad=0.2822p pd=2.34u as=0.1577p ps=1.21u w=0.83u l=0.3u
X38 a_1551_576# a_1619_496# VSS VSS sg13_lv_nmos ad=0.1577p pd=1.21u as=0.1577p ps=1.21u w=0.83u l=0.3u
X39 VSS a_1619_496# a_1551_576# VSS sg13_lv_nmos ad=0.1577p pd=1.21u as=0.2822p ps=2.34u w=0.83u l=0.3u
X40 a_2161_682# a_2061_435# a_2061_102# VSS sg13_lv_nmos ad=48f pd=0.62u as=0.102p ps=1.28u w=0.3u l=0.16u
X41 VSS a_2061_435# a_2161_682# VSS sg13_lv_nmos ad=57f pd=0.68u as=48f ps=0.62u w=0.3u l=0.16u
X42 VDD a_21_576# a_89_496# VDD sg13_lv_pmos ad=0.5508p pd=3.92u as=0.3078p ps=2u w=1.62u l=0.64u
X43 a_599_496# a_531_576# VDD VDD sg13_lv_pmos ad=0.3078p pd=2u as=0.5508p ps=3.92u w=1.62u l=0.64u
X44 a_2161_102# a_2061_435# a_2061_102# VDD sg13_lv_pmos ad=0.1152p pd=1.04u as=0.2448p ps=2.12u w=0.72u l=0.16u
X45 VDD a_2061_435# a_2161_102# VDD sg13_lv_pmos ad=0.1368p pd=1.1u as=0.1152p ps=1.04u w=0.72u l=0.16u
R3 m1_831_104# m1_1341_104# 0.253846
X46 VSS a_89_496# a_21_576# VSS sg13_lv_nmos ad=0.2822p pd=2.34u as=0.1577p ps=1.21u w=0.83u l=0.3u
X47 a_2365_682# a_2061_102# VSS VSS sg13_lv_nmos ad=48f pd=0.62u as=57f ps=0.68u w=0.3u l=0.16u
X48 a_21_576# a_89_496# VSS VSS sg13_lv_nmos ad=0.1577p pd=1.21u as=0.1577p ps=1.21u w=0.83u l=0.3u
X49 a_2461_102# a_2061_102# a_2365_682# VSS sg13_lv_nmos ad=0.102p pd=1.28u as=48f ps=0.62u w=0.3u l=0.16u
X50 a_2365_102# a_2061_102# VDD VDD sg13_lv_pmos ad=0.1152p pd=1.04u as=0.1368p ps=1.1u w=0.72u l=0.16u
X51 a_2461_102# a_2061_102# a_2365_102# VDD sg13_lv_pmos ad=0.2448p pd=2.12u as=0.1152p ps=1.04u w=0.72u l=0.16u
.ends

.subckt RM_IHPSG13_1P_WLDRV16X4 Z<14> Z<13> Z<12> Z<11> Z<10> Z<9> Z<8> Z<7> Z<6>
+ Z<5> Z<4> Z<3> Z<2> Z<1> Z<0> A<1> Z<15> A<2> A<13> A<12> A<0> A<15> A<14> A<3>
+ A<11> A<10> A<6> A<8> A<5> A<4> A<9> A<7> VDD VSS m4_468_n56#
X0 Z<8> a_123_1778# VSS VSS sg13_lv_nmos ad=0.2397p pd=2.09u as=0.16417p ps=1.28u w=0.705u l=0.13u
X1 Z<9> a_531_1778# VSS VSS sg13_lv_nmos ad=0.2397p pd=2.09u as=0.16417p ps=1.28u w=0.705u l=0.13u
X2 VDD A<5> a_531_936# VDD sg13_lv_pmos ad=0.2538p pd=2u as=0.306p ps=2.48u w=0.9u l=0.13u
X3 VDD A<11> a_1347_1778# VDD sg13_lv_pmos ad=0.2538p pd=2u as=0.306p ps=2.48u w=0.9u l=0.13u
X4 Z<1> a_531_98# VDD VDD sg13_lv_pmos ad=0.3078p pd=2u as=0.2538p ps=2u w=1.62u l=0.13u
X5 Z<15> a_1347_2616# VSS VSS sg13_lv_nmos ad=0.2397p pd=2.09u as=0.16417p ps=1.28u w=0.705u l=0.13u
X6 VDD A<14> a_939_2616# VDD sg13_lv_pmos ad=0.2538p pd=2u as=0.306p ps=2.48u w=0.9u l=0.13u
X7 VDD a_531_98# Z<1> VDD sg13_lv_pmos ad=0.5508p pd=3.92u as=0.3078p ps=2u w=1.62u l=0.13u
X8 Z<11> a_1347_1778# VSS VSS sg13_lv_nmos ad=0.2397p pd=2.09u as=0.16417p ps=1.28u w=0.705u l=0.13u
X9 VDD A<2> a_939_98# VDD sg13_lv_pmos ad=0.2538p pd=2u as=0.306p ps=2.48u w=0.9u l=0.13u
X10 VDD A<12> a_123_2616# VDD sg13_lv_pmos ad=0.2538p pd=2u as=0.306p ps=2.48u w=0.9u l=0.13u
X11 VDD A<13> a_531_2616# VDD sg13_lv_pmos ad=0.2538p pd=2u as=0.306p ps=2.48u w=0.9u l=0.13u
X12 Z<10> a_939_1778# VDD VDD sg13_lv_pmos ad=0.3078p pd=2u as=0.2538p ps=2u w=1.62u l=0.13u
X13 Z<2> a_939_98# VSS VSS sg13_lv_nmos ad=0.2397p pd=2.09u as=0.16417p ps=1.28u w=0.705u l=0.13u
X14 Z<8> a_123_1778# VDD VDD sg13_lv_pmos ad=0.3078p pd=2u as=0.2538p ps=2u w=1.62u l=0.13u
X15 Z<9> a_531_1778# VDD VDD sg13_lv_pmos ad=0.3078p pd=2u as=0.2538p ps=2u w=1.62u l=0.13u
X16 Z<5> a_531_936# VDD VDD sg13_lv_pmos ad=0.3078p pd=2u as=0.2538p ps=2u w=1.62u l=0.13u
X17 VDD a_531_936# Z<5> VDD sg13_lv_pmos ad=0.5508p pd=3.92u as=0.3078p ps=2u w=1.62u l=0.13u
X18 VDD A<3> a_1347_98# VDD sg13_lv_pmos ad=0.2538p pd=2u as=0.306p ps=2.48u w=0.9u l=0.13u
X19 Z<14> a_939_2616# VDD VDD sg13_lv_pmos ad=0.3078p pd=2u as=0.2538p ps=2u w=1.62u l=0.13u
X20 VDD A<15> a_1347_2616# VDD sg13_lv_pmos ad=0.2538p pd=2u as=0.306p ps=2.48u w=0.9u l=0.13u
X21 Z<6> a_939_936# VSS VSS sg13_lv_nmos ad=0.2397p pd=2.09u as=0.16417p ps=1.28u w=0.705u l=0.13u
X22 VDD A<0> a_123_98# VDD sg13_lv_pmos ad=0.2538p pd=2u as=0.306p ps=2.48u w=0.9u l=0.13u
X23 Z<2> a_939_98# VDD VDD sg13_lv_pmos ad=0.3078p pd=2u as=0.2538p ps=2u w=1.62u l=0.13u
X24 VSS A<14> a_939_2616# VSS sg13_lv_nmos ad=0.16417p pd=1.28u as=0.306p ps=2.48u w=0.9u l=0.13u
X25 VDD a_939_98# Z<2> VDD sg13_lv_pmos ad=0.5508p pd=3.92u as=0.3078p ps=2u w=1.62u l=0.13u
X26 Z<12> a_123_2616# VDD VDD sg13_lv_pmos ad=0.3078p pd=2u as=0.2538p ps=2u w=1.62u l=0.13u
X27 Z<13> a_531_2616# VDD VDD sg13_lv_pmos ad=0.3078p pd=2u as=0.2538p ps=2u w=1.62u l=0.13u
X28 Z<11> a_1347_1778# VDD VDD sg13_lv_pmos ad=0.3078p pd=2u as=0.2538p ps=2u w=1.62u l=0.13u
X29 Z<4> a_123_936# VSS VSS sg13_lv_nmos ad=0.2397p pd=2.09u as=0.16417p ps=1.28u w=0.705u l=0.13u
X30 Z<5> a_531_936# VSS VSS sg13_lv_nmos ad=0.2397p pd=2.09u as=0.16417p ps=1.28u w=0.705u l=0.13u
X31 VSS A<12> a_123_2616# VSS sg13_lv_nmos ad=0.16417p pd=1.28u as=0.306p ps=2.48u w=0.9u l=0.13u
X32 VSS A<13> a_531_2616# VSS sg13_lv_nmos ad=0.16417p pd=1.28u as=0.306p ps=2.48u w=0.9u l=0.13u
X33 VDD a_531_1778# Z<9> VDD sg13_lv_pmos ad=0.5508p pd=3.92u as=0.3078p ps=2u w=1.62u l=0.13u
X34 Z<0> a_123_98# VSS VSS sg13_lv_nmos ad=0.2397p pd=2.09u as=0.16417p ps=1.28u w=0.705u l=0.13u
X35 VSS A<1> a_531_98# VSS sg13_lv_nmos ad=0.16417p pd=1.28u as=0.306p ps=2.48u w=0.9u l=0.13u
X36 Z<3> a_1347_98# VSS VSS sg13_lv_nmos ad=0.2397p pd=2.09u as=0.16417p ps=1.28u w=0.705u l=0.13u
X37 VDD a_123_1778# Z<8> VDD sg13_lv_pmos ad=0.5508p pd=3.92u as=0.3078p ps=2u w=1.62u l=0.13u
X38 VDD A<6> a_939_936# VDD sg13_lv_pmos ad=0.2538p pd=2u as=0.306p ps=2.48u w=0.9u l=0.13u
X39 Z<6> a_939_936# VDD VDD sg13_lv_pmos ad=0.3078p pd=2u as=0.2538p ps=2u w=1.62u l=0.13u
X40 Z<3> a_1347_98# VDD VDD sg13_lv_pmos ad=0.3078p pd=2u as=0.2538p ps=2u w=1.62u l=0.13u
X41 VSS A<2> a_939_98# VSS sg13_lv_nmos ad=0.16417p pd=1.28u as=0.306p ps=2.48u w=0.9u l=0.13u
X42 VDD a_939_936# Z<6> VDD sg13_lv_pmos ad=0.5508p pd=3.92u as=0.3078p ps=2u w=1.62u l=0.13u
X43 Z<15> a_1347_2616# VDD VDD sg13_lv_pmos ad=0.3078p pd=2u as=0.2538p ps=2u w=1.62u l=0.13u
X44 Z<7> a_1347_936# VSS VSS sg13_lv_nmos ad=0.2397p pd=2.09u as=0.16417p ps=1.28u w=0.705u l=0.13u
X45 Z<0> a_123_98# VDD VDD sg13_lv_pmos ad=0.3078p pd=2u as=0.2538p ps=2u w=1.62u l=0.13u
X46 VDD A<1> a_531_98# VDD sg13_lv_pmos ad=0.2538p pd=2u as=0.306p ps=2.48u w=0.9u l=0.13u
X47 VDD a_1347_98# Z<3> VDD sg13_lv_pmos ad=0.5508p pd=3.92u as=0.3078p ps=2u w=1.62u l=0.13u
X48 Z<1> a_531_98# VSS VSS sg13_lv_nmos ad=0.2397p pd=2.09u as=0.16417p ps=1.28u w=0.705u l=0.13u
X49 VSS A<15> a_1347_2616# VSS sg13_lv_nmos ad=0.16417p pd=1.28u as=0.306p ps=2.48u w=0.9u l=0.13u
X50 VDD a_531_2616# Z<13> VDD sg13_lv_pmos ad=0.5508p pd=3.92u as=0.3078p ps=2u w=1.62u l=0.13u
X51 VDD a_123_2616# Z<12> VDD sg13_lv_pmos ad=0.5508p pd=3.92u as=0.3078p ps=2u w=1.62u l=0.13u
X52 VDD a_939_1778# Z<10> VDD sg13_lv_pmos ad=0.5508p pd=3.92u as=0.3078p ps=2u w=1.62u l=0.13u
X53 VDD a_1347_1778# Z<11> VDD sg13_lv_pmos ad=0.5508p pd=3.92u as=0.3078p ps=2u w=1.62u l=0.13u
X54 VSS A<10> a_939_1778# VSS sg13_lv_nmos ad=0.16417p pd=1.28u as=0.306p ps=2.48u w=0.9u l=0.13u
X55 VDD a_123_98# Z<0> VDD sg13_lv_pmos ad=0.5508p pd=3.92u as=0.3078p ps=2u w=1.62u l=0.13u
X56 VSS A<8> a_123_1778# VSS sg13_lv_nmos ad=0.16417p pd=1.28u as=0.306p ps=2.48u w=0.9u l=0.13u
X57 VSS A<9> a_531_1778# VSS sg13_lv_nmos ad=0.16417p pd=1.28u as=0.306p ps=2.48u w=0.9u l=0.13u
X58 VSS A<6> a_939_936# VSS sg13_lv_nmos ad=0.16417p pd=1.28u as=0.306p ps=2.48u w=0.9u l=0.13u
X59 VDD A<7> a_1347_936# VDD sg13_lv_pmos ad=0.2538p pd=2u as=0.306p ps=2.48u w=0.9u l=0.13u
X60 VSS A<4> a_123_936# VSS sg13_lv_nmos ad=0.16417p pd=1.28u as=0.306p ps=2.48u w=0.9u l=0.13u
X61 VSS A<5> a_531_936# VSS sg13_lv_nmos ad=0.16417p pd=1.28u as=0.306p ps=2.48u w=0.9u l=0.13u
X62 VDD A<4> a_123_936# VDD sg13_lv_pmos ad=0.2538p pd=2u as=0.306p ps=2.48u w=0.9u l=0.13u
X63 Z<7> a_1347_936# VDD VDD sg13_lv_pmos ad=0.3078p pd=2u as=0.2538p ps=2u w=1.62u l=0.13u
X64 VDD A<10> a_939_1778# VDD sg13_lv_pmos ad=0.2538p pd=2u as=0.306p ps=2.48u w=0.9u l=0.13u
X65 VSS A<0> a_123_98# VSS sg13_lv_nmos ad=0.16417p pd=1.28u as=0.306p ps=2.48u w=0.9u l=0.13u
X66 VSS A<3> a_1347_98# VSS sg13_lv_nmos ad=0.16417p pd=1.28u as=0.306p ps=2.48u w=0.9u l=0.13u
X67 VDD A<8> a_123_1778# VDD sg13_lv_pmos ad=0.2538p pd=2u as=0.306p ps=2.48u w=0.9u l=0.13u
X68 VDD A<9> a_531_1778# VDD sg13_lv_pmos ad=0.2538p pd=2u as=0.306p ps=2.48u w=0.9u l=0.13u
X69 Z<4> a_123_936# VDD VDD sg13_lv_pmos ad=0.3078p pd=2u as=0.2538p ps=2u w=1.62u l=0.13u
X70 VDD a_1347_936# Z<7> VDD sg13_lv_pmos ad=0.5508p pd=3.92u as=0.3078p ps=2u w=1.62u l=0.13u
X71 Z<14> a_939_2616# VSS VSS sg13_lv_nmos ad=0.2397p pd=2.09u as=0.16417p ps=1.28u w=0.705u l=0.13u
X72 VDD a_939_2616# Z<14> VDD sg13_lv_pmos ad=0.5508p pd=3.92u as=0.3078p ps=2u w=1.62u l=0.13u
X73 VDD a_1347_2616# Z<15> VDD sg13_lv_pmos ad=0.5508p pd=3.92u as=0.3078p ps=2u w=1.62u l=0.13u
X74 VDD a_123_936# Z<4> VDD sg13_lv_pmos ad=0.5508p pd=3.92u as=0.3078p ps=2u w=1.62u l=0.13u
X75 Z<12> a_123_2616# VSS VSS sg13_lv_nmos ad=0.2397p pd=2.09u as=0.16417p ps=1.28u w=0.705u l=0.13u
X76 Z<13> a_531_2616# VSS VSS sg13_lv_nmos ad=0.2397p pd=2.09u as=0.16417p ps=1.28u w=0.705u l=0.13u
X77 Z<10> a_939_1778# VSS VSS sg13_lv_nmos ad=0.2397p pd=2.09u as=0.16417p ps=1.28u w=0.705u l=0.13u
X78 VSS A<11> a_1347_1778# VSS sg13_lv_nmos ad=0.16417p pd=1.28u as=0.306p ps=2.48u w=0.9u l=0.13u
X79 VSS A<7> a_1347_936# VSS sg13_lv_nmos ad=0.16417p pd=1.28u as=0.306p ps=2.48u w=0.9u l=0.13u
.ends

.subckt RM_IHPSG13_1P_DLY_2 Z A VSS VDD
X0 VSS a_599_496# a_531_576# VSS sg13_lv_nmos ad=0.1577p pd=1.21u as=0.2822p ps=2.34u w=0.83u l=0.3u
X1 VSS a_2129_496# a_2061_576# VSS sg13_lv_nmos ad=0.2822p pd=2.34u as=0.1577p ps=1.21u w=0.83u l=0.3u
X2 a_2571_576# a_2639_496# VSS VSS sg13_lv_nmos ad=0.1577p pd=1.21u as=0.1577p ps=1.21u w=0.83u l=0.3u
X3 VSS a_2639_496# a_2571_576# VSS sg13_lv_nmos ad=0.1577p pd=1.21u as=0.2822p ps=2.34u w=0.83u l=0.3u
X4 VSS a_89_496# a_21_576# VSS sg13_lv_nmos ad=0.1577p pd=1.21u as=0.2822p ps=2.34u w=0.83u l=0.3u
X5 a_3181_682# a_3081_435# a_3081_102# VSS sg13_lv_nmos ad=48f pd=0.62u as=0.102p ps=1.28u w=0.3u l=0.16u
X6 VSS a_3081_435# a_3181_682# VSS sg13_lv_nmos ad=57f pd=0.68u as=48f ps=0.62u w=0.3u l=0.16u
X7 a_3181_102# a_3081_435# a_3081_102# VDD sg13_lv_pmos ad=0.1152p pd=1.04u as=0.2448p ps=2.12u w=0.72u l=0.16u
X8 VDD a_3081_435# a_3181_102# VDD sg13_lv_pmos ad=0.1368p pd=1.1u as=0.1152p ps=1.04u w=0.72u l=0.16u
R0 m1_1341_104# m1_1851_104# 0.253846
R1 m1_1851_104# m1_2361_104# 0.253846
X9 VSS a_599_496# a_531_576# VSS sg13_lv_nmos ad=0.2822p pd=2.34u as=0.1577p ps=1.21u w=0.83u l=0.3u
X10 a_3385_682# a_3081_102# VSS VSS sg13_lv_nmos ad=48f pd=0.62u as=57f ps=0.68u w=0.3u l=0.16u
X11 a_3481_102# a_3081_102# a_3385_682# VSS sg13_lv_nmos ad=0.102p pd=1.28u as=48f ps=0.62u w=0.3u l=0.16u
X12 a_3385_102# a_3081_102# VDD VDD sg13_lv_pmos ad=0.1152p pd=1.04u as=0.1368p ps=1.1u w=0.72u l=0.16u
X13 a_531_576# a_599_496# VSS VSS sg13_lv_nmos ad=0.1577p pd=1.21u as=0.1577p ps=1.21u w=0.83u l=0.3u
X14 a_89_496# a_21_576# VDD VDD sg13_lv_pmos ad=0.3078p pd=2u as=0.5508p ps=3.92u w=1.62u l=0.64u
X15 a_3481_102# a_3081_102# a_3385_102# VDD sg13_lv_pmos ad=0.2448p pd=2.12u as=0.1152p ps=1.04u w=0.72u l=0.16u
X16 VSS a_2639_496# a_2571_576# VSS sg13_lv_nmos ad=0.2822p pd=2.34u as=0.1577p ps=1.21u w=0.83u l=0.3u
R2 A m1_321_104# 0.253846
X17 a_3691_682# a_3481_102# a_3591_102# VSS sg13_lv_nmos ad=48f pd=0.62u as=0.102p ps=1.28u w=0.3u l=0.16u
X18 VSS a_3481_102# a_3691_682# VSS sg13_lv_nmos ad=57f pd=0.68u as=48f ps=0.62u w=0.3u l=0.16u
X19 VDD a_3481_102# a_3691_102# VDD sg13_lv_pmos ad=0.1368p pd=1.1u as=0.1152p ps=1.04u w=0.72u l=0.16u
X20 VDD a_1551_576# a_1619_496# VDD sg13_lv_pmos ad=0.5508p pd=3.92u as=0.3078p ps=2u w=1.62u l=0.64u
X21 a_3691_102# a_3481_102# a_3591_102# VDD sg13_lv_pmos ad=0.1152p pd=1.04u as=0.2448p ps=2.12u w=0.72u l=0.16u
R3 m1_2361_104# a_3081_435# 0.253846
X22 a_3895_682# a_3591_102# VSS VSS sg13_lv_nmos ad=48f pd=0.62u as=57f ps=0.68u w=0.3u l=0.16u
X23 Z a_3591_102# a_3895_682# VSS sg13_lv_nmos ad=0.102p pd=1.28u as=48f ps=0.62u w=0.3u l=0.16u
X24 VDD a_2571_576# a_2639_496# VDD sg13_lv_pmos ad=0.5508p pd=3.92u as=0.3078p ps=2u w=1.62u l=0.64u
X25 a_3895_102# a_3591_102# VDD VDD sg13_lv_pmos ad=0.1152p pd=1.04u as=0.1368p ps=1.1u w=0.72u l=0.16u
X26 Z a_3591_102# a_3895_102# VDD sg13_lv_pmos ad=0.2448p pd=2.12u as=0.1152p ps=1.04u w=0.72u l=0.16u
X27 VSS a_1109_496# a_1041_576# VSS sg13_lv_nmos ad=0.2822p pd=2.34u as=0.1577p ps=1.21u w=0.83u l=0.3u
X28 VDD a_1041_576# a_1109_496# VDD sg13_lv_pmos ad=0.5508p pd=3.92u as=0.3078p ps=2u w=1.62u l=0.64u
X29 a_1619_496# a_1551_576# VDD VDD sg13_lv_pmos ad=0.3078p pd=2u as=0.5508p ps=3.92u w=1.62u l=0.64u
X30 a_1041_576# a_1109_496# VSS VSS sg13_lv_nmos ad=0.1577p pd=1.21u as=0.1577p ps=1.21u w=0.83u l=0.3u
R4 m1_321_104# m1_831_104# 0.253846
X31 VDD a_2061_576# a_2129_496# VDD sg13_lv_pmos ad=0.5508p pd=3.92u as=0.3078p ps=2u w=1.62u l=0.64u
X32 a_2639_496# a_2571_576# VDD VDD sg13_lv_pmos ad=0.3078p pd=2u as=0.5508p ps=3.92u w=1.62u l=0.64u
X33 VSS a_1109_496# a_1041_576# VSS sg13_lv_nmos ad=0.1577p pd=1.21u as=0.2822p ps=2.34u w=0.83u l=0.3u
X34 a_1109_496# a_1041_576# VDD VDD sg13_lv_pmos ad=0.3078p pd=2u as=0.5508p ps=3.92u w=1.62u l=0.64u
X35 a_2129_496# a_2061_576# VDD VDD sg13_lv_pmos ad=0.3078p pd=2u as=0.5508p ps=3.92u w=1.62u l=0.64u
X36 VDD a_531_576# a_599_496# VDD sg13_lv_pmos ad=0.5508p pd=3.92u as=0.3078p ps=2u w=1.62u l=0.64u
X37 VSS a_1619_496# a_1551_576# VSS sg13_lv_nmos ad=0.2822p pd=2.34u as=0.1577p ps=1.21u w=0.83u l=0.3u
X38 a_1551_576# a_1619_496# VSS VSS sg13_lv_nmos ad=0.1577p pd=1.21u as=0.1577p ps=1.21u w=0.83u l=0.3u
X39 a_2061_576# a_2129_496# VSS VSS sg13_lv_nmos ad=0.1577p pd=1.21u as=0.1577p ps=1.21u w=0.83u l=0.3u
X40 VSS a_2129_496# a_2061_576# VSS sg13_lv_nmos ad=0.1577p pd=1.21u as=0.2822p ps=2.34u w=0.83u l=0.3u
X41 VSS a_1619_496# a_1551_576# VSS sg13_lv_nmos ad=0.1577p pd=1.21u as=0.2822p ps=2.34u w=0.83u l=0.3u
X42 VDD a_21_576# a_89_496# VDD sg13_lv_pmos ad=0.5508p pd=3.92u as=0.3078p ps=2u w=1.62u l=0.64u
X43 a_599_496# a_531_576# VDD VDD sg13_lv_pmos ad=0.3078p pd=2u as=0.5508p ps=3.92u w=1.62u l=0.64u
R5 m1_831_104# m1_1341_104# 0.253846
X44 VSS a_89_496# a_21_576# VSS sg13_lv_nmos ad=0.2822p pd=2.34u as=0.1577p ps=1.21u w=0.83u l=0.3u
X45 a_21_576# a_89_496# VSS VSS sg13_lv_nmos ad=0.1577p pd=1.21u as=0.1577p ps=1.21u w=0.83u l=0.3u
.ends

.subckt RM_IHPSG13_1P_COLDRV13X4 WCLK_O DCLK_O ADDR_DEC_O<5> RCLK_O ADDR_DEC_O<7>
+ ADDR_DEC_O<4> ADDR_DEC_O<6> ADDR_COL_O<0> ADDR_COL_O<1> ADDR_DEC_O<3> WCLK_I ADDR_DEC_I<6>
+ ADDR_DEC_I<5> ADDR_DEC_I<1> ADDR_DEC_I<3> ADDR_COL_I<1> ADDR_COL_I<0> ADDR_DEC_I<2>
+ ADDR_DEC_I<4> ADDR_DEC_I<0> ADDR_DEC_I<7> ADDR_DEC_O<1> ADDR_DEC_O<0> ADDR_DEC_O<2>
+ RCLK_I VDD_uq0 VDD_uq1 m3_0_n6153# DCLK_I VDD_uq2 m3_0_n6573# VSS VDD m3_0_n273#
X0 ADDR_DEC_O<7> a_21_n4942# VSS VSS sg13_lv_nmos ad=0.13395p pd=1.085u as=0.13395p ps=1.085u w=0.705u l=0.13u
X1 VDD ADDR_DEC_I<4> a_429_n5784# VDD sg13_lv_pmos ad=0.3078p pd=2u as=0.5508p ps=3.92u w=1.62u l=0.13u
X2 RCLK_O a_21_n7464# VSS VSS sg13_lv_nmos ad=0.13395p pd=1.085u as=0.13395p ps=1.085u w=0.705u l=0.13u
X3 VSS ADDR_COL_I<0> a_429_n4104# VSS sg13_lv_nmos ad=0.13395p pd=1.085u as=0.2397p ps=2.09u w=0.705u l=0.13u
X4 VDD_uq1 a_429_n4104# ADDR_COL_O<0> VDD_uq1 sg13_lv_pmos ad=0.5508p pd=3.92u as=0.3078p ps=2u w=1.62u l=0.13u
X5 VDD_uq2 ADDR_DEC_I<0> a_429_n3262# VDD_uq2 sg13_lv_pmos ad=0.3078p pd=2u as=0.5508p ps=3.92u w=1.62u l=0.13u
X6 ADDR_DEC_O<6> a_21_n5784# VDD VDD sg13_lv_pmos ad=0.3078p pd=2u as=0.3078p ps=2u w=1.62u l=0.13u
X7 ADDR_DEC_O<2> a_21_n4104# VSS VSS sg13_lv_nmos ad=0.13395p pd=1.085u as=0.13395p ps=1.085u w=0.705u l=0.13u
X8 VSS a_429_n6622# ADDR_COL_O<1> VSS sg13_lv_nmos ad=0.2397p pd=2.09u as=0.13395p ps=1.085u w=0.705u l=0.13u
X9 ADDR_DEC_O<3> a_21_n3262# VDD_uq2 VDD_uq2 sg13_lv_pmos ad=0.3078p pd=2u as=0.3078p ps=2u w=1.62u l=0.13u
X10 VDD_uq0 a_429_n7464# DCLK_O VDD_uq0 sg13_lv_pmos ad=0.5508p pd=3.92u as=0.3078p ps=2u w=1.62u l=0.13u
X11 VSS a_429_n3262# ADDR_DEC_O<0> VSS sg13_lv_nmos ad=0.2397p pd=2.09u as=0.13395p ps=1.085u w=0.705u l=0.13u
X12 VDD_uq1 a_429_n4942# ADDR_DEC_O<5> VDD_uq1 sg13_lv_pmos ad=0.5508p pd=3.92u as=0.3078p ps=2u w=1.62u l=0.13u
X13 VSS a_429_n5784# ADDR_DEC_O<4> VSS sg13_lv_nmos ad=0.2397p pd=2.09u as=0.13395p ps=1.085u w=0.705u l=0.13u
X14 VDD ADDR_COL_I<1> a_429_n6622# VDD sg13_lv_pmos ad=0.3078p pd=2u as=0.5508p ps=3.92u w=1.62u l=0.13u
X15 VDD_uq2 ADDR_DEC_I<1> a_21_n2424# VDD_uq2 sg13_lv_pmos ad=0.3078p pd=2u as=0.5508p ps=3.92u w=1.62u l=0.13u
X16 VDD_uq2 a_21_n2424# ADDR_DEC_O<1> VDD_uq2 sg13_lv_pmos ad=0.5508p pd=3.92u as=0.3078p ps=2u w=1.62u l=0.13u
X17 ADDR_DEC_O<5> a_429_n4942# VSS VSS sg13_lv_nmos ad=0.13395p pd=1.085u as=0.13395p ps=1.085u w=0.705u l=0.13u
X18 DCLK_O a_429_n7464# VSS VSS sg13_lv_nmos ad=0.13395p pd=1.085u as=0.13395p ps=1.085u w=0.705u l=0.13u
X19 WCLK_O a_21_n6622# VDD VDD sg13_lv_pmos ad=0.3078p pd=2u as=0.3078p ps=2u w=1.62u l=0.13u
X20 VSS ADDR_DEC_I<7> a_21_n4942# VSS sg13_lv_nmos ad=0.13395p pd=1.085u as=0.2397p ps=2.09u w=0.705u l=0.13u
X21 VSS a_21_n4942# ADDR_DEC_O<7> VSS sg13_lv_nmos ad=0.2397p pd=2.09u as=0.13395p ps=1.085u w=0.705u l=0.13u
X22 ADDR_DEC_O<4> a_429_n5784# VDD VDD sg13_lv_pmos ad=0.3078p pd=2u as=0.3078p ps=2u w=1.62u l=0.13u
X23 VSS RCLK_I a_21_n7464# VSS sg13_lv_nmos ad=0.13395p pd=1.085u as=0.2397p ps=2.09u w=0.705u l=0.13u
X24 VSS a_21_n7464# RCLK_O VSS sg13_lv_nmos ad=0.2397p pd=2.09u as=0.13395p ps=1.085u w=0.705u l=0.13u
X25 ADDR_COL_O<0> a_429_n4104# VSS VSS sg13_lv_nmos ad=0.13395p pd=1.085u as=0.13395p ps=1.085u w=0.705u l=0.13u
X26 VDD_uq1 ADDR_COL_I<0> a_429_n4104# VDD_uq1 sg13_lv_pmos ad=0.3078p pd=2u as=0.5508p ps=3.92u w=1.62u l=0.13u
X27 ADDR_DEC_O<0> a_429_n3262# VDD_uq2 VDD_uq2 sg13_lv_pmos ad=0.3078p pd=2u as=0.3078p ps=2u w=1.62u l=0.13u
X28 VDD ADDR_DEC_I<6> a_21_n5784# VDD sg13_lv_pmos ad=0.3078p pd=2u as=0.5508p ps=3.92u w=1.62u l=0.13u
X29 VDD a_21_n5784# ADDR_DEC_O<6> VDD sg13_lv_pmos ad=0.5508p pd=3.92u as=0.3078p ps=2u w=1.62u l=0.13u
X30 ADDR_DEC_O<1> a_21_n2424# VSS VSS sg13_lv_nmos ad=0.13395p pd=1.085u as=0.13395p ps=1.085u w=0.705u l=0.13u
X31 VSS ADDR_DEC_I<2> a_21_n4104# VSS sg13_lv_nmos ad=0.13395p pd=1.085u as=0.2397p ps=2.09u w=0.705u l=0.13u
X32 VSS a_21_n4104# ADDR_DEC_O<2> VSS sg13_lv_nmos ad=0.2397p pd=2.09u as=0.13395p ps=1.085u w=0.705u l=0.13u
X33 ADDR_DEC_O<2> a_21_n4104# VDD_uq1 VDD_uq1 sg13_lv_pmos ad=0.3078p pd=2u as=0.3078p ps=2u w=1.62u l=0.13u
X34 VSS ADDR_COL_I<1> a_429_n6622# VSS sg13_lv_nmos ad=0.13395p pd=1.085u as=0.2397p ps=2.09u w=0.705u l=0.13u
X35 VDD_uq2 ADDR_DEC_I<3> a_21_n3262# VDD_uq2 sg13_lv_pmos ad=0.3078p pd=2u as=0.5508p ps=3.92u w=1.62u l=0.13u
X36 VDD_uq2 a_21_n3262# ADDR_DEC_O<3> VDD_uq2 sg13_lv_pmos ad=0.5508p pd=3.92u as=0.3078p ps=2u w=1.62u l=0.13u
X37 WCLK_O a_21_n6622# VSS VSS sg13_lv_nmos ad=0.13395p pd=1.085u as=0.13395p ps=1.085u w=0.705u l=0.13u
X38 VDD_uq0 DCLK_I a_429_n7464# VDD_uq0 sg13_lv_pmos ad=0.3078p pd=2u as=0.5508p ps=3.92u w=1.62u l=0.13u
X39 VSS ADDR_DEC_I<0> a_429_n3262# VSS sg13_lv_nmos ad=0.13395p pd=1.085u as=0.2397p ps=2.09u w=0.705u l=0.13u
X40 VSS ADDR_DEC_I<4> a_429_n5784# VSS sg13_lv_nmos ad=0.13395p pd=1.085u as=0.2397p ps=2.09u w=0.705u l=0.13u
X41 VDD_uq1 ADDR_DEC_I<5> a_429_n4942# VDD_uq1 sg13_lv_pmos ad=0.3078p pd=2u as=0.5508p ps=3.92u w=1.62u l=0.13u
X42 ADDR_COL_O<1> a_429_n6622# VDD VDD sg13_lv_pmos ad=0.3078p pd=2u as=0.3078p ps=2u w=1.62u l=0.13u
X43 RCLK_O a_21_n7464# VDD_uq0 VDD_uq0 sg13_lv_pmos ad=0.3078p pd=2u as=0.3078p ps=2u w=1.62u l=0.13u
X44 ADDR_DEC_O<3> a_21_n3262# VSS VSS sg13_lv_nmos ad=0.13395p pd=1.085u as=0.13395p ps=1.085u w=0.705u l=0.13u
X45 ADDR_DEC_O<6> a_21_n5784# VSS VSS sg13_lv_nmos ad=0.13395p pd=1.085u as=0.13395p ps=1.085u w=0.705u l=0.13u
X46 ADDR_DEC_O<7> a_21_n4942# VDD_uq1 VDD_uq1 sg13_lv_pmos ad=0.3078p pd=2u as=0.3078p ps=2u w=1.62u l=0.13u
X47 VDD WCLK_I a_21_n6622# VDD sg13_lv_pmos ad=0.3078p pd=2u as=0.5508p ps=3.92u w=1.62u l=0.13u
X48 VDD a_21_n6622# WCLK_O VDD sg13_lv_pmos ad=0.5508p pd=3.92u as=0.3078p ps=2u w=1.62u l=0.13u
X49 VSS a_429_n4942# ADDR_DEC_O<5> VSS sg13_lv_nmos ad=0.2397p pd=2.09u as=0.13395p ps=1.085u w=0.705u l=0.13u
X50 VSS a_429_n7464# DCLK_O VSS sg13_lv_nmos ad=0.2397p pd=2.09u as=0.13395p ps=1.085u w=0.705u l=0.13u
X51 ADDR_COL_O<0> a_429_n4104# VDD_uq1 VDD_uq1 sg13_lv_pmos ad=0.3078p pd=2u as=0.3078p ps=2u w=1.62u l=0.13u
X52 VDD a_429_n5784# ADDR_DEC_O<4> VDD sg13_lv_pmos ad=0.5508p pd=3.92u as=0.3078p ps=2u w=1.62u l=0.13u
X53 VSS ADDR_DEC_I<1> a_21_n2424# VSS sg13_lv_nmos ad=0.13395p pd=1.085u as=0.2397p ps=2.09u w=0.705u l=0.13u
X54 VSS a_21_n2424# ADDR_DEC_O<1> VSS sg13_lv_nmos ad=0.2397p pd=2.09u as=0.13395p ps=1.085u w=0.705u l=0.13u
X55 VDD_uq1 ADDR_DEC_I<2> a_21_n4104# VDD_uq1 sg13_lv_pmos ad=0.3078p pd=2u as=0.5508p ps=3.92u w=1.62u l=0.13u
X56 VDD_uq1 a_21_n4104# ADDR_DEC_O<2> VDD_uq1 sg13_lv_pmos ad=0.5508p pd=3.92u as=0.3078p ps=2u w=1.62u l=0.13u
X57 ADDR_COL_O<1> a_429_n6622# VSS VSS sg13_lv_nmos ad=0.13395p pd=1.085u as=0.13395p ps=1.085u w=0.705u l=0.13u
X58 VDD_uq2 a_429_n3262# ADDR_DEC_O<0> VDD_uq2 sg13_lv_pmos ad=0.5508p pd=3.92u as=0.3078p ps=2u w=1.62u l=0.13u
X59 VSS a_429_n4104# ADDR_COL_O<0> VSS sg13_lv_nmos ad=0.2397p pd=2.09u as=0.13395p ps=1.085u w=0.705u l=0.13u
X60 VSS WCLK_I a_21_n6622# VSS sg13_lv_nmos ad=0.13395p pd=1.085u as=0.2397p ps=2.09u w=0.705u l=0.13u
X61 VSS a_21_n6622# WCLK_O VSS sg13_lv_nmos ad=0.2397p pd=2.09u as=0.13395p ps=1.085u w=0.705u l=0.13u
X62 DCLK_O a_429_n7464# VDD_uq0 VDD_uq0 sg13_lv_pmos ad=0.3078p pd=2u as=0.3078p ps=2u w=1.62u l=0.13u
X63 ADDR_DEC_O<0> a_429_n3262# VSS VSS sg13_lv_nmos ad=0.13395p pd=1.085u as=0.13395p ps=1.085u w=0.705u l=0.13u
X64 ADDR_DEC_O<4> a_429_n5784# VSS VSS sg13_lv_nmos ad=0.13395p pd=1.085u as=0.13395p ps=1.085u w=0.705u l=0.13u
X65 ADDR_DEC_O<5> a_429_n4942# VDD_uq1 VDD_uq1 sg13_lv_pmos ad=0.3078p pd=2u as=0.3078p ps=2u w=1.62u l=0.13u
X66 VDD_uq0 RCLK_I a_21_n7464# VDD_uq0 sg13_lv_pmos ad=0.3078p pd=2u as=0.5508p ps=3.92u w=1.62u l=0.13u
X67 VDD_uq0 a_21_n7464# RCLK_O VDD_uq0 sg13_lv_pmos ad=0.5508p pd=3.92u as=0.3078p ps=2u w=1.62u l=0.13u
X68 VSS ADDR_DEC_I<3> a_21_n3262# VSS sg13_lv_nmos ad=0.13395p pd=1.085u as=0.2397p ps=2.09u w=0.705u l=0.13u
X69 VSS a_21_n3262# ADDR_DEC_O<3> VSS sg13_lv_nmos ad=0.2397p pd=2.09u as=0.13395p ps=1.085u w=0.705u l=0.13u
X70 VSS ADDR_DEC_I<6> a_21_n5784# VSS sg13_lv_nmos ad=0.13395p pd=1.085u as=0.2397p ps=2.09u w=0.705u l=0.13u
X71 VSS a_21_n5784# ADDR_DEC_O<6> VSS sg13_lv_nmos ad=0.2397p pd=2.09u as=0.13395p ps=1.085u w=0.705u l=0.13u
X72 VDD_uq1 ADDR_DEC_I<7> a_21_n4942# VDD_uq1 sg13_lv_pmos ad=0.3078p pd=2u as=0.5508p ps=3.92u w=1.62u l=0.13u
X73 VDD_uq1 a_21_n4942# ADDR_DEC_O<7> VDD_uq1 sg13_lv_pmos ad=0.5508p pd=3.92u as=0.3078p ps=2u w=1.62u l=0.13u
X74 ADDR_DEC_O<1> a_21_n2424# VDD_uq2 VDD_uq2 sg13_lv_pmos ad=0.3078p pd=2u as=0.3078p ps=2u w=1.62u l=0.13u
X75 VSS ADDR_DEC_I<5> a_429_n4942# VSS sg13_lv_nmos ad=0.13395p pd=1.085u as=0.2397p ps=2.09u w=0.705u l=0.13u
X76 VDD a_429_n6622# ADDR_COL_O<1> VDD sg13_lv_pmos ad=0.5508p pd=3.92u as=0.3078p ps=2u w=1.62u l=0.13u
X77 VSS DCLK_I a_429_n7464# VSS sg13_lv_nmos ad=0.13395p pd=1.085u as=0.2397p ps=2.09u w=0.705u l=0.13u
.ends

.subckt RM_IHPSG13_1P_COLDEC2 ADDR<1> ADDR<2> ADDR<0> BIST_ADDR<1> BIST_EN_I BIST_ADDR<2>
+ BIST_ADDR<0> ADDR_COL<1> ADDR_COL<0> ADDR_DEC<0> ADDR_DEC<7> ADDR_DEC<1> ADDR_DEC<2>
+ ADDR_DEC<3> ADDR_DEC<4> ADDR_DEC<5> ADDR_DEC<6> VDD m2_2096_n9300# m2_4646_n9300#
+ m2_n556_n9300# m2_1484_n9300# m2_n454_n5040# m2_3932_n9300# m2_1382_n9300# m2_n454_n9300#
+ m2_n352_n5040# m2_4340_n5040# m2_2504_n4785# m2_4238_n5040# m2_1178_n5040# m2_n352_n9300#
+ m2_3830_n9300# m2_4340_n9300# m2_3728_n9300# m2_4238_n9300# m2_n250_n5040# m2_1076_n5040#
+ m2_260_n5040# m2_n148_n5040# m2_n250_n9300# m2_158_n5040# m2_3626_n9300# m2_n148_n9300#
+ m2_4136_n9300# m2_158_n9300# m2_5514_n5092# m2_3524_n9300# m2_4034_n9300# m2_3014_n4275#
+ m2_2912_n9300# m2_3422_n9300# m2_56_n9300# m2_2606_n4683# m2_2708_n9300# m2_3218_n4173#
+ m2_2606_n9300# m3_n1122_n8450# m2_6584_n5040# ACLK_N VSS m2_3014_n9300# m2_n46_n5040#
+ m2_2810_n4479# m2_2708_n4581# m2_2402_n9300# m2_n46_n9300# m2_2300_n9300# m2_5768_n9300#
+ m2_3320_n4071# m2_5666_n9300# m2_1994_n9300# m2_6074_n9300# m2_2912_n4377# m2_974_n5040#
+ m2_n964_n9300# m2_n862_n5040# m2_5360_n5040# m2_872_n5040# m2_n862_n9300# m2_4748_n5040#
+ m2_1790_n9300# m2_1688_n9300# m2_2198_n9300# m2_4748_n9300# m2_4646_n5040# VDD_uq0
X0 VDD_uq0 a_803_n8064# a_803_n8342# VDD_uq0 sg13_lv_pmos ad=0.3078p pd=2u as=0.3078p ps=2u w=1.62u l=0.385u
X1 a_5699_n8700# a_5699_n9186# VDD_uq0 VDD_uq0 sg13_lv_pmos ad=0.3078p pd=2u as=0.3078p ps=2u w=1.62u l=0.385u
X2 VSS a_497_n3302# a_497_n3024# VSS sg13_lv_nmos ad=0.2822p pd=2.34u as=0.1577p ps=1.21u w=0.83u l=0.13u
X3 VDD_uq0 a_6447_n8664# a_6485_n8744# VDD_uq0 sg13_lv_pmos ad=0.5508p pd=3.92u as=0.3078p ps=2u w=1.62u l=0.385u
X4 VSS a_n1033_n8342# a_n1033_n8064# VSS sg13_lv_nmos ad=0.1577p pd=1.21u as=0.1577p ps=1.21u w=0.83u l=0.13u
X5 VSS a_5087_n8342# a_5087_n8064# VSS sg13_lv_nmos ad=0.1577p pd=1.21u as=0.1577p ps=1.21u w=0.83u l=0.13u
X6 VDD a_5699_n3024# a_5699_n3302# VDD sg13_lv_pmos ad=0.3078p pd=2u as=0.3078p ps=2u w=1.62u l=0.385u
X7 VSS a_3149_n4037# a_3073_n3630# VSS sg13_lv_nmos ad=91.2f pd=0.86u as=91.2f ps=0.86u w=0.48u l=0.13u
X8 VSS BIST_ADDR<1> a_1849_n3630# VSS sg13_lv_nmos ad=0.1904p pd=1.8u as=0.1064p ps=0.94u w=0.56u l=0.13u
X9 a_4475_n3302# a_4475_n3024# VDD VDD sg13_lv_pmos ad=0.3078p pd=2u as=0.3078p ps=2u w=1.62u l=0.385u
X10 VSS a_n727_n3660# a_n727_n4146# VSS sg13_lv_nmos ad=0.1577p pd=1.21u as=0.1577p ps=1.21u w=0.83u l=0.13u
X11 VSS a_n421_n8342# a_n421_n8064# VSS sg13_lv_nmos ad=0.1577p pd=1.21u as=0.1577p ps=1.21u w=0.83u l=0.13u
X12 VSS a_3251_n8342# a_3251_n8064# VSS sg13_lv_nmos ad=0.1577p pd=1.21u as=0.1577p ps=1.21u w=0.83u l=0.13u
X13 VSS BIST_EN_I a_1449_n4035# VSS sg13_lv_nmos ad=0.1064p pd=0.94u as=0.1904p ps=1.8u w=0.56u l=0.13u
X14 VDD_uq0 a_4475_n9186# a_4475_n8700# VDD_uq0 sg13_lv_pmos ad=0.3078p pd=2u as=0.3078p ps=2u w=1.62u l=0.385u
X15 VSS a_3251_n8342# a_3251_n8064# VSS sg13_lv_nmos ad=0.1577p pd=1.21u as=0.1577p ps=1.21u w=0.83u l=0.13u
X16 a_5521_n4104# a_6070_n3764# a_5521_n3654# VSS sg13_lv_nmos ad=0.3332p pd=2.64u as=0.1862p ps=1.36u w=0.98u l=0.13u
X17 a_5699_n3302# a_5699_n3024# VDD VDD sg13_lv_pmos ad=0.3078p pd=2u as=0.3078p ps=2u w=1.62u l=0.385u
X18 VSS a_1415_n8342# a_1415_n8064# VSS sg13_lv_nmos ad=0.1577p pd=1.21u as=0.1577p ps=1.21u w=0.83u l=0.13u
X19 a_3889_n4104# a_5050_n3764# a_3889_n3654# VSS sg13_lv_nmos ad=0.3332p pd=2.64u as=0.1862p ps=1.36u w=0.98u l=0.13u
X20 a_191_n8700# a_191_n9186# VDD_uq0 VDD_uq0 sg13_lv_pmos ad=0.3078p pd=2u as=0.3078p ps=2u w=1.62u l=0.385u
X21 VSS a_4475_n8700# a_4475_n9186# VSS sg13_lv_nmos ad=0.1577p pd=1.21u as=0.1577p ps=1.21u w=0.83u l=0.13u
X22 VSS a_803_n8342# a_803_n8064# VSS sg13_lv_nmos ad=0.1577p pd=1.21u as=0.1577p ps=1.21u w=0.83u l=0.13u
X23 VSS a_n115_n4982# a_n115_n4704# VSS sg13_lv_nmos ad=0.1577p pd=1.21u as=0.1577p ps=1.21u w=0.83u l=0.13u
X24 a_3073_n3186# ACLK_N a_2971_n3260# VSS sg13_lv_nmos ad=91.2f pd=0.86u as=0.13375p ps=1.23u w=0.48u l=0.13u
X25 a_2869_n4038# a_2537_n4040# VDD VDD sg13_lv_pmos ad=0.1881p pd=1.37u as=0.3366p ps=2.66u w=0.99u l=0.13u
X26 VSS a_n115_n4982# a_n115_n4704# VSS sg13_lv_nmos ad=0.1577p pd=1.21u as=0.1577p ps=1.21u w=0.83u l=0.13u
X27 VSS a_4475_n8700# a_4475_n9186# VSS sg13_lv_nmos ad=0.1577p pd=1.21u as=0.1577p ps=1.21u w=0.83u l=0.13u
X28 a_2869_n3218# a_2537_n3220# VSS VSS sg13_lv_nmos ad=0.1783p pd=1.44u as=0.289p ps=2.38u w=0.85u l=0.13u
X29 VSS a_2639_n8700# a_2639_n9186# VSS sg13_lv_nmos ad=0.1577p pd=1.21u as=0.1577p ps=1.21u w=0.83u l=0.13u
X30 VSS a_3863_n8700# a_3863_n9186# VSS sg13_lv_nmos ad=0.1577p pd=1.21u as=0.1577p ps=1.21u w=0.83u l=0.13u
X31 VSS a_6485_n8744# a_6447_n8664# VSS sg13_lv_nmos ad=0.1577p pd=1.21u as=0.2822p ps=2.34u w=0.83u l=0.13u
X32 VSS a_2027_n8700# a_2027_n9186# VSS sg13_lv_nmos ad=0.1577p pd=1.21u as=0.1577p ps=1.21u w=0.83u l=0.13u
X33 a_n1033_n8342# a_n1033_n8064# VDD_uq0 VDD_uq0 sg13_lv_pmos ad=0.3078p pd=2u as=0.5508p ps=3.92u w=1.62u l=0.385u
X34 a_5087_n8700# a_5087_n9186# VDD_uq0 VDD_uq0 sg13_lv_pmos ad=0.3078p pd=2u as=0.3078p ps=2u w=1.62u l=0.385u
X35 a_n727_n4704# a_n727_n4982# VSS VSS sg13_lv_nmos ad=0.1577p pd=1.21u as=0.1577p ps=1.21u w=0.83u l=0.13u
X36 a_3149_n4037# a_2971_n4038# VSS VSS sg13_lv_nmos ad=0.1632p pd=1.64u as=91.2f ps=0.86u w=0.48u l=0.13u
X37 a_5699_n9186# a_5699_n8700# VSS VSS sg13_lv_nmos ad=0.1577p pd=1.21u as=0.1577p ps=1.21u w=0.83u l=0.13u
X38 VDD_uq0 a_2639_n9186# a_2639_n8700# VDD_uq0 sg13_lv_pmos ad=0.3078p pd=2u as=0.3078p ps=2u w=1.62u l=0.385u
X39 a_2461_n2874# ACLK_N a_2359_n3262# VDD sg13_lv_pmos ad=91.2f pd=0.86u as=0.14927p ps=1.355u w=0.48u l=0.13u
X40 VSS a_2027_n8700# a_2027_n9186# VSS sg13_lv_nmos ad=0.1577p pd=1.21u as=0.1577p ps=1.21u w=0.83u l=0.13u
X41 a_n421_n8700# a_n421_n9186# VDD_uq0 VDD_uq0 sg13_lv_pmos ad=0.3078p pd=2u as=0.3078p ps=2u w=1.62u l=0.385u
X42 a_n115_n4704# a_n115_n4982# VSS VSS sg13_lv_nmos ad=0.1577p pd=1.21u as=0.1577p ps=1.21u w=0.83u l=0.13u
X43 VSS a_6485_n3704# a_6447_n3624# VSS sg13_lv_nmos ad=0.2822p pd=2.34u as=0.1577p ps=1.21u w=0.83u l=0.13u
X44 VDD_uq0 a_3863_n9186# a_3863_n8700# VDD_uq0 sg13_lv_pmos ad=0.3078p pd=2u as=0.3078p ps=2u w=1.62u l=0.385u
X45 a_497_n3302# a_497_n3024# VDD VDD sg13_lv_pmos ad=0.3078p pd=2u as=0.3078p ps=2u w=1.62u l=0.385u
X46 a_4475_n3024# a_4475_n3302# VSS VSS sg13_lv_nmos ad=0.1577p pd=1.21u as=0.1577p ps=1.21u w=0.83u l=0.13u
X47 a_1415_n8700# a_1415_n9186# VDD_uq0 VDD_uq0 sg13_lv_pmos ad=0.3078p pd=2u as=0.3078p ps=2u w=1.62u l=0.385u
X48 ADDR_DEC<0> a_5011_n4104# VSS VSS sg13_lv_nmos ad=0.3332p pd=2.64u as=0.3332p ps=2.64u w=0.98u l=0.13u
X49 a_n727_n3660# a_n727_n4146# VDD VDD sg13_lv_pmos ad=0.3078p pd=2u as=0.5508p ps=3.92u w=1.62u l=0.385u
X50 VDD a_6070_n3764# a_5521_n4104# VDD sg13_lv_pmos ad=0.5508p pd=3.92u as=0.3078p ps=2u w=1.62u l=0.13u
X51 a_2869_n2880# a_2537_n3220# VDD VDD sg13_lv_pmos ad=0.1881p pd=1.37u as=0.3366p ps=2.66u w=0.99u l=0.13u
X52 VDD a_5050_n3764# a_3889_n4104# VDD sg13_lv_pmos ad=0.5508p pd=3.92u as=0.3078p ps=2u w=1.62u l=0.13u
X53 a_6447_n3262# a_6485_n3082# VSS VSS sg13_lv_nmos ad=0.1577p pd=1.21u as=0.1577p ps=1.21u w=0.83u l=0.13u
X54 a_5087_n8342# a_5087_n8064# VDD_uq0 VDD_uq0 sg13_lv_pmos ad=0.3078p pd=2u as=0.3078p ps=2u w=1.62u l=0.385u
X55 a_3863_n8342# a_3863_n8064# VDD_uq0 VDD_uq0 sg13_lv_pmos ad=0.3078p pd=2u as=0.3078p ps=2u w=1.62u l=0.385u
X56 VDD_uq0 a_2027_n8064# a_2027_n8342# VDD_uq0 sg13_lv_pmos ad=0.3078p pd=2u as=0.3078p ps=2u w=1.62u l=0.385u
X57 a_497_n3302# a_497_n3024# VDD VDD sg13_lv_pmos ad=0.3078p pd=2u as=0.3078p ps=2u w=1.62u l=0.385u
X58 VSS a_5699_n3302# a_5699_n3024# VSS sg13_lv_nmos ad=0.2822p pd=2.34u as=0.1577p ps=1.21u w=0.83u l=0.13u
X59 a_3863_n9186# a_3863_n8700# VSS VSS sg13_lv_nmos ad=0.1577p pd=1.21u as=0.1577p ps=1.21u w=0.83u l=0.13u
X60 VDD a_4305_n3624# a_4343_n3704# VDD sg13_lv_pmos ad=0.5508p pd=3.92u as=0.3078p ps=2u w=1.62u l=0.385u
X61 a_5699_n3302# a_5699_n3024# VDD VDD sg13_lv_pmos ad=0.3078p pd=2u as=0.3078p ps=2u w=1.62u l=0.385u
X62 VDD a_3149_n4037# a_3073_n3938# VDD sg13_lv_pmos ad=91.2f pd=0.86u as=91.2f ps=0.86u w=0.48u l=0.13u
X63 VSS a_4475_n8342# a_4475_n8064# VSS sg13_lv_nmos ad=0.1577p pd=1.21u as=0.1577p ps=1.21u w=0.83u l=0.13u
X64 VDD a_6447_n3262# a_6485_n3082# VDD sg13_lv_pmos ad=0.5508p pd=3.92u as=0.3078p ps=2u w=1.62u l=0.385u
X65 a_191_n9186# a_191_n8700# VSS VSS sg13_lv_nmos ad=0.1577p pd=1.21u as=0.1577p ps=1.21u w=0.83u l=0.13u
X66 VDD_uq0 a_3863_n8064# a_3863_n8342# VDD_uq0 sg13_lv_pmos ad=0.3078p pd=2u as=0.3078p ps=2u w=1.62u l=0.385u
X67 a_1415_n8342# a_1415_n8064# VDD_uq0 VDD_uq0 sg13_lv_pmos ad=0.3078p pd=2u as=0.3078p ps=2u w=1.62u l=0.385u
X68 a_2027_n9186# a_2027_n8700# VSS VSS sg13_lv_nmos ad=0.1577p pd=1.21u as=0.1577p ps=1.21u w=0.83u l=0.13u
X69 VSS a_4475_n8342# a_4475_n8064# VSS sg13_lv_nmos ad=0.1577p pd=1.21u as=0.1577p ps=1.21u w=0.83u l=0.13u
X70 a_1211_n4980# a_1211_n4980# VDD VDD sg13_lv_pmos ad=0.1632p pd=1.64u as=0.1632p ps=1.64u w=0.48u l=0.13u
X71 VSS BIST_ADDR<0> a_1849_n3202# VSS sg13_lv_nmos ad=0.1904p pd=1.8u as=0.1064p ps=0.94u w=0.56u l=0.13u
X72 a_6070_n3764# a_5050_n3764# VDD VDD sg13_lv_pmos ad=0.5508p pd=3.92u as=0.5508p ps=3.92u w=1.62u l=0.13u
X73 VDD a_n727_n4704# a_n727_n4982# VDD sg13_lv_pmos ad=0.3078p pd=2u as=0.3078p ps=2u w=1.62u l=0.385u
X74 a_4305_n3624# a_4343_n3704# VSS VSS sg13_lv_nmos ad=0.1577p pd=1.21u as=0.1577p ps=1.21u w=0.83u l=0.13u
X75 VSS a_3863_n8342# a_3863_n8064# VSS sg13_lv_nmos ad=0.1577p pd=1.21u as=0.1577p ps=1.21u w=0.83u l=0.13u
X76 VSS a_2639_n8342# a_2639_n8064# VSS sg13_lv_nmos ad=0.1577p pd=1.21u as=0.1577p ps=1.21u w=0.83u l=0.13u
X77 VSS BIST_EN_I a_1449_n3202# VSS sg13_lv_nmos ad=0.1064p pd=0.94u as=0.1904p ps=1.8u w=0.56u l=0.13u
X78 VDD a_4475_n3024# a_4475_n3302# VDD sg13_lv_pmos ad=0.3078p pd=2u as=0.3078p ps=2u w=1.62u l=0.385u
X79 VSS a_6485_n8122# a_6447_n8302# VSS sg13_lv_nmos ad=0.1577p pd=1.21u as=0.2822p ps=2.34u w=0.83u l=0.13u
X80 VSS a_803_n8700# a_803_n9186# VSS sg13_lv_nmos ad=0.1577p pd=1.21u as=0.1577p ps=1.21u w=0.83u l=0.13u
X81 VSS a_4475_n3302# a_4475_n3024# VSS sg13_lv_nmos ad=0.1577p pd=1.21u as=0.1577p ps=1.21u w=0.83u l=0.13u
X82 VSS a_2027_n8342# a_2027_n8064# VSS sg13_lv_nmos ad=0.1577p pd=1.21u as=0.1577p ps=1.21u w=0.83u l=0.13u
X83 a_5699_n8064# a_5699_n8342# VSS VSS sg13_lv_nmos ad=0.1577p pd=1.21u as=0.1577p ps=1.21u w=0.83u l=0.13u
X84 a_n727_n3660# a_n727_n4146# VDD VDD sg13_lv_pmos ad=0.3078p pd=2u as=0.3078p ps=2u w=1.62u l=0.385u
X85 a_n115_n3302# a_n115_n3024# VDD VDD sg13_lv_pmos ad=0.3078p pd=2u as=0.3078p ps=2u w=1.62u l=0.385u
X86 VSS a_3863_n3302# a_3863_n3024# VSS sg13_lv_nmos ad=0.1577p pd=1.21u as=0.1577p ps=1.21u w=0.83u l=0.13u
X87 VSS a_2027_n8342# a_2027_n8064# VSS sg13_lv_nmos ad=0.1577p pd=1.21u as=0.1577p ps=1.21u w=0.83u l=0.13u
X88 ADDR_DEC<0> a_5011_n4104# VDD VDD sg13_lv_pmos ad=0.5508p pd=3.92u as=0.5508p ps=3.92u w=1.62u l=0.13u
X89 a_1645_n4035# ADDR<1> VDD VDD sg13_lv_pmos ad=0.18715p pd=1.365u as=0.16165p ps=1.365u w=0.985u l=0.13u
X90 VSS a_2537_n3220# a_2461_n3184# VSS sg13_lv_nmos ad=91.2f pd=0.86u as=91.2f ps=0.86u w=0.48u l=0.13u
X91 VDD_uq0 a_191_n9186# a_191_n8700# VDD_uq0 sg13_lv_pmos ad=0.3078p pd=2u as=0.3078p ps=2u w=1.62u l=0.385u
X92 a_2461_n3632# a_2061_n4035# a_2359_n4035# VSS sg13_lv_nmos ad=91.2f pd=0.86u as=0.13605p ps=1.25u w=0.48u l=0.13u
X93 a_2359_n3262# ACLK_N a_2257_n3262# VSS sg13_lv_nmos ad=0.13605p pd=1.25u as=0.1653p ps=1.25u w=0.87u l=0.13u
X94 VDD_uq0 a_2027_n8064# a_2027_n8342# VDD_uq0 sg13_lv_pmos ad=0.3078p pd=2u as=0.3078p ps=2u w=1.62u l=0.385u
X95 a_3149_n4037# a_2971_n4038# VDD VDD sg13_lv_pmos ad=0.1632p pd=1.64u as=91.2f ps=0.86u w=0.48u l=0.13u
X96 VDD a_497_n4146# a_497_n3660# VDD sg13_lv_pmos ad=0.5508p pd=3.92u as=0.3078p ps=2u w=1.62u l=0.385u
X97 a_5087_n3302# a_5087_n3024# VDD VDD sg13_lv_pmos ad=0.3078p pd=2u as=0.3078p ps=2u w=1.62u l=0.385u
X98 VSS a_n421_n8700# a_n421_n9186# VSS sg13_lv_nmos ad=0.1577p pd=1.21u as=0.1577p ps=1.21u w=0.83u l=0.13u
X99 a_n1033_n9186# a_n1033_n8700# VSS VSS sg13_lv_nmos ad=0.1577p pd=1.21u as=0.2822p ps=2.34u w=0.83u l=0.13u
X100 a_1211_n4140# a_1211_n4140# VDD VDD sg13_lv_pmos ad=0.1632p pd=1.64u as=0.1632p ps=1.64u w=0.48u l=0.13u
X101 a_n115_n3302# a_n115_n3024# VDD VDD sg13_lv_pmos ad=0.3078p pd=2u as=0.3078p ps=2u w=1.62u l=0.385u
X102 VSS a_191_n8700# a_191_n9186# VSS sg13_lv_nmos ad=0.1577p pd=1.21u as=0.1577p ps=1.21u w=0.83u l=0.13u
X103 VDD_uq0 a_n1033_n8064# a_n1033_n8342# VDD_uq0 sg13_lv_pmos ad=0.3078p pd=2u as=0.3078p ps=2u w=1.62u l=0.385u
X104 VDD_uq0 a_5087_n9186# a_5087_n8700# VDD_uq0 sg13_lv_pmos ad=0.3078p pd=2u as=0.3078p ps=2u w=1.62u l=0.385u
X105 a_3863_n8064# a_3863_n8342# VSS VSS sg13_lv_nmos ad=0.1577p pd=1.21u as=0.1577p ps=1.21u w=0.83u l=0.13u
X106 a_2639_n8700# a_2639_n9186# VDD_uq0 VDD_uq0 sg13_lv_pmos ad=0.3078p pd=2u as=0.3078p ps=2u w=1.62u l=0.385u
X107 a_3863_n8700# a_3863_n9186# VDD_uq0 VDD_uq0 sg13_lv_pmos ad=0.3078p pd=2u as=0.3078p ps=2u w=1.62u l=0.385u
X108 VDD_uq0 a_1415_n9186# a_1415_n8700# VDD_uq0 sg13_lv_pmos ad=0.3078p pd=2u as=0.3078p ps=2u w=1.62u l=0.385u
X109 a_6485_n8744# a_6447_n8664# VDD_uq0 VDD_uq0 sg13_lv_pmos ad=0.3078p pd=2u as=0.5508p ps=3.92u w=1.62u l=0.385u
X110 ADDR_DEC<6> a_4781_n4140# VSS VSS sg13_lv_nmos ad=0.1632p pd=1.64u as=0.1632p ps=1.64u w=0.48u l=0.13u
X111 a_1645_n2882# ADDR<0> VDD VDD sg13_lv_pmos ad=0.18715p pd=1.365u as=0.16165p ps=1.365u w=0.985u l=0.13u
X112 VDD a_3863_n3024# a_3863_n3302# VDD sg13_lv_pmos ad=0.3078p pd=2u as=0.3078p ps=2u w=1.62u l=0.385u
X113 a_191_n8064# a_191_n8342# VSS VSS sg13_lv_nmos ad=0.1577p pd=1.21u as=0.1577p ps=1.21u w=0.83u l=0.13u
X114 a_2027_n8064# a_2027_n8342# VSS VSS sg13_lv_nmos ad=0.1577p pd=1.21u as=0.1577p ps=1.21u w=0.83u l=0.13u
X115 a_1747_n4035# BIST_EN_I a_1645_n4035# VDD sg13_lv_pmos ad=0.18715p pd=1.365u as=0.18715p ps=1.365u w=0.985u l=0.13u
X116 a_497_n4146# a_497_n3660# VSS VSS sg13_lv_nmos ad=0.1577p pd=1.21u as=0.1577p ps=1.21u w=0.83u l=0.13u
X117 a_n1033_n9186# a_n1033_n8700# VSS VSS sg13_lv_nmos ad=0.1577p pd=1.21u as=0.1577p ps=1.21u w=0.83u l=0.13u
X118 a_5087_n9186# a_5087_n8700# VSS VSS sg13_lv_nmos ad=0.1577p pd=1.21u as=0.1577p ps=1.21u w=0.83u l=0.13u
X119 a_n421_n9186# a_n421_n8700# VSS VSS sg13_lv_nmos ad=0.1577p pd=1.21u as=0.1577p ps=1.21u w=0.83u l=0.13u
X120 VSS a_803_n8342# a_803_n8064# VSS sg13_lv_nmos ad=0.1577p pd=1.21u as=0.1577p ps=1.21u w=0.83u l=0.13u
X121 a_3863_n9186# a_3863_n8700# VSS VSS sg13_lv_nmos ad=0.1577p pd=1.21u as=0.1577p ps=1.21u w=0.83u l=0.13u
X122 a_5087_n9186# a_5087_n8700# VSS VSS sg13_lv_nmos ad=0.1577p pd=1.21u as=0.1577p ps=1.21u w=0.83u l=0.13u
X123 VDD a_3149_n3300# a_3073_n2878# VDD sg13_lv_pmos ad=91.2f pd=0.86u as=91.2f ps=0.86u w=0.48u l=0.13u
X124 VSS a_n115_n3302# a_n115_n3024# VSS sg13_lv_nmos ad=0.1577p pd=1.21u as=0.1577p ps=1.21u w=0.83u l=0.13u
X125 a_6031_n3654# a_5967_n3764# VSS VSS sg13_lv_nmos ad=0.1862p pd=1.36u as=0.3332p ps=2.64u w=0.98u l=0.13u
X126 a_2639_n8342# a_2639_n8064# VDD_uq0 VDD_uq0 sg13_lv_pmos ad=0.3078p pd=2u as=0.3078p ps=2u w=1.62u l=0.385u
X127 VSS a_497_n3660# a_497_n4146# VSS sg13_lv_nmos ad=0.1577p pd=1.21u as=0.1577p ps=1.21u w=0.83u l=0.13u
X128 a_3251_n9186# a_3251_n8700# VSS VSS sg13_lv_nmos ad=0.1577p pd=1.21u as=0.1577p ps=1.21u w=0.83u l=0.13u
X129 VSS a_5699_n8700# a_5699_n9186# VSS sg13_lv_nmos ad=0.1577p pd=1.21u as=0.1577p ps=1.21u w=0.83u l=0.13u
X130 a_2639_n9186# a_2639_n8700# VSS VSS sg13_lv_nmos ad=0.1577p pd=1.21u as=0.1577p ps=1.21u w=0.83u l=0.13u
X131 a_1415_n9186# a_1415_n8700# VSS VSS sg13_lv_nmos ad=0.1577p pd=1.21u as=0.1577p ps=1.21u w=0.83u l=0.13u
X132 VDD a_497_n4146# a_497_n3660# VDD sg13_lv_pmos ad=0.3078p pd=2u as=0.3078p ps=2u w=1.62u l=0.385u
X133 a_497_n3024# a_497_n3302# VSS VSS sg13_lv_nmos ad=0.1577p pd=1.21u as=0.1577p ps=1.21u w=0.83u l=0.13u
X134 a_1415_n9186# a_1415_n8700# VSS VSS sg13_lv_nmos ad=0.1577p pd=1.21u as=0.1577p ps=1.21u w=0.83u l=0.13u
X135 VDD a_n115_n4146# a_n115_n3660# VDD sg13_lv_pmos ad=0.3078p pd=2u as=0.3078p ps=2u w=1.62u l=0.385u
X136 a_n727_n3024# a_n727_n3302# VSS VSS sg13_lv_nmos ad=0.1577p pd=1.21u as=0.2822p ps=2.34u w=0.83u l=0.13u
X137 VDD_uq0 a_5087_n9186# a_5087_n8700# VDD_uq0 sg13_lv_pmos ad=0.3078p pd=2u as=0.3078p ps=2u w=1.62u l=0.385u
X138 VDD_uq0 a_n1033_n8064# a_n1033_n8342# VDD_uq0 sg13_lv_pmos ad=0.3078p pd=2u as=0.3078p ps=2u w=1.62u l=0.385u
X139 a_803_n9186# a_803_n8700# VSS VSS sg13_lv_nmos ad=0.1577p pd=1.21u as=0.1577p ps=1.21u w=0.83u l=0.13u
X140 VSS a_5087_n3302# a_5087_n3024# VSS sg13_lv_nmos ad=0.1577p pd=1.21u as=0.1577p ps=1.21u w=0.83u l=0.13u
X141 a_1747_n3202# BIST_EN_I a_1645_n2882# VDD sg13_lv_pmos ad=0.18715p pd=1.365u as=0.18715p ps=1.365u w=0.985u l=0.13u
X142 VDD_uq0 a_803_n9186# a_803_n8700# VDD_uq0 sg13_lv_pmos ad=0.3078p pd=2u as=0.3078p ps=2u w=1.62u l=0.385u
X143 VDD a_n727_n4146# a_n727_n3660# VDD sg13_lv_pmos ad=0.3078p pd=2u as=0.3078p ps=2u w=1.62u l=0.385u
X144 a_n727_n3024# a_n727_n3302# VSS VSS sg13_lv_nmos ad=0.1577p pd=1.21u as=0.1577p ps=1.21u w=0.83u l=0.13u
X145 a_n727_n4982# a_n727_n4704# VDD VDD sg13_lv_pmos ad=0.3078p pd=2u as=0.5508p ps=3.92u w=1.62u l=0.385u
X146 VDD a_2537_n4040# a_2461_n3942# VDD sg13_lv_pmos ad=91.2f pd=0.86u as=91.2f ps=0.86u w=0.48u l=0.13u
X147 VSS a_3863_n3302# a_3863_n3024# VSS sg13_lv_nmos ad=0.1577p pd=1.21u as=0.1577p ps=1.21u w=0.83u l=0.13u
X148 VSS a_5087_n3302# a_5087_n3024# VSS sg13_lv_nmos ad=0.1577p pd=1.21u as=0.1577p ps=1.21u w=0.83u l=0.13u
X149 VSS a_n421_n8342# a_n421_n8064# VSS sg13_lv_nmos ad=0.1577p pd=1.21u as=0.1577p ps=1.21u w=0.83u l=0.13u
X150 VSS a_497_n4982# a_497_n4704# VSS sg13_lv_nmos ad=0.1577p pd=1.21u as=0.1577p ps=1.21u w=0.83u l=0.13u
X151 a_n1033_n8064# a_n1033_n8342# VSS VSS sg13_lv_nmos ad=0.1577p pd=1.21u as=0.2822p ps=2.34u w=0.83u l=0.13u
X152 VSS a_191_n8342# a_191_n8064# VSS sg13_lv_nmos ad=0.1577p pd=1.21u as=0.1577p ps=1.21u w=0.83u l=0.13u
X153 a_4475_n8342# a_4475_n8064# VDD_uq0 VDD_uq0 sg13_lv_pmos ad=0.3078p pd=2u as=0.3078p ps=2u w=1.62u l=0.385u
X154 a_5699_n3024# a_5699_n3302# VSS VSS sg13_lv_nmos ad=0.1577p pd=1.21u as=0.1577p ps=1.21u w=0.83u l=0.13u
X155 VSS a_n115_n3660# a_n115_n4146# VSS sg13_lv_nmos ad=0.1577p pd=1.21u as=0.1577p ps=1.21u w=0.83u l=0.13u
X156 VDD a_n115_n3024# a_n115_n3302# VDD sg13_lv_pmos ad=0.3078p pd=2u as=0.3078p ps=2u w=1.62u l=0.385u
X157 a_3149_n3300# a_2971_n3260# VDD VDD sg13_lv_pmos ad=0.1632p pd=1.64u as=91.2f ps=0.86u w=0.48u l=0.13u
X158 a_497_n4704# a_497_n4982# VSS VSS sg13_lv_nmos ad=0.1577p pd=1.21u as=0.1577p ps=1.21u w=0.83u l=0.13u
X159 VSS a_n115_n3660# a_n115_n4146# VSS sg13_lv_nmos ad=0.1577p pd=1.21u as=0.1577p ps=1.21u w=0.83u l=0.13u
X160 VDD_uq0 a_3251_n8064# a_3251_n8342# VDD_uq0 sg13_lv_pmos ad=0.3078p pd=2u as=0.3078p ps=2u w=1.62u l=0.385u
X161 a_6031_n4104# a_5967_n3764# VDD VDD sg13_lv_pmos ad=0.3078p pd=2u as=0.5508p ps=3.92u w=1.62u l=0.13u
X162 a_2027_n8342# a_2027_n8064# VDD_uq0 VDD_uq0 sg13_lv_pmos ad=0.3078p pd=2u as=0.3078p ps=2u w=1.62u l=0.385u
X163 a_n1033_n8064# a_n1033_n8342# VSS VSS sg13_lv_nmos ad=0.1577p pd=1.21u as=0.1577p ps=1.21u w=0.83u l=0.13u
X164 a_5087_n8064# a_5087_n8342# VSS VSS sg13_lv_nmos ad=0.1577p pd=1.21u as=0.1577p ps=1.21u w=0.83u l=0.13u
X165 a_n727_n4146# a_n727_n3660# VSS VSS sg13_lv_nmos ad=0.1577p pd=1.21u as=0.1577p ps=1.21u w=0.83u l=0.13u
X166 a_n421_n8064# a_n421_n8342# VSS VSS sg13_lv_nmos ad=0.1577p pd=1.21u as=0.1577p ps=1.21u w=0.83u l=0.13u
X167 a_5087_n8064# a_5087_n8342# VSS VSS sg13_lv_nmos ad=0.1577p pd=1.21u as=0.1577p ps=1.21u w=0.83u l=0.13u
X168 a_3863_n8064# a_3863_n8342# VSS VSS sg13_lv_nmos ad=0.1577p pd=1.21u as=0.1577p ps=1.21u w=0.83u l=0.13u
X169 VDD a_5087_n3024# a_5087_n3302# VDD sg13_lv_pmos ad=0.3078p pd=2u as=0.3078p ps=2u w=1.62u l=0.385u
X170 a_1645_n3630# ADDR<1> VSS VSS sg13_lv_nmos ad=0.1064p pd=0.94u as=0.1064p ps=0.94u w=0.56u l=0.13u
X171 a_3863_n3302# a_3863_n3024# VDD VDD sg13_lv_pmos ad=0.3078p pd=2u as=0.3078p ps=2u w=1.62u l=0.385u
X172 a_n115_n4146# a_n115_n3660# VSS VSS sg13_lv_nmos ad=0.1577p pd=1.21u as=0.1577p ps=1.21u w=0.83u l=0.13u
X173 a_6485_n3082# a_6447_n3262# VDD VDD sg13_lv_pmos ad=0.3078p pd=2u as=0.5508p ps=3.92u w=1.62u l=0.385u
X174 a_3251_n8064# a_3251_n8342# VSS VSS sg13_lv_nmos ad=0.1577p pd=1.21u as=0.1577p ps=1.21u w=0.83u l=0.13u
X175 VSS a_5699_n8342# a_5699_n8064# VSS sg13_lv_nmos ad=0.1577p pd=1.21u as=0.1577p ps=1.21u w=0.83u l=0.13u
X176 VSS a_n727_n3302# a_n727_n3024# VSS sg13_lv_nmos ad=0.1577p pd=1.21u as=0.1577p ps=1.21u w=0.83u l=0.13u
X177 a_5087_n3024# a_5087_n3302# VSS VSS sg13_lv_nmos ad=0.1577p pd=1.21u as=0.1577p ps=1.21u w=0.83u l=0.13u
X178 a_2639_n8064# a_2639_n8342# VSS VSS sg13_lv_nmos ad=0.1577p pd=1.21u as=0.1577p ps=1.21u w=0.83u l=0.13u
X179 a_1415_n8064# a_1415_n8342# VSS VSS sg13_lv_nmos ad=0.1577p pd=1.21u as=0.1577p ps=1.21u w=0.83u l=0.13u
X180 a_n1033_n8700# a_n1033_n9186# VDD_uq0 VDD_uq0 sg13_lv_pmos ad=0.3078p pd=2u as=0.5508p ps=3.92u w=1.62u l=0.385u
X181 a_n115_n4704# a_n115_n4982# VSS VSS sg13_lv_nmos ad=0.1577p pd=1.21u as=0.1577p ps=1.21u w=0.83u l=0.13u
X182 a_n727_n4982# a_n727_n4704# VDD VDD sg13_lv_pmos ad=0.3078p pd=2u as=0.3078p ps=2u w=1.62u l=0.385u
X183 a_1415_n8064# a_1415_n8342# VSS VSS sg13_lv_nmos ad=0.1577p pd=1.21u as=0.1577p ps=1.21u w=0.83u l=0.13u
X184 a_n115_n4704# a_n115_n4982# VSS VSS sg13_lv_nmos ad=0.1577p pd=1.21u as=0.1577p ps=1.21u w=0.83u l=0.13u
X185 VSS a_3149_n3300# a_3073_n3186# VSS sg13_lv_nmos ad=91.2f pd=0.86u as=91.2f ps=0.86u w=0.48u l=0.13u
X186 a_5457_n3764# a_5967_n3764# VSS VSS sg13_lv_nmos ad=0.3332p pd=2.64u as=0.3332p ps=2.64u w=0.98u l=0.13u
X187 VDD ACLK_N a_2061_n4035# VDD sg13_lv_pmos ad=0.14812p pd=1.355u as=0.1632p ps=1.64u w=0.48u l=0.13u
X188 a_2971_n4038# ACLK_N a_2869_n4038# VDD sg13_lv_pmos ad=0.1511p pd=1.37u as=0.1881p ps=1.37u w=0.99u l=0.13u
X189 a_4475_n9186# a_4475_n8700# VSS VSS sg13_lv_nmos ad=0.1577p pd=1.21u as=0.1577p ps=1.21u w=0.83u l=0.13u
X190 a_803_n8064# a_803_n8342# VSS VSS sg13_lv_nmos ad=0.1577p pd=1.21u as=0.1577p ps=1.21u w=0.83u l=0.13u
X191 a_6447_n8664# a_6485_n8744# VSS VSS sg13_lv_nmos ad=0.1577p pd=1.21u as=0.1577p ps=1.21u w=0.83u l=0.13u
X192 VDD ACLK_N a_2061_n3262# VDD sg13_lv_pmos ad=0.14812p pd=1.355u as=0.1632p ps=1.64u w=0.48u l=0.13u
X193 a_497_n3660# a_497_n4146# VDD VDD sg13_lv_pmos ad=0.3078p pd=2u as=0.3078p ps=2u w=1.62u l=0.385u
X194 ADDR_COL<0> a_1211_n3300# VSS VSS sg13_lv_nmos ad=0.1632p pd=1.64u as=0.1632p ps=1.64u w=0.48u l=0.13u
X195 a_2639_n9186# a_2639_n8700# VSS VSS sg13_lv_nmos ad=0.1577p pd=1.21u as=0.1577p ps=1.21u w=0.83u l=0.13u
X196 VSS a_n727_n4982# a_n727_n4704# VSS sg13_lv_nmos ad=0.1577p pd=1.21u as=0.1577p ps=1.21u w=0.83u l=0.13u
X197 VDD a_497_n4704# a_497_n4982# VDD sg13_lv_pmos ad=0.5508p pd=3.92u as=0.3078p ps=2u w=1.62u l=0.385u
X198 VSS a_5699_n8700# a_5699_n9186# VSS sg13_lv_nmos ad=0.2822p pd=2.34u as=0.1577p ps=1.21u w=0.83u l=0.13u
X199 VDD a_2537_n3220# a_2461_n2874# VDD sg13_lv_pmos ad=91.2f pd=0.86u as=91.2f ps=0.86u w=0.48u l=0.13u
X200 a_3863_n8700# a_3863_n9186# VDD_uq0 VDD_uq0 sg13_lv_pmos ad=0.3078p pd=2u as=0.3078p ps=2u w=1.62u l=0.385u
X201 a_5087_n8700# a_5087_n9186# VDD_uq0 VDD_uq0 sg13_lv_pmos ad=0.3078p pd=2u as=0.3078p ps=2u w=1.62u l=0.385u
X202 VSS a_n727_n4982# a_n727_n4704# VSS sg13_lv_nmos ad=0.1577p pd=1.21u as=0.1577p ps=1.21u w=0.83u l=0.13u
X203 a_1747_n4035# a_1449_n4035# a_1645_n3630# VSS sg13_lv_nmos ad=0.1064p pd=0.94u as=0.1064p ps=0.94u w=0.56u l=0.13u
X204 VDD_uq0 a_2027_n9186# a_2027_n8700# VDD_uq0 sg13_lv_pmos ad=0.3078p pd=2u as=0.3078p ps=2u w=1.62u l=0.385u
X205 a_497_n3660# a_497_n4146# VDD VDD sg13_lv_pmos ad=0.3078p pd=2u as=0.3078p ps=2u w=1.62u l=0.385u
X206 VDD a_5087_n3024# a_5087_n3302# VDD sg13_lv_pmos ad=0.3078p pd=2u as=0.3078p ps=2u w=1.62u l=0.385u
X207 a_n1033_n8342# a_n1033_n8064# VDD_uq0 VDD_uq0 sg13_lv_pmos ad=0.3078p pd=2u as=0.3078p ps=2u w=1.62u l=0.385u
X208 VDD_uq0 a_3863_n9186# a_3863_n8700# VDD_uq0 sg13_lv_pmos ad=0.3078p pd=2u as=0.3078p ps=2u w=1.62u l=0.385u
X209 a_2971_n3260# ACLK_N a_2869_n2880# VDD sg13_lv_pmos ad=0.1511p pd=1.37u as=0.1881p ps=1.37u w=0.99u l=0.13u
X210 a_3149_n3300# a_2971_n3260# VSS VSS sg13_lv_nmos ad=0.1632p pd=1.64u as=91.2f ps=0.86u w=0.48u l=0.13u
X211 VDD a_6447_n3624# a_6485_n3704# VDD sg13_lv_pmos ad=0.5508p pd=3.92u as=0.3078p ps=2u w=1.62u l=0.385u
X212 a_1415_n8700# a_1415_n9186# VDD_uq0 VDD_uq0 sg13_lv_pmos ad=0.3078p pd=2u as=0.3078p ps=2u w=1.62u l=0.385u
X213 VSS a_6485_n3082# a_6447_n3262# VSS sg13_lv_nmos ad=0.2822p pd=2.34u as=0.1577p ps=1.21u w=0.83u l=0.13u
X214 a_2257_n4035# a_1747_n4035# VDD VDD sg13_lv_pmos ad=0.18525p pd=1.355u as=0.14812p ps=1.355u w=0.975u l=0.13u
X215 VSS a_4475_n8700# a_4475_n9186# VSS sg13_lv_nmos ad=0.1577p pd=1.21u as=0.1577p ps=1.21u w=0.83u l=0.13u
X216 VDD_uq0 a_5699_n8064# a_5699_n8342# VDD_uq0 sg13_lv_pmos ad=0.5508p pd=3.92u as=0.3078p ps=2u w=1.62u l=0.385u
X217 VDD_uq0 a_4475_n8064# a_4475_n8342# VDD_uq0 sg13_lv_pmos ad=0.3078p pd=2u as=0.3078p ps=2u w=1.62u l=0.385u
X218 VSS a_497_n4982# a_497_n4704# VSS sg13_lv_nmos ad=0.2822p pd=2.34u as=0.1577p ps=1.21u w=0.83u l=0.13u
X219 a_5457_n3764# a_5967_n3764# VDD VDD sg13_lv_pmos ad=0.5508p pd=3.92u as=0.5508p ps=3.92u w=1.62u l=0.13u
X220 a_3251_n8342# a_3251_n8064# VDD_uq0 VDD_uq0 sg13_lv_pmos ad=0.3078p pd=2u as=0.3078p ps=2u w=1.62u l=0.385u
X221 VSS a_3863_n8700# a_3863_n9186# VSS sg13_lv_nmos ad=0.1577p pd=1.21u as=0.1577p ps=1.21u w=0.83u l=0.13u
X222 a_1211_n3300# a_1211_n3300# VDD VDD sg13_lv_pmos ad=0.1632p pd=1.64u as=0.1632p ps=1.64u w=0.48u l=0.13u
X223 VSS a_2639_n8700# a_2639_n9186# VSS sg13_lv_nmos ad=0.1577p pd=1.21u as=0.1577p ps=1.21u w=0.83u l=0.13u
X224 ADDR_DEC<5> a_1211_n4140# VSS VSS sg13_lv_nmos ad=0.1632p pd=1.64u as=0.1632p ps=1.64u w=0.48u l=0.13u
X225 a_n115_n3660# a_n115_n4146# VDD VDD sg13_lv_pmos ad=0.3078p pd=2u as=0.3078p ps=2u w=1.62u l=0.385u
X226 VSS a_2027_n8700# a_2027_n9186# VSS sg13_lv_nmos ad=0.1577p pd=1.21u as=0.1577p ps=1.21u w=0.83u l=0.13u
X227 a_4475_n8064# a_4475_n8342# VSS VSS sg13_lv_nmos ad=0.1577p pd=1.21u as=0.1577p ps=1.21u w=0.83u l=0.13u
X228 VDD a_497_n4704# a_497_n4982# VDD sg13_lv_pmos ad=0.3078p pd=2u as=0.3078p ps=2u w=1.62u l=0.385u
X229 a_803_n8342# a_803_n8064# VDD_uq0 VDD_uq0 sg13_lv_pmos ad=0.3078p pd=2u as=0.3078p ps=2u w=1.62u l=0.385u
X230 VDD a_n115_n4704# a_n115_n4982# VDD sg13_lv_pmos ad=0.3078p pd=2u as=0.3078p ps=2u w=1.62u l=0.385u
X231 VSS a_4343_n3704# a_4305_n3624# VSS sg13_lv_nmos ad=0.2822p pd=2.34u as=0.1577p ps=1.21u w=0.83u l=0.13u
X232 a_1645_n3202# ADDR<0> VSS VSS sg13_lv_nmos ad=0.1064p pd=0.94u as=0.1064p ps=0.94u w=0.56u l=0.13u
X233 VDD_uq0 a_2027_n9186# a_2027_n8700# VDD_uq0 sg13_lv_pmos ad=0.3078p pd=2u as=0.3078p ps=2u w=1.62u l=0.385u
X234 a_6447_n8302# a_6485_n8122# VSS VSS sg13_lv_nmos ad=0.1577p pd=1.21u as=0.1577p ps=1.21u w=0.83u l=0.13u
X235 VDD a_n999_n4104# a_n999_n4104# VDD sg13_lv_pmos ad=0.1632p pd=1.64u as=0.1632p ps=1.64u w=0.48u l=0.13u
X236 a_4475_n3024# a_4475_n3302# VSS VSS sg13_lv_nmos ad=0.1577p pd=1.21u as=0.1577p ps=1.21u w=0.83u l=0.13u
X237 a_2639_n8064# a_2639_n8342# VSS VSS sg13_lv_nmos ad=0.1577p pd=1.21u as=0.1577p ps=1.21u w=0.83u l=0.13u
X238 VDD a_n727_n4704# a_n727_n4982# VDD sg13_lv_pmos ad=0.3078p pd=2u as=0.3078p ps=2u w=1.62u l=0.385u
X239 VSS a_6485_n3704# a_6447_n3624# VSS sg13_lv_nmos ad=0.1577p pd=1.21u as=0.2822p ps=2.34u w=0.83u l=0.13u
X240 VSS a_5699_n8342# a_5699_n8064# VSS sg13_lv_nmos ad=0.2822p pd=2.34u as=0.1577p ps=1.21u w=0.83u l=0.13u
X241 a_4475_n3024# a_4475_n3302# VSS VSS sg13_lv_nmos ad=0.1577p pd=1.21u as=0.1577p ps=1.21u w=0.83u l=0.13u
X242 a_n421_n8342# a_n421_n8064# VDD_uq0 VDD_uq0 sg13_lv_pmos ad=0.3078p pd=2u as=0.3078p ps=2u w=1.62u l=0.385u
X243 a_3863_n3024# a_3863_n3302# VSS VSS sg13_lv_nmos ad=0.1577p pd=1.21u as=0.1577p ps=1.21u w=0.83u l=0.13u
X244 a_n115_n3660# a_n115_n4146# VDD VDD sg13_lv_pmos ad=0.3078p pd=2u as=0.3078p ps=2u w=1.62u l=0.385u
X245 a_2537_n3220# a_2359_n3262# VSS VSS sg13_lv_nmos ad=0.1632p pd=1.64u as=91.2f ps=0.86u w=0.48u l=0.13u
X246 VDD_uq0 a_n1033_n9186# a_n1033_n8700# VDD_uq0 sg13_lv_pmos ad=0.3078p pd=2u as=0.3078p ps=2u w=1.62u l=0.385u
X247 VSS a_2537_n4040# a_2461_n3632# VSS sg13_lv_nmos ad=91.2f pd=0.86u as=91.2f ps=0.86u w=0.48u l=0.13u
X248 a_2257_n2880# a_1747_n3202# VDD VDD sg13_lv_pmos ad=0.18525p pd=1.355u as=0.14812p ps=1.355u w=0.975u l=0.13u
X249 VSS a_5699_n3302# a_5699_n3024# VSS sg13_lv_nmos ad=0.1577p pd=1.21u as=0.1577p ps=1.21u w=0.83u l=0.13u
X250 a_3251_n8342# a_3251_n8064# VDD_uq0 VDD_uq0 sg13_lv_pmos ad=0.3078p pd=2u as=0.3078p ps=2u w=1.62u l=0.385u
X251 a_2971_n4038# a_2061_n4035# a_2869_n3672# VSS sg13_lv_nmos ad=0.13375p pd=1.23u as=0.1783p ps=1.44u w=0.85u l=0.13u
X252 VDD_uq0 a_803_n8064# a_803_n8342# VDD_uq0 sg13_lv_pmos ad=0.3078p pd=2u as=0.3078p ps=2u w=1.62u l=0.385u
X253 VSS a_4475_n8342# a_4475_n8064# VSS sg13_lv_nmos ad=0.1577p pd=1.21u as=0.1577p ps=1.21u w=0.83u l=0.13u
X254 a_191_n9186# a_191_n8700# VSS VSS sg13_lv_nmos ad=0.1577p pd=1.21u as=0.1577p ps=1.21u w=0.83u l=0.13u
X255 a_3863_n3302# a_3863_n3024# VDD VDD sg13_lv_pmos ad=0.3078p pd=2u as=0.5508p ps=3.92u w=1.62u l=0.385u
X256 a_5087_n3302# a_5087_n3024# VDD VDD sg13_lv_pmos ad=0.3078p pd=2u as=0.3078p ps=2u w=1.62u l=0.385u
X257 VSS a_3863_n8342# a_3863_n8064# VSS sg13_lv_nmos ad=0.1577p pd=1.21u as=0.1577p ps=1.21u w=0.83u l=0.13u
X258 a_1747_n3202# a_1449_n3202# a_1645_n3202# VSS sg13_lv_nmos ad=0.1064p pd=0.94u as=0.1064p ps=0.94u w=0.56u l=0.13u
X259 a_5050_n3764# a_2971_n3260# VDD VDD sg13_lv_pmos ad=0.5508p pd=3.92u as=0.5508p ps=3.92u w=1.62u l=0.13u
X260 a_2639_n8700# a_2639_n9186# VDD_uq0 VDD_uq0 sg13_lv_pmos ad=0.3078p pd=2u as=0.3078p ps=2u w=1.62u l=0.385u
X261 VSS a_2639_n8342# a_2639_n8064# VSS sg13_lv_nmos ad=0.1577p pd=1.21u as=0.1577p ps=1.21u w=0.83u l=0.13u
X262 a_5011_n3654# a_5967_n3764# VSS VSS sg13_lv_nmos ad=0.1862p pd=1.36u as=0.3332p ps=2.64u w=0.98u l=0.13u
X263 VSS a_191_n8700# a_191_n9186# VSS sg13_lv_nmos ad=0.1577p pd=1.21u as=0.1577p ps=1.21u w=0.83u l=0.13u
X264 VSS a_2027_n8342# a_2027_n8064# VSS sg13_lv_nmos ad=0.1577p pd=1.21u as=0.1577p ps=1.21u w=0.83u l=0.13u
X265 VDD a_3863_n3024# a_3863_n3302# VDD sg13_lv_pmos ad=0.3078p pd=2u as=0.3078p ps=2u w=1.62u l=0.385u
X266 a_1849_n4035# a_1449_n4035# a_1747_n4035# VDD sg13_lv_pmos ad=0.18715p pd=1.365u as=0.18715p ps=1.365u w=0.985u l=0.13u
X267 VSS a_497_n3660# a_497_n4146# VSS sg13_lv_nmos ad=0.1577p pd=1.21u as=0.1577p ps=1.21u w=0.83u l=0.13u
X268 VSS a_n1033_n8700# a_n1033_n9186# VSS sg13_lv_nmos ad=0.1577p pd=1.21u as=0.1577p ps=1.21u w=0.83u l=0.13u
X269 VSS a_5087_n8700# a_5087_n9186# VSS sg13_lv_nmos ad=0.1577p pd=1.21u as=0.1577p ps=1.21u w=0.83u l=0.13u
X270 ADDR_DEC<2> a_3889_n4104# VSS VSS sg13_lv_nmos ad=0.3332p pd=2.64u as=0.3332p ps=2.64u w=0.98u l=0.13u
X271 VSS a_n421_n8700# a_n421_n9186# VSS sg13_lv_nmos ad=0.1577p pd=1.21u as=0.1577p ps=1.21u w=0.83u l=0.13u
X272 VSS a_3863_n8700# a_3863_n9186# VSS sg13_lv_nmos ad=0.1577p pd=1.21u as=0.1577p ps=1.21u w=0.83u l=0.13u
X273 VSS a_5087_n8700# a_5087_n9186# VSS sg13_lv_nmos ad=0.1577p pd=1.21u as=0.1577p ps=1.21u w=0.83u l=0.13u
X274 VDD_uq0 a_n1033_n9186# a_n1033_n8700# VDD_uq0 sg13_lv_pmos ad=0.3078p pd=2u as=0.3078p ps=2u w=1.62u l=0.385u
X275 a_497_n3024# a_497_n3302# VSS VSS sg13_lv_nmos ad=0.1577p pd=1.21u as=0.1577p ps=1.21u w=0.83u l=0.13u
X276 a_6031_n4104# a_6070_n3764# a_6031_n3654# VSS sg13_lv_nmos ad=0.3332p pd=2.64u as=0.1862p ps=1.36u w=0.98u l=0.13u
X277 a_2257_n3632# a_1747_n4035# VSS VSS sg13_lv_nmos ad=0.1653p pd=1.25u as=0.13717p ps=1.25u w=0.87u l=0.13u
X278 a_497_n4146# a_497_n3660# VSS VSS sg13_lv_nmos ad=0.1577p pd=1.21u as=0.1577p ps=1.21u w=0.83u l=0.13u
X279 VSS a_3251_n8700# a_3251_n9186# VSS sg13_lv_nmos ad=0.1577p pd=1.21u as=0.1577p ps=1.21u w=0.83u l=0.13u
X280 a_5699_n9186# a_5699_n8700# VSS VSS sg13_lv_nmos ad=0.1577p pd=1.21u as=0.1577p ps=1.21u w=0.83u l=0.13u
X281 a_497_n4982# a_497_n4704# VDD VDD sg13_lv_pmos ad=0.3078p pd=2u as=0.3078p ps=2u w=1.62u l=0.385u
X282 VSS a_1415_n8700# a_1415_n9186# VSS sg13_lv_nmos ad=0.1577p pd=1.21u as=0.1577p ps=1.21u w=0.83u l=0.13u
X283 VSS a_2639_n8700# a_2639_n9186# VSS sg13_lv_nmos ad=0.1577p pd=1.21u as=0.1577p ps=1.21u w=0.83u l=0.13u
X284 a_4475_n8700# a_4475_n9186# VDD_uq0 VDD_uq0 sg13_lv_pmos ad=0.3078p pd=2u as=0.3078p ps=2u w=1.62u l=0.385u
X285 VSS a_497_n3302# a_497_n3024# VSS sg13_lv_nmos ad=0.1577p pd=1.21u as=0.1577p ps=1.21u w=0.83u l=0.13u
X286 VSS a_1415_n8700# a_1415_n9186# VSS sg13_lv_nmos ad=0.1577p pd=1.21u as=0.1577p ps=1.21u w=0.83u l=0.13u
X287 VDD_uq0 a_191_n8064# a_191_n8342# VDD_uq0 sg13_lv_pmos ad=0.3078p pd=2u as=0.3078p ps=2u w=1.62u l=0.385u
X288 VDD_uq0 a_n421_n8064# a_n421_n8342# VDD_uq0 sg13_lv_pmos ad=0.3078p pd=2u as=0.3078p ps=2u w=1.62u l=0.385u
X289 VDD a_n115_n4146# a_n115_n3660# VDD sg13_lv_pmos ad=0.3078p pd=2u as=0.3078p ps=2u w=1.62u l=0.385u
X290 a_497_n4982# a_497_n4704# VDD VDD sg13_lv_pmos ad=0.3078p pd=2u as=0.3078p ps=2u w=1.62u l=0.385u
X291 VSS a_803_n8700# a_803_n9186# VSS sg13_lv_nmos ad=0.1577p pd=1.21u as=0.1577p ps=1.21u w=0.83u l=0.13u
X292 a_5699_n3024# a_5699_n3302# VSS VSS sg13_lv_nmos ad=0.1577p pd=1.21u as=0.1577p ps=1.21u w=0.83u l=0.13u
X293 a_1849_n2882# a_1449_n3202# a_1747_n3202# VDD sg13_lv_pmos ad=0.18715p pd=1.365u as=0.18715p ps=1.365u w=0.985u l=0.13u
X294 VDD_uq0 a_3251_n9186# a_3251_n8700# VDD_uq0 sg13_lv_pmos ad=0.3078p pd=2u as=0.3078p ps=2u w=1.62u l=0.385u
X295 VDD_uq0 a_n421_n8064# a_n421_n8342# VDD_uq0 sg13_lv_pmos ad=0.3078p pd=2u as=0.3078p ps=2u w=1.62u l=0.385u
X296 a_2537_n4040# a_2359_n4035# VDD VDD sg13_lv_pmos ad=0.1632p pd=1.64u as=91.2f ps=0.86u w=0.48u l=0.13u
X297 a_2027_n8700# a_2027_n9186# VDD_uq0 VDD_uq0 sg13_lv_pmos ad=0.3078p pd=2u as=0.3078p ps=2u w=1.62u l=0.385u
X298 a_5011_n4104# a_5967_n3764# VDD VDD sg13_lv_pmos ad=0.3078p pd=2u as=0.5508p ps=3.92u w=1.62u l=0.13u
X299 a_191_n8064# a_191_n8342# VSS VSS sg13_lv_nmos ad=0.1577p pd=1.21u as=0.1577p ps=1.21u w=0.83u l=0.13u
X300 a_6070_n3764# a_5050_n3764# VSS VSS sg13_lv_nmos ad=0.3332p pd=2.64u as=0.3332p ps=2.64u w=0.98u l=0.13u
X301 a_n115_n4146# a_n115_n3660# VSS VSS sg13_lv_nmos ad=0.1577p pd=1.21u as=0.1577p ps=1.21u w=0.83u l=0.13u
X302 VDD_uq0 a_5699_n8064# a_5699_n8342# VDD_uq0 sg13_lv_pmos ad=0.3078p pd=2u as=0.3078p ps=2u w=1.62u l=0.385u
X303 a_n115_n4146# a_n115_n3660# VSS VSS sg13_lv_nmos ad=0.1577p pd=1.21u as=0.1577p ps=1.21u w=0.83u l=0.13u
X304 a_n421_n9186# a_n421_n8700# VSS VSS sg13_lv_nmos ad=0.1577p pd=1.21u as=0.1577p ps=1.21u w=0.83u l=0.13u
X305 a_4475_n8342# a_4475_n8064# VDD_uq0 VDD_uq0 sg13_lv_pmos ad=0.3078p pd=2u as=0.3078p ps=2u w=1.62u l=0.385u
X306 a_5087_n9186# a_5087_n8700# VSS VSS sg13_lv_nmos ad=0.1577p pd=1.21u as=0.1577p ps=1.21u w=0.83u l=0.13u
X307 VDD_uq0 a_2639_n8064# a_2639_n8342# VDD_uq0 sg13_lv_pmos ad=0.3078p pd=2u as=0.3078p ps=2u w=1.62u l=0.385u
X308 VDD_uq0 a_1415_n8064# a_1415_n8342# VDD_uq0 sg13_lv_pmos ad=0.3078p pd=2u as=0.3078p ps=2u w=1.62u l=0.385u
X309 ADDR_DEC<2> a_3889_n4104# VDD VDD sg13_lv_pmos ad=0.5508p pd=3.92u as=0.5508p ps=3.92u w=1.62u l=0.13u
X310 a_6485_n3704# a_6447_n3624# VDD VDD sg13_lv_pmos ad=0.3078p pd=2u as=0.5508p ps=3.92u w=1.62u l=0.385u
X311 VSS a_191_n8342# a_191_n8064# VSS sg13_lv_nmos ad=0.1577p pd=1.21u as=0.1577p ps=1.21u w=0.83u l=0.13u
X312 VSS a_n115_n3302# a_n115_n3024# VSS sg13_lv_nmos ad=0.1577p pd=1.21u as=0.1577p ps=1.21u w=0.83u l=0.13u
X313 VDD a_6070_n3764# a_6031_n4104# VDD sg13_lv_pmos ad=0.5508p pd=3.92u as=0.3078p ps=2u w=1.62u l=0.13u
X314 a_3251_n9186# a_3251_n8700# VSS VSS sg13_lv_nmos ad=0.1577p pd=1.21u as=0.1577p ps=1.21u w=0.83u l=0.13u
X315 VSS a_n1033_n8342# a_n1033_n8064# VSS sg13_lv_nmos ad=0.1577p pd=1.21u as=0.1577p ps=1.21u w=0.83u l=0.13u
X316 a_5699_n8342# a_5699_n8064# VDD_uq0 VDD_uq0 sg13_lv_pmos ad=0.3078p pd=2u as=0.3078p ps=2u w=1.62u l=0.385u
X317 VSS a_5087_n8342# a_5087_n8064# VSS sg13_lv_nmos ad=0.1577p pd=1.21u as=0.1577p ps=1.21u w=0.83u l=0.13u
X318 VSS a_n115_n3302# a_n115_n3024# VSS sg13_lv_nmos ad=0.1577p pd=1.21u as=0.1577p ps=1.21u w=0.83u l=0.13u
X319 VDD_uq0 a_3251_n8064# a_3251_n8342# VDD_uq0 sg13_lv_pmos ad=0.3078p pd=2u as=0.3078p ps=2u w=1.62u l=0.385u
X320 a_n115_n4982# a_n115_n4704# VDD VDD sg13_lv_pmos ad=0.3078p pd=2u as=0.3078p ps=2u w=1.62u l=0.385u
X321 a_2027_n8342# a_2027_n8064# VDD_uq0 VDD_uq0 sg13_lv_pmos ad=0.3078p pd=2u as=0.3078p ps=2u w=1.62u l=0.385u
X322 VSS a_n727_n3660# a_n727_n4146# VSS sg13_lv_nmos ad=0.1577p pd=1.21u as=0.1577p ps=1.21u w=0.83u l=0.13u
X323 VSS a_n421_n8342# a_n421_n8064# VSS sg13_lv_nmos ad=0.1577p pd=1.21u as=0.1577p ps=1.21u w=0.83u l=0.13u
X324 VSS a_5087_n8342# a_5087_n8064# VSS sg13_lv_nmos ad=0.1577p pd=1.21u as=0.1577p ps=1.21u w=0.83u l=0.13u
X325 VSS a_3863_n8342# a_3863_n8064# VSS sg13_lv_nmos ad=0.1577p pd=1.21u as=0.1577p ps=1.21u w=0.83u l=0.13u
X326 VSS a_n999_n2712# ADDR_DEC<4> VSS sg13_lv_nmos ad=0.1632p pd=1.64u as=0.1632p ps=1.64u w=0.48u l=0.13u
X327 a_803_n9186# a_803_n8700# VSS VSS sg13_lv_nmos ad=0.1577p pd=1.21u as=0.1577p ps=1.21u w=0.83u l=0.13u
X328 VSS a_n727_n3660# a_n727_n4146# VSS sg13_lv_nmos ad=0.1577p pd=1.21u as=0.1577p ps=1.21u w=0.83u l=0.13u
X329 VSS a_3251_n8342# a_3251_n8064# VSS sg13_lv_nmos ad=0.1577p pd=1.21u as=0.1577p ps=1.21u w=0.83u l=0.13u
X330 a_5699_n8064# a_5699_n8342# VSS VSS sg13_lv_nmos ad=0.1577p pd=1.21u as=0.1577p ps=1.21u w=0.83u l=0.13u
X331 a_n727_n3024# a_n727_n3302# VSS VSS sg13_lv_nmos ad=0.1577p pd=1.21u as=0.1577p ps=1.21u w=0.83u l=0.13u
X332 VSS a_5087_n3302# a_5087_n3024# VSS sg13_lv_nmos ad=0.1577p pd=1.21u as=0.1577p ps=1.21u w=0.83u l=0.13u
X333 VSS a_2639_n8342# a_2639_n8064# VSS sg13_lv_nmos ad=0.1577p pd=1.21u as=0.1577p ps=1.21u w=0.83u l=0.13u
X334 VSS a_1415_n8342# a_1415_n8064# VSS sg13_lv_nmos ad=0.1577p pd=1.21u as=0.1577p ps=1.21u w=0.83u l=0.13u
X335 a_n115_n3024# a_n115_n3302# VSS VSS sg13_lv_nmos ad=0.1577p pd=1.21u as=0.1577p ps=1.21u w=0.83u l=0.13u
X336 VSS a_1415_n8342# a_1415_n8064# VSS sg13_lv_nmos ad=0.1577p pd=1.21u as=0.1577p ps=1.21u w=0.83u l=0.13u
X337 VSS a_n115_n4982# a_n115_n4704# VSS sg13_lv_nmos ad=0.1577p pd=1.21u as=0.1577p ps=1.21u w=0.83u l=0.13u
X338 a_n115_n4982# a_n115_n4704# VDD VDD sg13_lv_pmos ad=0.3078p pd=2u as=0.3078p ps=2u w=1.62u l=0.385u
X339 VSS a_803_n8342# a_803_n8064# VSS sg13_lv_nmos ad=0.1577p pd=1.21u as=0.1577p ps=1.21u w=0.83u l=0.13u
X340 VDD a_n727_n3024# a_n727_n3302# VDD sg13_lv_pmos ad=0.3078p pd=2u as=0.3078p ps=2u w=1.62u l=0.385u
X341 VSS a_497_n3660# a_497_n4146# VSS sg13_lv_nmos ad=0.2822p pd=2.34u as=0.1577p ps=1.21u w=0.83u l=0.13u
X342 a_497_n4704# a_497_n4982# VSS VSS sg13_lv_nmos ad=0.1577p pd=1.21u as=0.1577p ps=1.21u w=0.83u l=0.13u
X343 VSS a_6485_n8744# a_6447_n8664# VSS sg13_lv_nmos ad=0.2822p pd=2.34u as=0.1577p ps=1.21u w=0.83u l=0.13u
X344 a_n1033_n8700# a_n1033_n9186# VDD_uq0 VDD_uq0 sg13_lv_pmos ad=0.3078p pd=2u as=0.3078p ps=2u w=1.62u l=0.385u
X345 a_191_n8342# a_191_n8064# VDD_uq0 VDD_uq0 sg13_lv_pmos ad=0.3078p pd=2u as=0.3078p ps=2u w=1.62u l=0.385u
X346 a_n727_n4704# a_n727_n4982# VSS VSS sg13_lv_nmos ad=0.1577p pd=1.21u as=0.2822p ps=2.34u w=0.83u l=0.13u
X347 a_4475_n3302# a_4475_n3024# VDD VDD sg13_lv_pmos ad=0.3078p pd=2u as=0.3078p ps=2u w=1.62u l=0.385u
X348 a_2537_n3220# a_2359_n3262# VDD VDD sg13_lv_pmos ad=0.1632p pd=1.64u as=91.2f ps=0.86u w=0.48u l=0.13u
X349 a_n421_n8064# a_n421_n8342# VSS VSS sg13_lv_nmos ad=0.1577p pd=1.21u as=0.1577p ps=1.21u w=0.83u l=0.13u
X350 VDD a_n999_n2712# a_n999_n2712# VDD sg13_lv_pmos ad=0.1632p pd=1.64u as=0.1632p ps=1.64u w=0.48u l=0.13u
X351 a_5087_n8064# a_5087_n8342# VSS VSS sg13_lv_nmos ad=0.1577p pd=1.21u as=0.1577p ps=1.21u w=0.83u l=0.13u
X352 a_n727_n4704# a_n727_n4982# VSS VSS sg13_lv_nmos ad=0.1577p pd=1.21u as=0.1577p ps=1.21u w=0.83u l=0.13u
X353 a_3073_n3630# ACLK_N a_2971_n4038# VSS sg13_lv_nmos ad=91.2f pd=0.86u as=0.13375p ps=1.23u w=0.48u l=0.13u
X354 a_1849_n3630# BIST_EN_I a_1747_n4035# VSS sg13_lv_nmos ad=0.1064p pd=0.94u as=0.1064p ps=0.94u w=0.56u l=0.13u
X355 VSS a_n999_n4104# ADDR_COL<1> VSS sg13_lv_nmos ad=0.1632p pd=1.64u as=0.1632p ps=1.64u w=0.48u l=0.13u
X356 VDD_uq0 a_4475_n9186# a_4475_n8700# VDD_uq0 sg13_lv_pmos ad=0.3078p pd=2u as=0.3078p ps=2u w=1.62u l=0.385u
X357 VDD_uq0 a_5699_n9186# a_5699_n8700# VDD_uq0 sg13_lv_pmos ad=0.5508p pd=3.92u as=0.3078p ps=2u w=1.62u l=0.385u
X358 a_3251_n8700# a_3251_n9186# VDD_uq0 VDD_uq0 sg13_lv_pmos ad=0.3078p pd=2u as=0.3078p ps=2u w=1.62u l=0.385u
X359 a_803_n8342# a_803_n8064# VDD_uq0 VDD_uq0 sg13_lv_pmos ad=0.3078p pd=2u as=0.3078p ps=2u w=1.62u l=0.385u
X360 a_3251_n8064# a_3251_n8342# VSS VSS sg13_lv_nmos ad=0.1577p pd=1.21u as=0.1577p ps=1.21u w=0.83u l=0.13u
X361 a_5521_n3654# a_5457_n3764# VSS VSS sg13_lv_nmos ad=0.1862p pd=1.36u as=0.3332p ps=2.64u w=0.98u l=0.13u
X362 a_5699_n8342# a_5699_n8064# VDD_uq0 VDD_uq0 sg13_lv_pmos ad=0.3078p pd=2u as=0.3078p ps=2u w=1.62u l=0.385u
X363 a_5011_n4104# a_5050_n3764# a_5011_n3654# VSS sg13_lv_nmos ad=0.3332p pd=2.64u as=0.1862p ps=1.36u w=0.98u l=0.13u
X364 a_3889_n3654# a_5457_n3764# VSS VSS sg13_lv_nmos ad=0.1862p pd=1.36u as=0.3332p ps=2.64u w=0.98u l=0.13u
X365 VDD_uq0 a_6447_n8302# a_6485_n8122# VDD_uq0 sg13_lv_pmos ad=0.5508p pd=3.92u as=0.3078p ps=2u w=1.62u l=0.385u
X366 a_2359_n4035# a_2061_n4035# a_2257_n4035# VDD sg13_lv_pmos ad=0.14927p pd=1.355u as=0.18525p ps=1.355u w=0.975u l=0.13u
X367 a_4475_n9186# a_4475_n8700# VSS VSS sg13_lv_nmos ad=0.1577p pd=1.21u as=0.1577p ps=1.21u w=0.83u l=0.13u
X368 a_803_n8064# a_803_n8342# VSS VSS sg13_lv_nmos ad=0.1577p pd=1.21u as=0.1577p ps=1.21u w=0.83u l=0.13u
X369 a_803_n8700# a_803_n9186# VDD_uq0 VDD_uq0 sg13_lv_pmos ad=0.3078p pd=2u as=0.3078p ps=2u w=1.62u l=0.385u
X370 a_5967_n3764# a_2971_n4038# VSS VSS sg13_lv_nmos ad=0.3332p pd=2.64u as=0.3332p ps=2.64u w=0.98u l=0.13u
X371 VDD BIST_EN_I a_1449_n3202# VDD sg13_lv_pmos ad=0.16165p pd=1.365u as=0.2193p ps=1.97u w=0.645u l=0.13u
X372 ADDR_DEC<3> a_5521_n4104# VSS VSS sg13_lv_nmos ad=0.3332p pd=2.64u as=0.3332p ps=2.64u w=0.98u l=0.13u
X373 a_4475_n9186# a_4475_n8700# VSS VSS sg13_lv_nmos ad=0.1577p pd=1.21u as=0.1577p ps=1.21u w=0.83u l=0.13u
X374 VDD_uq0 a_4475_n8064# a_4475_n8342# VDD_uq0 sg13_lv_pmos ad=0.3078p pd=2u as=0.3078p ps=2u w=1.62u l=0.385u
X375 a_2639_n9186# a_2639_n8700# VSS VSS sg13_lv_nmos ad=0.1577p pd=1.21u as=0.1577p ps=1.21u w=0.83u l=0.13u
X376 a_3863_n9186# a_3863_n8700# VSS VSS sg13_lv_nmos ad=0.1577p pd=1.21u as=0.1577p ps=1.21u w=0.83u l=0.13u
X377 a_2027_n9186# a_2027_n8700# VSS VSS sg13_lv_nmos ad=0.1577p pd=1.21u as=0.1577p ps=1.21u w=0.83u l=0.13u
X378 a_n421_n8700# a_n421_n9186# VDD_uq0 VDD_uq0 sg13_lv_pmos ad=0.3078p pd=2u as=0.3078p ps=2u w=1.62u l=0.385u
X379 a_191_n8342# a_191_n8064# VDD_uq0 VDD_uq0 sg13_lv_pmos ad=0.3078p pd=2u as=0.3078p ps=2u w=1.62u l=0.385u
X380 VSS a_n727_n4982# a_n727_n4704# VSS sg13_lv_nmos ad=0.1577p pd=1.21u as=0.1577p ps=1.21u w=0.83u l=0.13u
X381 VSS a_5699_n8700# a_5699_n9186# VSS sg13_lv_nmos ad=0.1577p pd=1.21u as=0.1577p ps=1.21u w=0.83u l=0.13u
X382 a_2027_n9186# a_2027_n8700# VSS VSS sg13_lv_nmos ad=0.1577p pd=1.21u as=0.1577p ps=1.21u w=0.83u l=0.13u
X383 VDD a_n115_n4704# a_n115_n4982# VDD sg13_lv_pmos ad=0.3078p pd=2u as=0.3078p ps=2u w=1.62u l=0.385u
X384 VSS a_6485_n8122# a_6447_n8302# VSS sg13_lv_nmos ad=0.2822p pd=2.34u as=0.1577p ps=1.21u w=0.83u l=0.13u
X385 VSS a_4475_n3302# a_4475_n3024# VSS sg13_lv_nmos ad=0.1577p pd=1.21u as=0.1577p ps=1.21u w=0.83u l=0.13u
X386 a_3251_n8700# a_3251_n9186# VDD_uq0 VDD_uq0 sg13_lv_pmos ad=0.3078p pd=2u as=0.3078p ps=2u w=1.62u l=0.385u
X387 a_6447_n3624# a_6485_n3704# VSS VSS sg13_lv_nmos ad=0.1577p pd=1.21u as=0.1577p ps=1.21u w=0.83u l=0.13u
X388 VSS a_4475_n3302# a_4475_n3024# VSS sg13_lv_nmos ad=0.1577p pd=1.21u as=0.1577p ps=1.21u w=0.83u l=0.13u
X389 VDD_uq0 a_803_n9186# a_803_n8700# VDD_uq0 sg13_lv_pmos ad=0.3078p pd=2u as=0.3078p ps=2u w=1.62u l=0.385u
X390 a_5521_n4104# a_5457_n3764# VDD VDD sg13_lv_pmos ad=0.3078p pd=2u as=0.5508p ps=3.92u w=1.62u l=0.13u
X391 a_5087_n8342# a_5087_n8064# VDD_uq0 VDD_uq0 sg13_lv_pmos ad=0.3078p pd=2u as=0.3078p ps=2u w=1.62u l=0.385u
X392 VSS a_3863_n3302# a_3863_n3024# VSS sg13_lv_nmos ad=0.1577p pd=1.21u as=0.1577p ps=1.21u w=0.83u l=0.13u
X393 VDD_uq0 a_2639_n8064# a_2639_n8342# VDD_uq0 sg13_lv_pmos ad=0.3078p pd=2u as=0.3078p ps=2u w=1.62u l=0.385u
X394 VDD a_5050_n3764# a_5011_n4104# VDD sg13_lv_pmos ad=0.5508p pd=3.92u as=0.3078p ps=2u w=1.62u l=0.13u
X395 a_3889_n4104# a_5457_n3764# VDD VDD sg13_lv_pmos ad=0.3078p pd=2u as=0.5508p ps=3.92u w=1.62u l=0.13u
X396 VSS a_6485_n3082# a_6447_n3262# VSS sg13_lv_nmos ad=0.1577p pd=1.21u as=0.2822p ps=2.34u w=0.83u l=0.13u
X397 a_n421_n8342# a_n421_n8064# VDD_uq0 VDD_uq0 sg13_lv_pmos ad=0.3078p pd=2u as=0.3078p ps=2u w=1.62u l=0.385u
X398 ADDR_DEC<7> a_1211_n4980# VSS VSS sg13_lv_nmos ad=0.1632p pd=1.64u as=0.1632p ps=1.64u w=0.48u l=0.13u
X399 a_2537_n4040# a_2359_n4035# VSS VSS sg13_lv_nmos ad=0.1632p pd=1.64u as=91.2f ps=0.86u w=0.48u l=0.13u
X400 a_2359_n3262# a_2061_n3262# a_2257_n2880# VDD sg13_lv_pmos ad=0.14927p pd=1.355u as=0.18525p ps=1.355u w=0.975u l=0.13u
X401 a_5967_n3764# a_2971_n4038# VDD VDD sg13_lv_pmos ad=0.5508p pd=3.92u as=0.5508p ps=3.92u w=1.62u l=0.13u
X402 a_5699_n3024# a_5699_n3302# VSS VSS sg13_lv_nmos ad=0.1577p pd=1.21u as=0.1577p ps=1.21u w=0.83u l=0.13u
X403 ADDR_DEC<3> a_5521_n4104# VDD VDD sg13_lv_pmos ad=0.5508p pd=3.92u as=0.5508p ps=3.92u w=1.62u l=0.13u
X404 VSS ACLK_N a_2061_n3262# VSS sg13_lv_nmos ad=0.13717p pd=1.25u as=0.1683p ps=1.67u w=0.495u l=0.13u
X405 VDD_uq0 a_3863_n8064# a_3863_n8342# VDD_uq0 sg13_lv_pmos ad=0.3078p pd=2u as=0.3078p ps=2u w=1.62u l=0.385u
X406 a_n727_n3302# a_n727_n3024# VDD VDD sg13_lv_pmos ad=0.3078p pd=2u as=0.5508p ps=3.92u w=1.62u l=0.385u
X407 a_2971_n3260# a_2061_n3262# a_2869_n3218# VSS sg13_lv_nmos ad=0.13375p pd=1.23u as=0.1783p ps=1.44u w=0.85u l=0.13u
X408 a_1415_n8342# a_1415_n8064# VDD_uq0 VDD_uq0 sg13_lv_pmos ad=0.3078p pd=2u as=0.3078p ps=2u w=1.62u l=0.385u
X409 a_3073_n3938# a_2061_n4035# a_2971_n4038# VDD sg13_lv_pmos ad=91.2f pd=0.86u as=0.1511p ps=1.37u w=0.48u l=0.13u
X410 a_4475_n8064# a_4475_n8342# VSS VSS sg13_lv_nmos ad=0.1577p pd=1.21u as=0.1577p ps=1.21u w=0.83u l=0.13u
X411 VSS a_191_n8700# a_191_n9186# VSS sg13_lv_nmos ad=0.1577p pd=1.21u as=0.1577p ps=1.21u w=0.83u l=0.13u
X412 a_4475_n8064# a_4475_n8342# VSS VSS sg13_lv_nmos ad=0.1577p pd=1.21u as=0.1577p ps=1.21u w=0.83u l=0.13u
X413 VDD a_4475_n3024# a_4475_n3302# VDD sg13_lv_pmos ad=0.3078p pd=2u as=0.3078p ps=2u w=1.62u l=0.385u
X414 a_1849_n3202# BIST_EN_I a_1747_n3202# VSS sg13_lv_nmos ad=0.1064p pd=0.94u as=0.1064p ps=0.94u w=0.56u l=0.13u
X415 VDD a_5699_n3024# a_5699_n3302# VDD sg13_lv_pmos ad=0.5508p pd=3.92u as=0.3078p ps=2u w=1.62u l=0.385u
X416 VSS a_4343_n3704# a_4305_n3624# VSS sg13_lv_nmos ad=0.1577p pd=1.21u as=0.2822p ps=2.34u w=0.83u l=0.13u
X417 a_3863_n8064# a_3863_n8342# VSS VSS sg13_lv_nmos ad=0.1577p pd=1.21u as=0.1577p ps=1.21u w=0.83u l=0.13u
X418 a_2639_n8064# a_2639_n8342# VSS VSS sg13_lv_nmos ad=0.1577p pd=1.21u as=0.1577p ps=1.21u w=0.83u l=0.13u
X419 a_803_n9186# a_803_n8700# VSS VSS sg13_lv_nmos ad=0.1577p pd=1.21u as=0.1577p ps=1.21u w=0.83u l=0.13u
X420 a_2027_n8064# a_2027_n8342# VSS VSS sg13_lv_nmos ad=0.1577p pd=1.21u as=0.1577p ps=1.21u w=0.83u l=0.13u
X421 VSS a_5699_n8342# a_5699_n8064# VSS sg13_lv_nmos ad=0.1577p pd=1.21u as=0.1577p ps=1.21u w=0.83u l=0.13u
X422 VDD BIST_ADDR<1> a_1849_n4035# VDD sg13_lv_pmos ad=0.3349p pd=2.65u as=0.18715p ps=1.365u w=0.985u l=0.13u
X423 a_n1033_n9186# a_n1033_n8700# VSS VSS sg13_lv_nmos ad=0.1577p pd=1.21u as=0.1577p ps=1.21u w=0.83u l=0.13u
X424 a_3863_n3024# a_3863_n3302# VSS VSS sg13_lv_nmos ad=0.1577p pd=1.21u as=0.1577p ps=1.21u w=0.83u l=0.13u
X425 a_5699_n9186# a_5699_n8700# VSS VSS sg13_lv_nmos ad=0.1577p pd=1.21u as=0.1577p ps=1.21u w=0.83u l=0.13u
X426 a_2027_n8064# a_2027_n8342# VSS VSS sg13_lv_nmos ad=0.1577p pd=1.21u as=0.1577p ps=1.21u w=0.83u l=0.13u
X427 VDD_uq0 a_191_n9186# a_191_n8700# VDD_uq0 sg13_lv_pmos ad=0.3078p pd=2u as=0.3078p ps=2u w=1.62u l=0.385u
X428 VDD_uq0 a_n421_n9186# a_n421_n8700# VDD_uq0 sg13_lv_pmos ad=0.3078p pd=2u as=0.3078p ps=2u w=1.62u l=0.385u
X429 VDD BIST_EN_I a_1449_n4035# VDD sg13_lv_pmos ad=0.16165p pd=1.365u as=0.2193p ps=1.97u w=0.645u l=0.13u
X430 a_2461_n3184# a_2061_n3262# a_2359_n3262# VSS sg13_lv_nmos ad=91.2f pd=0.86u as=0.13605p ps=1.25u w=0.48u l=0.13u
X431 VSS a_497_n3302# a_497_n3024# VSS sg13_lv_nmos ad=0.1577p pd=1.21u as=0.1577p ps=1.21u w=0.83u l=0.13u
X432 a_2359_n4035# ACLK_N a_2257_n3632# VSS sg13_lv_nmos ad=0.13605p pd=1.25u as=0.1653p ps=1.25u w=0.87u l=0.13u
X433 a_2257_n3262# a_1747_n3202# VSS VSS sg13_lv_nmos ad=0.1653p pd=1.25u as=0.13717p ps=1.25u w=0.87u l=0.13u
X434 a_3251_n9186# a_3251_n8700# VSS VSS sg13_lv_nmos ad=0.1577p pd=1.21u as=0.1577p ps=1.21u w=0.83u l=0.13u
X435 VDD_uq0 a_n421_n9186# a_n421_n8700# VDD_uq0 sg13_lv_pmos ad=0.3078p pd=2u as=0.3078p ps=2u w=1.62u l=0.385u
X436 a_n727_n3302# a_n727_n3024# VDD VDD sg13_lv_pmos ad=0.3078p pd=2u as=0.3078p ps=2u w=1.62u l=0.385u
X437 a_497_n3024# a_497_n3302# VSS VSS sg13_lv_nmos ad=0.1577p pd=1.21u as=0.1577p ps=1.21u w=0.83u l=0.13u
X438 VDD_uq0 a_5699_n9186# a_5699_n8700# VDD_uq0 sg13_lv_pmos ad=0.3078p pd=2u as=0.3078p ps=2u w=1.62u l=0.385u
X439 a_1415_n9186# a_1415_n8700# VSS VSS sg13_lv_nmos ad=0.1577p pd=1.21u as=0.1577p ps=1.21u w=0.83u l=0.13u
X440 VSS ACLK_N a_2061_n4035# VSS sg13_lv_nmos ad=0.13717p pd=1.25u as=0.1683p ps=1.67u w=0.495u l=0.13u
X441 a_4475_n8700# a_4475_n9186# VDD_uq0 VDD_uq0 sg13_lv_pmos ad=0.3078p pd=2u as=0.3078p ps=2u w=1.62u l=0.385u
X442 a_191_n9186# a_191_n8700# VSS VSS sg13_lv_nmos ad=0.1577p pd=1.21u as=0.1577p ps=1.21u w=0.83u l=0.13u
X443 VDD_uq0 a_1415_n9186# a_1415_n8700# VDD_uq0 sg13_lv_pmos ad=0.3078p pd=2u as=0.3078p ps=2u w=1.62u l=0.385u
X444 VDD_uq0 a_2639_n9186# a_2639_n8700# VDD_uq0 sg13_lv_pmos ad=0.3078p pd=2u as=0.3078p ps=2u w=1.62u l=0.385u
X445 VDD_uq0 a_191_n8064# a_191_n8342# VDD_uq0 sg13_lv_pmos ad=0.3078p pd=2u as=0.3078p ps=2u w=1.62u l=0.385u
X446 VDD BIST_ADDR<0> a_1849_n2882# VDD sg13_lv_pmos ad=0.3349p pd=2.65u as=0.18715p ps=1.365u w=0.985u l=0.13u
X447 a_n421_n9186# a_n421_n8700# VSS VSS sg13_lv_nmos ad=0.1577p pd=1.21u as=0.1577p ps=1.21u w=0.83u l=0.13u
X448 a_5699_n8700# a_5699_n9186# VDD_uq0 VDD_uq0 sg13_lv_pmos ad=0.3078p pd=2u as=0.3078p ps=2u w=1.62u l=0.385u
X449 VSS a_191_n8342# a_191_n8064# VSS sg13_lv_nmos ad=0.1577p pd=1.21u as=0.1577p ps=1.21u w=0.83u l=0.13u
X450 VDD a_497_n3024# a_497_n3302# VDD sg13_lv_pmos ad=0.5508p pd=3.92u as=0.3078p ps=2u w=1.62u l=0.385u
X451 VDD_uq0 a_3251_n9186# a_3251_n8700# VDD_uq0 sg13_lv_pmos ad=0.3078p pd=2u as=0.3078p ps=2u w=1.62u l=0.385u
X452 VSS a_n1033_n8700# a_n1033_n9186# VSS sg13_lv_nmos ad=0.1577p pd=1.21u as=0.1577p ps=1.21u w=0.83u l=0.13u
X453 a_2027_n8700# a_2027_n9186# VDD_uq0 VDD_uq0 sg13_lv_pmos ad=0.3078p pd=2u as=0.3078p ps=2u w=1.62u l=0.385u
X454 VSS a_n115_n3660# a_n115_n4146# VSS sg13_lv_nmos ad=0.1577p pd=1.21u as=0.1577p ps=1.21u w=0.83u l=0.13u
X455 VSS a_n1033_n8700# a_n1033_n9186# VSS sg13_lv_nmos ad=0.1577p pd=1.21u as=0.1577p ps=1.21u w=0.83u l=0.13u
X456 VSS a_5087_n8700# a_5087_n9186# VSS sg13_lv_nmos ad=0.1577p pd=1.21u as=0.1577p ps=1.21u w=0.83u l=0.13u
X457 VDD_uq0 a_5087_n8064# a_5087_n8342# VDD_uq0 sg13_lv_pmos ad=0.3078p pd=2u as=0.3078p ps=2u w=1.62u l=0.385u
X458 VSS a_n421_n8700# a_n421_n9186# VSS sg13_lv_nmos ad=0.1577p pd=1.21u as=0.1577p ps=1.21u w=0.83u l=0.13u
X459 a_3863_n8342# a_3863_n8064# VDD_uq0 VDD_uq0 sg13_lv_pmos ad=0.3078p pd=2u as=0.3078p ps=2u w=1.62u l=0.385u
X460 a_2639_n8342# a_2639_n8064# VDD_uq0 VDD_uq0 sg13_lv_pmos ad=0.3078p pd=2u as=0.3078p ps=2u w=1.62u l=0.385u
X461 ADDR_DEC<1> a_6031_n4104# VSS VSS sg13_lv_nmos ad=0.3332p pd=2.64u as=0.3332p ps=2.64u w=0.98u l=0.13u
X462 a_n115_n3024# a_n115_n3302# VSS VSS sg13_lv_nmos ad=0.1577p pd=1.21u as=0.1577p ps=1.21u w=0.83u l=0.13u
X463 VSS a_3251_n8700# a_3251_n9186# VSS sg13_lv_nmos ad=0.1577p pd=1.21u as=0.1577p ps=1.21u w=0.83u l=0.13u
X464 a_803_n8064# a_803_n8342# VSS VSS sg13_lv_nmos ad=0.1577p pd=1.21u as=0.1577p ps=1.21u w=0.83u l=0.13u
X465 a_6485_n8122# a_6447_n8302# VDD_uq0 VDD_uq0 sg13_lv_pmos ad=0.3078p pd=2u as=0.5508p ps=3.92u w=1.62u l=0.385u
X466 VDD_uq0 a_1415_n8064# a_1415_n8342# VDD_uq0 sg13_lv_pmos ad=0.3078p pd=2u as=0.3078p ps=2u w=1.62u l=0.385u
X467 a_3073_n2878# a_2061_n3262# a_2971_n3260# VDD sg13_lv_pmos ad=91.2f pd=0.86u as=0.1511p ps=1.37u w=0.48u l=0.13u
X468 a_n115_n3024# a_n115_n3302# VSS VSS sg13_lv_nmos ad=0.1577p pd=1.21u as=0.1577p ps=1.21u w=0.83u l=0.13u
X469 a_497_n4146# a_497_n3660# VSS VSS sg13_lv_nmos ad=0.1577p pd=1.21u as=0.1577p ps=1.21u w=0.83u l=0.13u
X470 VSS a_3251_n8700# a_3251_n9186# VSS sg13_lv_nmos ad=0.1577p pd=1.21u as=0.1577p ps=1.21u w=0.83u l=0.13u
X471 a_n1033_n8064# a_n1033_n8342# VSS VSS sg13_lv_nmos ad=0.1577p pd=1.21u as=0.1577p ps=1.21u w=0.83u l=0.13u
X472 a_5699_n8064# a_5699_n8342# VSS VSS sg13_lv_nmos ad=0.1577p pd=1.21u as=0.1577p ps=1.21u w=0.83u l=0.13u
X473 a_2869_n3672# a_2537_n4040# VSS VSS sg13_lv_nmos ad=0.1783p pd=1.44u as=0.289p ps=2.38u w=0.85u l=0.13u
X474 a_n727_n4146# a_n727_n3660# VSS VSS sg13_lv_nmos ad=0.1577p pd=1.21u as=0.2822p ps=2.34u w=0.83u l=0.13u
X475 VSS a_1415_n8700# a_1415_n9186# VSS sg13_lv_nmos ad=0.1577p pd=1.21u as=0.1577p ps=1.21u w=0.83u l=0.13u
X476 VSS a_803_n8700# a_803_n9186# VSS sg13_lv_nmos ad=0.1577p pd=1.21u as=0.1577p ps=1.21u w=0.83u l=0.13u
X477 a_n727_n4146# a_n727_n3660# VSS VSS sg13_lv_nmos ad=0.1577p pd=1.21u as=0.1577p ps=1.21u w=0.83u l=0.13u
X478 a_3251_n8064# a_3251_n8342# VSS VSS sg13_lv_nmos ad=0.1577p pd=1.21u as=0.1577p ps=1.21u w=0.83u l=0.13u
X479 VDD a_n727_n4146# a_n727_n3660# VDD sg13_lv_pmos ad=0.3078p pd=2u as=0.3078p ps=2u w=1.62u l=0.385u
X480 VSS a_n727_n3302# a_n727_n3024# VSS sg13_lv_nmos ad=0.1577p pd=1.21u as=0.1577p ps=1.21u w=0.83u l=0.13u
X481 a_5087_n3024# a_5087_n3302# VSS VSS sg13_lv_nmos ad=0.1577p pd=1.21u as=0.1577p ps=1.21u w=0.83u l=0.13u
X482 a_191_n8700# a_191_n9186# VDD_uq0 VDD_uq0 sg13_lv_pmos ad=0.3078p pd=2u as=0.3078p ps=2u w=1.62u l=0.385u
X483 VSS a_n727_n3302# a_n727_n3024# VSS sg13_lv_nmos ad=0.1577p pd=1.21u as=0.1577p ps=1.21u w=0.83u l=0.13u
X484 a_2461_n3942# ACLK_N a_2359_n4035# VDD sg13_lv_pmos ad=91.2f pd=0.86u as=0.14927p ps=1.355u w=0.48u l=0.13u
X485 a_3863_n3024# a_3863_n3302# VSS VSS sg13_lv_nmos ad=0.1577p pd=1.21u as=0.2822p ps=2.34u w=0.83u l=0.13u
X486 a_5087_n3024# a_5087_n3302# VSS VSS sg13_lv_nmos ad=0.1577p pd=1.21u as=0.1577p ps=1.21u w=0.83u l=0.13u
X487 a_1415_n8064# a_1415_n8342# VSS VSS sg13_lv_nmos ad=0.1577p pd=1.21u as=0.1577p ps=1.21u w=0.83u l=0.13u
X488 a_497_n4704# a_497_n4982# VSS VSS sg13_lv_nmos ad=0.1577p pd=1.21u as=0.1577p ps=1.21u w=0.83u l=0.13u
X489 a_4781_n4140# a_4781_n4140# VDD VDD sg13_lv_pmos ad=0.1632p pd=1.64u as=0.1632p ps=1.64u w=0.48u l=0.13u
X490 a_191_n8064# a_191_n8342# VSS VSS sg13_lv_nmos ad=0.1577p pd=1.21u as=0.1577p ps=1.21u w=0.83u l=0.13u
X491 VDD a_497_n3024# a_497_n3302# VDD sg13_lv_pmos ad=0.3078p pd=2u as=0.3078p ps=2u w=1.62u l=0.385u
X492 a_5050_n3764# a_2971_n3260# VSS VSS sg13_lv_nmos ad=0.3332p pd=2.64u as=0.3332p ps=2.64u w=0.98u l=0.13u
X493 VDD a_n115_n3024# a_n115_n3302# VDD sg13_lv_pmos ad=0.3078p pd=2u as=0.3078p ps=2u w=1.62u l=0.385u
X494 a_4343_n3704# a_4305_n3624# VDD VDD sg13_lv_pmos ad=0.3078p pd=2u as=0.5508p ps=3.92u w=1.62u l=0.385u
X495 VSS a_5699_n3302# a_5699_n3024# VSS sg13_lv_nmos ad=0.1577p pd=1.21u as=0.1577p ps=1.21u w=0.83u l=0.13u
X496 a_n421_n8064# a_n421_n8342# VSS VSS sg13_lv_nmos ad=0.1577p pd=1.21u as=0.1577p ps=1.21u w=0.83u l=0.13u
X497 a_803_n8700# a_803_n9186# VDD_uq0 VDD_uq0 sg13_lv_pmos ad=0.3078p pd=2u as=0.3078p ps=2u w=1.62u l=0.385u
X498 VDD_uq0 a_5087_n8064# a_5087_n8342# VDD_uq0 sg13_lv_pmos ad=0.3078p pd=2u as=0.3078p ps=2u w=1.62u l=0.385u
X499 VSS a_497_n4982# a_497_n4704# VSS sg13_lv_nmos ad=0.1577p pd=1.21u as=0.1577p ps=1.21u w=0.83u l=0.13u
X500 ADDR_DEC<1> a_6031_n4104# VDD VDD sg13_lv_pmos ad=0.5508p pd=3.92u as=0.5508p ps=3.92u w=1.62u l=0.13u
X501 VDD a_n727_n3024# a_n727_n3302# VDD sg13_lv_pmos ad=0.3078p pd=2u as=0.3078p ps=2u w=1.62u l=0.385u
X502 VSS a_n1033_n8342# a_n1033_n8064# VSS sg13_lv_nmos ad=0.1577p pd=1.21u as=0.1577p ps=1.21u w=0.83u l=0.13u
.ends

.subckt RM_IHPSG13_1P_CTRL PULSE_L PULSE_H BIST_CS_I BIST_CK_I WCLK WE_I ECLK CS_I
+ CK_I BIST_RE_I RE_I BIST_WE_I B_TIEL_O m2_3014_n7620# m2_n46_n7620# ACLK_N m2_1994_n7620#
+ m2_6074_n7620# m2_n964_n7620# m2_n862_n7620# m2_4748_n7620# DCLK m2_4646_n7620#
+ m2_2096_n7620# ROW_CS m2_n556_n7620# m2_n454_n7620# m2_3932_n7620# m2_3830_n7620#
+ m2_4340_n7620# m2_n352_n7620# m2_3728_n7620# m2_4238_n7620# m2_5462_n6848# RCLK
+ m2_n250_n7620# m2_5360_n6950# m2_n148_n7620# m2_3626_n7620# m2_4136_n7620# m2_158_n7620#
+ BIST_EN m2_3524_n7620# m2_4034_n7620# m2_3422_n7620# m2_2912_n7620# m2_56_n7620#
+ PULSE_O VDD m3_1569_n5481# VSS
X0 a_n523_n6660# a_n319_n6660# VDD VDD sg13_lv_pmos ad=0.2413p pd=1.65u as=0.28155p ps=2u w=1.27u l=0.13u
X1 a_5419_n6569# PULSE_H a_5317_n6569# VSS sg13_lv_nmos ad=0.10545p pd=0.935u as=0.10545p ps=0.935u w=0.555u l=0.13u
X2 VSS a_5929_n6622# a_6133_n6622# VSS sg13_lv_nmos ad=0.2397p pd=2.09u as=0.13395p ps=1.085u w=0.705u l=0.13u
X3 ROW_CS a_n829_n7500# VSS VSS sg13_lv_nmos ad=0.13395p pd=1.085u as=0.2397p ps=2.09u w=0.705u l=0.13u
X4 a_3685_n7032# a_3353_n7400# VSS VSS sg13_lv_nmos ad=0.1783p pd=1.44u as=0.289p ps=2.38u w=0.85u l=0.13u
X5 a_5929_n6622# a_5725_n6613# VDD VDD sg13_lv_pmos ad=0.5508p pd=3.92u as=0.5508p ps=3.92u w=1.62u l=0.13u
X6 a_905_n5820# a_2461_n7395# VSS VSS sg13_lv_nmos ad=0.2397p pd=2.09u as=0.12308p ps=1.085u w=0.705u l=0.13u
X7 a_2359_n6990# WE_I VSS VSS sg13_lv_nmos ad=0.1064p pd=0.94u as=0.1064p ps=0.94u w=0.56u l=0.13u
X8 a_2461_n6562# BIST_EN a_2359_n6242# VDD sg13_lv_pmos ad=0.18715p pd=1.365u as=0.18715p ps=1.365u w=0.985u l=0.13u
X9 PULSE_O a_13_n5718# VDD VDD sg13_lv_pmos ad=0.5508p pd=3.92u as=0.5508p ps=3.92u w=1.62u l=0.13u
X10 a_5317_n7464# a_5019_n6918# VSS VSS sg13_lv_nmos ad=0.3332p pd=2.64u as=0.1502p ps=1.36u w=0.98u l=0.13u
X11 RCLK a_4501_n6300# VSS VSS sg13_lv_nmos ad=0.13395p pd=1.085u as=0.2397p ps=2.09u w=0.705u l=0.13u
X12 a_259_n7466# a_727_n6622# VDD VDD sg13_lv_pmos ad=0.1632p pd=1.64u as=0.14812p ps=1.355u w=0.48u l=0.13u
X13 a_701_n5820# a_803_n5820# VDD VDD sg13_lv_pmos ad=0.25417p pd=2u as=0.17195p ps=1.285u w=0.905u l=0.13u
X14 VDD a_n523_n6660# a_n1033_n6660# VDD sg13_lv_pmos ad=0.28155p pd=2u as=0.3078p ps=2u w=1.62u l=0.13u
X15 VSS a_n829_n7500# ROW_CS VSS sg13_lv_nmos ad=0.13395p pd=1.085u as=0.13395p ps=1.085u w=0.705u l=0.13u
X16 VSS BIST_RE_I a_2563_n6562# VSS sg13_lv_nmos ad=0.12308p pd=1.085u as=0.1064p ps=0.94u w=0.56u l=0.13u
X17 a_421_n6990# a_259_n7466# a_n115_n7500# VSS sg13_lv_nmos ad=0.1783p pd=1.44u as=0.13375p ps=1.23u w=0.85u l=0.13u
X18 VSS a_696_n7125# a_497_n7434# VSS sg13_lv_nmos ad=91.2f pd=0.86u as=0.1632p ps=1.64u w=0.48u l=0.13u
X19 a_5623_n6992# a_5317_n7464# VSS VSS sg13_lv_nmos ad=0.1653p pd=1.25u as=0.13755p ps=1.25u w=0.87u l=0.13u
X20 VDD a_3353_n7400# a_3277_n7302# VDD sg13_lv_pmos ad=91.2f pd=0.86u as=91.2f ps=0.86u w=0.48u l=0.13u
X21 a_115_n5310# ACLK_N a_13_n5718# VSS sg13_lv_nmos ad=91.2f pd=0.86u as=0.13375p ps=1.23u w=0.48u l=0.13u
X22 a_701_n5820# a_905_n5820# a_829_n5334# VSS sg13_lv_nmos ad=0.1862p pd=1.36u as=0.1862p ps=1.36u w=0.98u l=0.13u
X23 WCLK a_4501_n7464# VDD VDD sg13_lv_pmos ad=0.3078p pd=2u as=0.5508p ps=3.92u w=1.62u l=0.13u
X24 a_191_n5717# a_13_n5718# VSS VSS sg13_lv_nmos ad=0.1632p pd=1.64u as=91.2f ps=0.86u w=0.48u l=0.13u
X25 a_3175_n7395# a_727_n6622# a_3073_n6992# VSS sg13_lv_nmos ad=0.13605p pd=1.25u as=0.1653p ps=1.25u w=0.87u l=0.13u
X26 a_n599_n5715# ACLK_N a_n701_n5312# VSS sg13_lv_nmos ad=0.13605p pd=1.25u as=0.1653p ps=1.25u w=0.87u l=0.13u
X27 VDD a_1007_n6660# a_n319_n6660# VDD sg13_lv_pmos ad=0.2763p pd=2u as=0.5508p ps=3.92u w=1.62u l=0.13u
X28 a_5725_n6613# a_5317_n6569# VSS VSS sg13_lv_nmos ad=0.2635p pd=2.23u as=0.32617p ps=1.665u w=0.775u l=0.13u
X29 VSS a_3965_n7397# a_3889_n6990# VSS sg13_lv_nmos ad=91.2f pd=0.86u as=91.2f ps=0.86u w=0.48u l=0.13u
X30 a_905_n5820# a_2461_n7395# VDD VDD sg13_lv_pmos ad=0.5508p pd=3.92u as=0.26017p ps=2u w=1.62u l=0.13u
X31 VSS a_395_n6660# a_319_n6622# VSS sg13_lv_nmos ad=0.13755p pd=1.25u as=0.1653p ps=1.25u w=0.87u l=0.13u
X32 VSS a_803_n5820# a_1033_n6992# VSS sg13_lv_nmos ad=0.13717p pd=1.25u as=0.1653p ps=1.25u w=0.87u l=0.13u
X33 VSS ACLK_N a_n897_n5715# VSS sg13_lv_nmos ad=0.13717p pd=1.25u as=0.1683p ps=1.67u w=0.495u l=0.13u
X34 VDD a_6133_n6622# ECLK VDD sg13_lv_pmos ad=0.5508p pd=3.92u as=0.3078p ps=2u w=1.62u l=0.13u
X35 a_1584_n7469# BIST_EN VSS VSS sg13_lv_nmos ad=0.1904p pd=1.8u as=0.1064p ps=0.94u w=0.56u l=0.13u
X36 a_1543_n6990# BIST_CS_I VSS VSS sg13_lv_nmos ad=0.1064p pd=0.94u as=0.12308p ps=1.085u w=0.56u l=0.13u
X37 VSS a_701_n5820# a_395_n6660# VSS sg13_lv_nmos ad=0.1502p pd=1.36u as=0.17p ps=1.68u w=0.5u l=0.13u
X38 a_727_n6622# a_n319_n6660# VSS VSS sg13_lv_nmos ad=0.13395p pd=1.085u as=0.2397p ps=2.09u w=0.705u l=0.13u
X39 a_2359_n6562# RE_I VSS VSS sg13_lv_nmos ad=0.1064p pd=0.94u as=0.1064p ps=0.94u w=0.56u l=0.13u
X40 VSS a_n1033_n6660# ACLK_N VSS sg13_lv_nmos ad=0.2397p pd=2.09u as=0.13395p ps=1.085u w=0.705u l=0.13u
X41 a_1415_n6660# a_1584_n6031# a_1543_n6242# VDD sg13_lv_pmos ad=0.18715p pd=1.365u as=0.18715p ps=1.365u w=0.985u l=0.13u
X42 a_3685_n6240# a_3353_n6580# VDD VDD sg13_lv_pmos ad=0.1881p pd=1.37u as=0.3366p ps=2.66u w=0.99u l=0.13u
X43 a_4501_n7014# a_4297_n7464# VSS VSS sg13_lv_nmos ad=0.1862p pd=1.36u as=0.3332p ps=2.64u w=0.98u l=0.13u
X44 a_n293_n6622# a_n319_n6660# VSS VSS sg13_lv_nmos ad=0.1862p pd=1.36u as=0.16557p ps=1.36u w=0.98u l=0.13u
X45 VDD a_3965_n6660# a_3889_n6238# VDD sg13_lv_pmos ad=91.2f pd=0.86u as=91.2f ps=0.86u w=0.48u l=0.13u
X46 a_2461_n7395# BIST_EN a_2359_n7395# VDD sg13_lv_pmos ad=0.18715p pd=1.365u as=0.18715p ps=1.365u w=0.985u l=0.13u
X47 a_3277_n6992# a_2877_n7395# a_3175_n7395# VSS sg13_lv_nmos ad=91.2f pd=0.86u as=0.13605p ps=1.25u w=0.48u l=0.13u
X48 a_n13_n6660# a_137_n6072# a_115_n6240# VDD sg13_lv_pmos ad=0.14812p pd=1.355u as=91.2f ps=0.86u w=0.48u l=0.13u
X49 VDD a_4501_n6300# RCLK VDD sg13_lv_pmos ad=0.5508p pd=3.92u as=0.3078p ps=2u w=1.62u l=0.13u
X50 a_5929_n6622# a_5725_n6613# VSS VSS sg13_lv_nmos ad=0.2397p pd=2.09u as=0.2397p ps=2.09u w=0.705u l=0.13u
X51 VDD a_n13_n6660# a_n217_n6660# VDD sg13_lv_pmos ad=91.2f pd=0.86u as=0.1632p ps=1.64u w=0.48u l=0.13u
X52 VDD a_3353_n6580# a_3277_n6234# VDD sg13_lv_pmos ad=91.2f pd=0.86u as=91.2f ps=0.86u w=0.48u l=0.13u
X53 a_3175_n6622# a_727_n6622# a_3073_n6622# VSS sg13_lv_nmos ad=0.13605p pd=1.25u as=0.1653p ps=1.25u w=0.87u l=0.13u
X54 a_4501_n6300# a_4297_n6622# VDD VDD sg13_lv_pmos ad=0.3078p pd=2u as=0.5508p ps=3.92u w=1.62u l=0.13u
X55 a_1149_n6622# a_5458_n7124# VSS VSS sg13_lv_nmos ad=38.4f pd=0.56u as=0.10507p ps=1.085u w=0.32u l=0.2u
X56 ECLK a_6133_n6622# VDD VDD sg13_lv_pmos ad=0.3078p pd=2u as=0.5508p ps=3.92u w=1.62u l=0.13u
X57 a_1747_n6242# BIST_EN a_1415_n6660# VDD sg13_lv_pmos ad=0.18715p pd=1.365u as=0.18715p ps=1.365u w=0.985u l=0.13u
X58 VSS a_6141_n7014# DCLK VSS sg13_lv_nmos ad=0.2397p pd=2.09u as=0.13395p ps=1.085u w=0.705u l=0.13u
X59 a_115_n5618# a_n897_n5715# a_13_n5718# VDD sg13_lv_pmos ad=91.2f pd=0.86u as=0.1511p ps=1.37u w=0.48u l=0.13u
X60 a_3787_n6620# a_727_n6622# a_3685_n6240# VDD sg13_lv_pmos ad=0.1511p pd=1.37u as=0.1881p ps=1.37u w=0.99u l=0.13u
X61 VSS a_3965_n6660# a_3889_n6546# VSS sg13_lv_nmos ad=91.2f pd=0.86u as=91.2f ps=0.86u w=0.48u l=0.13u
X62 VDD a_n829_n7500# ROW_CS VDD sg13_lv_pmos ad=0.3078p pd=2u as=0.3078p ps=2u w=1.62u l=0.13u
X63 a_n421_n5720# a_n599_n5715# VDD VDD sg13_lv_pmos ad=0.1632p pd=1.64u as=91.2f ps=0.86u w=0.48u l=0.13u
X64 a_191_n5717# a_13_n5718# VDD VDD sg13_lv_pmos ad=0.1632p pd=1.64u as=91.2f ps=0.86u w=0.48u l=0.13u
X65 a_829_n5334# a_2767_n6591# a_701_n5820# VSS sg13_lv_nmos ad=0.3332p pd=2.64u as=0.1862p ps=1.36u w=0.98u l=0.13u
X66 VSS a_n523_n6660# a_n1033_n6660# VSS sg13_lv_nmos ad=0.16557p pd=1.36u as=0.13395p ps=1.085u w=0.705u l=0.13u
X67 VDD a_n421_n7500# a_n829_n7500# VDD sg13_lv_pmos ad=0.5508p pd=3.92u as=0.3078p ps=2u w=1.62u l=0.13u
X68 VDD a_803_n5820# a_5019_n6918# VDD sg13_lv_pmos ad=0.2508p pd=2u as=0.1634p ps=1.24u w=0.86u l=0.13u
X69 a_n701_n5715# a_n1007_n5784# VDD VDD sg13_lv_pmos ad=0.18525p pd=1.355u as=0.14812p ps=1.355u w=0.975u l=0.13u
X70 a_5725_n6613# a_5317_n6569# VDD VDD sg13_lv_pmos ad=0.5219p pd=3.75u as=0.5668p ps=2.425u w=1.535u l=0.13u
X71 a_3353_n6580# a_3175_n6622# VSS VSS sg13_lv_nmos ad=0.1632p pd=1.64u as=91.2f ps=0.86u w=0.48u l=0.13u
X72 VSS a_5873_n7154# a_5827_n6914# VSS sg13_lv_nmos ad=91.2f pd=0.86u as=91.2f ps=0.86u w=0.48u l=0.13u
X73 VDD a_497_n7434# a_421_n7398# VDD sg13_lv_pmos ad=0.3366p pd=2.66u as=0.1881p ps=1.37u w=0.99u l=0.13u
X74 a_5419_n6569# a_5019_n6569# a_5317_n6569# VDD sg13_lv_pmos ad=0.15675p pd=1.205u as=0.15675p ps=1.205u w=0.825u l=0.13u
X75 a_5725_n7395# a_5458_n7124# a_5623_n7395# VDD sg13_lv_pmos ad=0.14812p pd=1.355u as=0.18525p ps=1.355u w=0.975u l=0.13u
X76 a_1584_n6031# BIST_EN VSS VSS sg13_lv_nmos ad=0.1904p pd=1.8u as=0.1064p ps=0.94u w=0.56u l=0.13u
X77 VSS a_5458_n7124# a_5427_n7395# VSS sg13_lv_nmos ad=0.13755p pd=1.25u as=0.17p ps=1.68u w=0.5u l=0.13u
X78 a_1543_n6562# BIST_CK_I VSS VSS sg13_lv_nmos ad=0.1064p pd=0.94u as=0.12308p ps=1.085u w=0.56u l=0.13u
X79 a_5113_n6918# a_905_n5820# a_5019_n6918# VSS sg13_lv_nmos ad=95f pd=0.88u as=0.17p ps=1.68u w=0.5u l=0.13u
X80 VDD a_3965_n7397# a_3889_n7298# VDD sg13_lv_pmos ad=91.2f pd=0.86u as=91.2f ps=0.86u w=0.48u l=0.13u
X81 VDD a_n421_n5720# a_n497_n5622# VDD sg13_lv_pmos ad=91.2f pd=0.86u as=91.2f ps=0.86u w=0.48u l=0.13u
X82 VDD a_n319_n6660# a_727_n6622# VDD sg13_lv_pmos ad=0.5508p pd=3.92u as=0.3078p ps=2u w=1.62u l=0.13u
X83 a_n829_n7500# a_n421_n7500# VDD VDD sg13_lv_pmos ad=0.3078p pd=2u as=0.3078p ps=2u w=1.62u l=0.13u
X84 a_5317_n7464# a_5019_n6918# VDD VDD sg13_lv_pmos ad=0.5508p pd=3.92u as=0.2508p ps=2u w=1.62u l=0.13u
X85 a_1415_n7500# a_1584_n7469# a_1543_n7395# VDD sg13_lv_pmos ad=0.18715p pd=1.365u as=0.18715p ps=1.365u w=0.985u l=0.13u
X86 ACLK_N a_n1033_n6660# VDD VDD sg13_lv_pmos ad=0.3078p pd=2u as=0.3078p ps=2u w=1.62u l=0.13u
X87 VDD a_727_n6622# a_2877_n6622# VDD sg13_lv_pmos ad=0.14812p pd=1.355u as=0.1632p ps=1.64u w=0.48u l=0.13u
X88 a_3685_n6578# a_3353_n6580# VSS VSS sg13_lv_nmos ad=0.1783p pd=1.44u as=0.289p ps=2.38u w=0.85u l=0.13u
X89 a_3685_n7398# a_3353_n7400# VDD VDD sg13_lv_pmos ad=0.1881p pd=1.37u as=0.3366p ps=2.66u w=0.99u l=0.13u
X90 VSS a_5215_n6569# a_5419_n6569# VSS sg13_lv_nmos ad=0.32617p pd=1.665u as=0.10545p ps=0.935u w=0.555u l=0.13u
X91 VSS a_6133_n6622# ECLK VSS sg13_lv_nmos ad=0.2397p pd=2.09u as=0.13395p ps=1.085u w=0.705u l=0.13u
X92 a_5827_n7296# a_5427_n7395# a_5725_n7395# VDD sg13_lv_pmos ad=91.2f pd=0.86u as=0.14812p ps=1.355u w=0.48u l=0.13u
X93 a_696_n7125# a_727_n6622# a_829_n7302# VDD sg13_lv_pmos ad=0.14927p pd=1.355u as=91.2f ps=0.86u w=0.48u l=0.13u
X94 VSS PULSE_H a_5019_n6569# VSS sg13_lv_nmos ad=0.10282p pd=0.935u as=0.1632p ps=1.64u w=0.48u l=0.13u
X95 a_3965_n7397# a_3787_n7398# VSS VSS sg13_lv_nmos ad=0.1632p pd=1.64u as=91.2f ps=0.86u w=0.48u l=0.13u
X96 a_2461_n7395# a_2163_n7395# a_2359_n6990# VSS sg13_lv_nmos ad=0.1064p pd=0.94u as=0.1064p ps=0.94u w=0.56u l=0.13u
X97 a_2563_n6242# a_2163_n6562# a_2461_n6562# VDD sg13_lv_pmos ad=0.18715p pd=1.365u as=0.18715p ps=1.365u w=0.985u l=0.13u
X98 VSS a_n115_n7500# a_n421_n7500# VSS sg13_lv_nmos ad=0.3332p pd=2.64u as=0.3332p ps=2.64u w=0.98u l=0.13u
X99 a_259_n7466# a_727_n6622# VSS VSS sg13_lv_nmos ad=0.1683p pd=1.67u as=0.13717p ps=1.25u w=0.495u l=0.13u
X100 VSS a_4501_n6300# RCLK VSS sg13_lv_nmos ad=0.2397p pd=2.09u as=0.13395p ps=1.085u w=0.705u l=0.13u
X101 a_3787_n7398# a_727_n6622# a_3685_n7398# VDD sg13_lv_pmos ad=0.1511p pd=1.37u as=0.1881p ps=1.37u w=0.99u l=0.13u
X102 a_1747_n7395# BIST_EN a_1415_n7500# VDD sg13_lv_pmos ad=0.18715p pd=1.365u as=0.18715p ps=1.365u w=0.985u l=0.13u
X103 a_931_n5784# a_905_n5820# a_701_n5820# VDD sg13_lv_pmos ad=0.3078p pd=2u as=0.25417p ps=2u w=1.62u l=0.13u
X104 VDD a_n1033_n6660# ACLK_N VDD sg13_lv_pmos ad=0.3078p pd=2u as=0.3078p ps=2u w=1.62u l=0.13u
X105 a_3965_n6660# a_3787_n6620# VDD VDD sg13_lv_pmos ad=0.1632p pd=1.64u as=91.2f ps=0.86u w=0.48u l=0.13u
X106 a_4501_n6622# a_4297_n6622# VSS VSS sg13_lv_nmos ad=0.1862p pd=1.36u as=0.3332p ps=2.64u w=0.98u l=0.13u
X107 a_n1033_n6660# a_n523_n6660# VDD VDD sg13_lv_pmos ad=0.3078p pd=2u as=0.5508p ps=3.92u w=1.62u l=0.13u
X108 ECLK a_6133_n6622# VSS VSS sg13_lv_nmos ad=0.13395p pd=1.085u as=0.2397p ps=2.09u w=0.705u l=0.13u
X109 ROW_CS a_n829_n7500# VSS VSS sg13_lv_nmos ad=0.13395p pd=1.085u as=0.13395p ps=1.085u w=0.705u l=0.13u
X110 a_829_n6992# a_497_n7434# VSS VSS sg13_lv_nmos ad=91.2f pd=0.86u as=91.2f ps=0.86u w=0.48u l=0.13u
X111 a_5725_n7395# a_5427_n7395# a_5623_n6992# VSS sg13_lv_nmos ad=0.13605p pd=1.25u as=0.1653p ps=1.25u w=0.87u l=0.13u
X112 a_3353_n7400# a_3175_n7395# VDD VDD sg13_lv_pmos ad=0.1632p pd=1.64u as=91.2f ps=0.86u w=0.48u l=0.13u
X113 a_n1007_n5784# PULSE_O VDD VDD sg13_lv_pmos ad=0.5508p pd=3.92u as=0.5508p ps=3.92u w=1.62u l=0.13u
X114 a_137_n6072# a_n319_n6660# VDD VDD sg13_lv_pmos ad=0.17p pd=1.68u as=0.14962p ps=1.355u w=0.5u l=0.13u
X115 VDD a_4501_n7464# WCLK VDD sg13_lv_pmos ad=0.5508p pd=3.92u as=0.3078p ps=2u w=1.62u l=0.13u
X116 a_n701_n5312# a_n1007_n5784# VSS VSS sg13_lv_nmos ad=0.1653p pd=1.25u as=0.13717p ps=1.25u w=0.87u l=0.13u
X117 a_3965_n6660# a_3787_n6620# VSS VSS sg13_lv_nmos ad=0.1632p pd=1.64u as=91.2f ps=0.86u w=0.48u l=0.13u
X118 a_4501_n7464# a_4297_n7464# VDD VDD sg13_lv_pmos ad=0.3078p pd=2u as=0.5508p ps=3.92u w=1.62u l=0.13u
X119 DCLK a_6141_n7014# VDD VDD sg13_lv_pmos ad=0.3078p pd=2u as=0.28155p ps=2u w=1.62u l=0.13u
X120 a_n421_n5720# a_n599_n5715# VSS VSS sg13_lv_nmos ad=0.1632p pd=1.64u as=91.2f ps=0.86u w=0.48u l=0.13u
X121 a_137_n6072# a_n319_n6660# VSS VSS sg13_lv_nmos ad=0.17p pd=1.68u as=0.13755p ps=1.25u w=0.5u l=0.13u
X122 a_5873_n7154# a_5725_n7395# VSS VSS sg13_lv_nmos ad=0.1632p pd=1.64u as=91.2f ps=0.86u w=0.48u l=0.13u
X123 a_6141_n7014# a_5873_n7154# VDD VDD sg13_lv_pmos ad=0.2413p pd=1.65u as=0.4318p ps=3.22u w=1.27u l=0.13u
X124 a_2461_n6562# a_2163_n6562# a_2359_n6562# VSS sg13_lv_nmos ad=0.1064p pd=0.94u as=0.1064p ps=0.94u w=0.56u l=0.13u
X125 a_217_n6990# a_21_n7466# VSS VSS sg13_lv_nmos ad=91.2f pd=0.86u as=91.2f ps=0.86u w=0.48u l=0.13u
X126 a_1415_n7500# BIST_EN a_1543_n6990# VSS sg13_lv_nmos ad=0.1064p pd=0.94u as=0.1064p ps=0.94u w=0.56u l=0.13u
X127 VSS a_n319_n6660# a_727_n6622# VSS sg13_lv_nmos ad=0.2397p pd=2.09u as=0.13395p ps=1.085u w=0.705u l=0.13u
X128 ACLK_N a_n1033_n6660# VSS VSS sg13_lv_nmos ad=0.13395p pd=1.085u as=0.13395p ps=1.085u w=0.705u l=0.13u
X129 a_1149_n6217# a_5458_n7124# VDD VDD sg13_lv_pmos ad=0.144p pd=1.44u as=0.2763p ps=2u w=1.2u l=0.2u
X130 VDD BIST_EN a_2163_n6562# VDD sg13_lv_pmos ad=0.16165p pd=1.365u as=0.2193p ps=1.97u w=0.645u l=0.13u
X131 a_4501_n7464# a_5725_n6613# a_4501_n7014# VSS sg13_lv_nmos ad=0.3332p pd=2.64u as=0.1862p ps=1.36u w=0.98u l=0.13u
X132 VDD a_727_n6622# a_2877_n7395# VDD sg13_lv_pmos ad=0.14812p pd=1.355u as=0.1632p ps=1.64u w=0.48u l=0.13u
X133 a_2563_n7395# a_2163_n7395# a_2461_n7395# VDD sg13_lv_pmos ad=0.18715p pd=1.365u as=0.18715p ps=1.365u w=0.985u l=0.13u
X134 VDD a_2767_n6591# a_931_n5784# VDD sg13_lv_pmos ad=0.5508p pd=3.92u as=0.3078p ps=2u w=1.62u l=0.13u
X135 a_115_n6240# a_n217_n6660# VDD VDD sg13_lv_pmos ad=91.2f pd=0.86u as=91.2f ps=0.86u w=0.48u l=0.13u
X136 a_3965_n7397# a_3787_n7398# VDD VDD sg13_lv_pmos ad=0.1632p pd=1.64u as=91.2f ps=0.86u w=0.48u l=0.13u
X137 VSS a_3353_n7400# a_3277_n6992# VSS sg13_lv_nmos ad=91.2f pd=0.86u as=91.2f ps=0.86u w=0.48u l=0.13u
X138 VSS a_n421_n5720# a_n497_n5312# VSS sg13_lv_nmos ad=91.2f pd=0.86u as=91.2f ps=0.86u w=0.48u l=0.13u
X139 a_319_n6240# a_n319_n6660# a_n13_n6660# VDD sg13_lv_pmos ad=0.18525p pd=1.355u as=0.14812p ps=1.355u w=0.975u l=0.13u
X140 a_3353_n6580# a_3175_n6622# VDD VDD sg13_lv_pmos ad=0.1632p pd=1.64u as=91.2f ps=0.86u w=0.48u l=0.13u
X141 VDD a_5725_n6613# a_4501_n6300# VDD sg13_lv_pmos ad=0.5508p pd=3.92u as=0.3078p ps=2u w=1.62u l=0.13u
X142 a_3787_n7398# a_2877_n7395# a_3685_n7032# VSS sg13_lv_nmos ad=0.13375p pd=1.23u as=0.1783p ps=1.44u w=0.85u l=0.13u
X143 a_n13_n6660# a_n319_n6660# a_115_n6622# VSS sg13_lv_nmos ad=0.13605p pd=1.25u as=91.2f ps=0.86u w=0.48u l=0.13u
X144 VDD a_6133_n6622# ECLK VDD sg13_lv_pmos ad=0.3078p pd=2u as=0.3078p ps=2u w=1.62u l=0.13u
X145 VDD a_5458_n7124# a_6141_n7014# VDD sg13_lv_pmos ad=0.28155p pd=2u as=0.2413p ps=1.65u w=1.27u l=0.13u
X146 VSS a_n13_n6660# a_n217_n6660# VSS sg13_lv_nmos ad=91.2f pd=0.86u as=0.1632p ps=1.64u w=0.48u l=0.13u
X147 a_6133_n6622# a_5929_n6622# VDD VDD sg13_lv_pmos ad=0.3078p pd=2u as=0.5508p ps=3.92u w=1.62u l=0.13u
X148 a_1747_n6990# a_1584_n7469# a_1415_n7500# VSS sg13_lv_nmos ad=0.1064p pd=0.94u as=0.1064p ps=0.94u w=0.56u l=0.13u
X149 VDD CK_I a_1747_n6242# VDD sg13_lv_pmos ad=0.16165p pd=1.365u as=0.18715p ps=1.365u w=0.985u l=0.13u
X150 VSS a_n1033_n6660# ACLK_N VSS sg13_lv_nmos ad=0.13395p pd=1.085u as=0.13395p ps=1.085u w=0.705u l=0.13u
X151 ROW_CS a_n829_n7500# VDD VDD sg13_lv_pmos ad=0.3078p pd=2u as=0.5508p ps=3.92u w=1.62u l=0.13u
X152 a_n1033_n6660# a_n523_n6660# VSS VSS sg13_lv_nmos ad=0.13395p pd=1.085u as=0.2397p ps=2.09u w=0.705u l=0.13u
X153 a_4297_n7464# a_3787_n7398# VSS VSS sg13_lv_nmos ad=0.3332p pd=2.64u as=0.3332p ps=2.64u w=0.98u l=0.13u
X154 VDD BIST_EN a_2163_n7395# VDD sg13_lv_pmos ad=0.16165p pd=1.365u as=0.2193p ps=1.97u w=0.645u l=0.13u
X155 VDD ACLK_N a_n897_n5715# VDD sg13_lv_pmos ad=0.14812p pd=1.355u as=0.1632p ps=1.64u w=0.48u l=0.13u
X156 a_3073_n6240# a_2767_n6591# VDD VDD sg13_lv_pmos ad=0.18525p pd=1.355u as=0.14812p ps=1.355u w=0.975u l=0.13u
X157 a_4297_n6622# a_3787_n6620# VDD VDD sg13_lv_pmos ad=0.5508p pd=3.92u as=0.5508p ps=3.92u w=1.62u l=0.13u
X158 a_3787_n6620# a_2877_n6622# a_3685_n6578# VSS sg13_lv_nmos ad=0.13375p pd=1.23u as=0.1783p ps=1.44u w=0.85u l=0.13u
X159 VDD a_5215_n6569# a_5419_n6569# VDD sg13_lv_pmos ad=0.5668p pd=2.425u as=0.15675p ps=1.205u w=0.825u l=0.13u
X160 WCLK a_4501_n7464# VSS VSS sg13_lv_nmos ad=0.13395p pd=1.085u as=0.2397p ps=2.09u w=0.705u l=0.13u
X161 a_n89_n5352# a_n421_n5720# VSS VSS sg13_lv_nmos ad=0.1783p pd=1.44u as=0.289p ps=2.38u w=0.85u l=0.13u
X162 a_1415_n6660# BIST_EN a_1543_n6562# VSS sg13_lv_nmos ad=0.1064p pd=0.94u as=0.1064p ps=0.94u w=0.56u l=0.13u
X163 VSS a_803_n5820# a_5113_n6918# VSS sg13_lv_nmos ad=0.1502p pd=1.36u as=95f ps=0.88u w=0.5u l=0.13u
X164 VDD a_n829_n7500# ROW_CS VDD sg13_lv_pmos ad=0.3078p pd=2u as=0.3078p ps=2u w=1.62u l=0.13u
X165 a_n497_n5622# ACLK_N a_n599_n5715# VDD sg13_lv_pmos ad=91.2f pd=0.86u as=0.14927p ps=1.355u w=0.48u l=0.13u
X166 VDD a_n115_n7500# a_n421_n7500# VDD sg13_lv_pmos ad=0.5508p pd=3.92u as=0.5508p ps=3.92u w=1.62u l=0.13u
X167 a_13_n5718# ACLK_N a_n89_n5718# VDD sg13_lv_pmos ad=0.1511p pd=1.37u as=0.1881p ps=1.37u w=0.99u l=0.13u
X168 a_1007_n6660# a_5458_n7124# a_1149_n6622# VSS sg13_lv_nmos ad=0.1088p pd=1.32u as=38.4f ps=0.56u w=0.32u l=0.2u
X169 a_3277_n6544# a_2877_n6622# a_3175_n6622# VSS sg13_lv_nmos ad=91.2f pd=0.86u as=0.13605p ps=1.25u w=0.48u l=0.13u
X170 VDD a_5873_n7154# a_5827_n7296# VDD sg13_lv_pmos ad=91.2f pd=0.86u as=91.2f ps=0.86u w=0.48u l=0.13u
X171 a_5215_n6569# PULSE_L VSS VSS sg13_lv_nmos ad=0.10545p pd=0.935u as=0.10282p ps=0.935u w=0.555u l=0.13u
X172 a_217_n7298# a_21_n7466# VDD VDD sg13_lv_pmos ad=91.2f pd=0.86u as=91.2f ps=0.86u w=0.48u l=0.13u
X173 a_2563_n6990# BIST_EN a_2461_n7395# VSS sg13_lv_nmos ad=0.1064p pd=0.94u as=0.1064p ps=0.94u w=0.56u l=0.13u
X174 a_n89_n5718# a_n421_n5720# VDD VDD sg13_lv_pmos ad=0.1881p pd=1.37u as=0.3366p ps=2.66u w=0.99u l=0.13u
X175 VDD BIST_RE_I a_2563_n6242# VDD sg13_lv_pmos ad=0.26017p pd=2u as=0.18715p ps=1.365u w=0.985u l=0.13u
X176 VDD a_5458_n7124# a_5427_n7395# VDD sg13_lv_pmos ad=0.14962p pd=1.355u as=0.17p ps=1.68u w=0.5u l=0.13u
X177 ACLK_N a_n1033_n6660# VDD VDD sg13_lv_pmos ad=0.3078p pd=2u as=0.5508p ps=3.92u w=1.62u l=0.13u
X178 a_1747_n6562# a_1584_n6031# a_1415_n6660# VSS sg13_lv_nmos ad=0.1064p pd=0.94u as=0.1064p ps=0.94u w=0.56u l=0.13u
X179 a_3073_n7395# a_905_n5820# VDD VDD sg13_lv_pmos ad=0.18525p pd=1.355u as=0.14812p ps=1.355u w=0.975u l=0.13u
X180 VDD CS_I a_1747_n7395# VDD sg13_lv_pmos ad=0.16165p pd=1.365u as=0.18715p ps=1.365u w=0.985u l=0.13u
X181 a_4501_n6300# a_5725_n6613# a_4501_n6622# VSS sg13_lv_nmos ad=0.3332p pd=2.64u as=0.1862p ps=1.36u w=0.98u l=0.13u
X182 VSS a_727_n6622# a_2877_n6622# VSS sg13_lv_nmos ad=0.13717p pd=1.25u as=0.1683p ps=1.67u w=0.495u l=0.13u
X183 VSS a_6133_n6622# ECLK VSS sg13_lv_nmos ad=0.13395p pd=1.085u as=0.13395p ps=1.085u w=0.705u l=0.13u
X184 a_1033_n7395# a_259_n7466# a_696_n7125# VDD sg13_lv_pmos ad=0.18525p pd=1.355u as=0.14927p ps=1.355u w=0.975u l=0.13u
X185 VDD a_696_n7125# a_497_n7434# VDD sg13_lv_pmos ad=91.2f pd=0.86u as=0.1632p ps=1.64u w=0.48u l=0.13u
X186 VDD a_n217_n6660# a_n523_n6660# VDD sg13_lv_pmos ad=0.4318p pd=3.22u as=0.2413p ps=1.65u w=1.27u l=0.13u
X187 a_5317_n6569# a_5019_n6569# a_5215_n6569# VSS sg13_lv_nmos ad=0.10545p pd=0.935u as=0.10545p ps=0.935u w=0.555u l=0.13u
X188 a_6133_n6622# a_5929_n6622# VSS VSS sg13_lv_nmos ad=0.13395p pd=1.085u as=0.2397p ps=2.09u w=0.705u l=0.13u
X189 VSS a_n829_n7500# ROW_CS VSS sg13_lv_nmos ad=0.13395p pd=1.085u as=0.13395p ps=1.085u w=0.705u l=0.13u
X190 VSS a_n421_n7500# a_n829_n7500# VSS sg13_lv_nmos ad=0.2397p pd=2.09u as=0.13395p ps=1.085u w=0.705u l=0.13u
X191 a_696_n7125# a_259_n7466# a_829_n6992# VSS sg13_lv_nmos ad=0.13605p pd=1.25u as=91.2f ps=0.86u w=0.48u l=0.13u
X192 VSS a_1415_n6660# a_5458_n7124# VSS sg13_lv_nmos ad=0.12308p pd=1.085u as=0.2397p ps=2.09u w=0.705u l=0.13u
X193 VSS BIST_EN a_2163_n7395# VSS sg13_lv_nmos ad=0.1064p pd=0.94u as=0.1904p ps=1.8u w=0.56u l=0.13u
X194 VDD a_1415_n6660# a_5458_n7124# VDD sg13_lv_pmos ad=0.26017p pd=2u as=0.5508p ps=3.92u w=1.62u l=0.13u
X195 a_2359_n6242# RE_I VDD VDD sg13_lv_pmos ad=0.18715p pd=1.365u as=0.16165p ps=1.365u w=0.985u l=0.13u
X196 VDD a_5725_n6613# a_4501_n7464# VDD sg13_lv_pmos ad=0.5508p pd=3.92u as=0.3078p ps=2u w=1.62u l=0.13u
X197 a_4297_n6622# a_3787_n6620# VSS VSS sg13_lv_nmos ad=0.3332p pd=2.64u as=0.3332p ps=2.64u w=0.98u l=0.13u
X198 VDD a_701_n5820# a_395_n6660# VDD sg13_lv_pmos ad=0.17195p pd=1.285u as=0.3077p ps=2.49u w=0.905u l=0.13u
X199 VDD a_6141_n7014# DCLK VDD sg13_lv_pmos ad=0.5508p pd=3.92u as=0.3078p ps=2u w=1.62u l=0.13u
X200 a_n829_n7500# a_n421_n7500# VSS VSS sg13_lv_nmos ad=0.13395p pd=1.085u as=0.13395p ps=1.085u w=0.705u l=0.13u
X201 VSS a_727_n6622# a_2877_n7395# VSS sg13_lv_nmos ad=0.13717p pd=1.25u as=0.1683p ps=1.67u w=0.495u l=0.13u
X202 a_2563_n6562# BIST_EN a_2461_n6562# VSS sg13_lv_nmos ad=0.1064p pd=0.94u as=0.1064p ps=0.94u w=0.56u l=0.13u
X203 VSS a_n115_n7500# a_21_n7466# VSS sg13_lv_nmos ad=91.2f pd=0.86u as=0.1632p ps=1.64u w=0.48u l=0.13u
X204 a_n115_n7500# a_727_n6622# a_217_n6990# VSS sg13_lv_nmos ad=0.13375p pd=1.23u as=91.2f ps=0.86u w=0.48u l=0.13u
X205 PULSE_O a_13_n5718# VSS VSS sg13_lv_nmos ad=0.3332p pd=2.64u as=0.3332p ps=2.64u w=0.98u l=0.13u
X206 a_3277_n7302# a_727_n6622# a_3175_n7395# VDD sg13_lv_pmos ad=91.2f pd=0.86u as=0.14927p ps=1.355u w=0.48u l=0.13u
X207 VDD BIST_WE_I a_2563_n7395# VDD sg13_lv_pmos ad=0.26017p pd=2u as=0.18715p ps=1.365u w=0.985u l=0.13u
X208 a_829_n5334# a_803_n5820# VSS VSS sg13_lv_nmos ad=0.1862p pd=1.36u as=0.1502p ps=1.36u w=0.98u l=0.13u
X209 a_3353_n7400# a_3175_n7395# VSS VSS sg13_lv_nmos ad=0.1632p pd=1.64u as=91.2f ps=0.86u w=0.48u l=0.13u
X210 VSS a_191_n5717# a_115_n5310# VSS sg13_lv_nmos ad=91.2f pd=0.86u as=91.2f ps=0.86u w=0.48u l=0.13u
X211 VDD a_395_n6660# a_319_n6240# VDD sg13_lv_pmos ad=0.14962p pd=1.355u as=0.18525p ps=1.355u w=0.975u l=0.13u
X212 a_4297_n7464# a_3787_n7398# VDD VDD sg13_lv_pmos ad=0.5508p pd=3.92u as=0.5508p ps=3.92u w=1.62u l=0.13u
X213 a_6235_n7014# a_5873_n7154# a_6141_n7014# VSS sg13_lv_nmos ad=0.1862p pd=1.36u as=0.3332p ps=2.64u w=0.98u l=0.13u
X214 a_n497_n5312# a_n897_n5715# a_n599_n5715# VSS sg13_lv_nmos ad=91.2f pd=0.86u as=0.13605p ps=1.25u w=0.48u l=0.13u
X215 a_13_n5718# a_n897_n5715# a_n89_n5352# VSS sg13_lv_nmos ad=0.13375p pd=1.23u as=0.1783p ps=1.44u w=0.85u l=0.13u
X216 a_3889_n6990# a_727_n6622# a_3787_n7398# VSS sg13_lv_nmos ad=91.2f pd=0.86u as=0.13375p ps=1.23u w=0.48u l=0.13u
X217 a_3073_n6992# a_905_n5820# VSS VSS sg13_lv_nmos ad=0.1653p pd=1.25u as=0.13717p ps=1.25u w=0.87u l=0.13u
X218 ACLK_N a_n1033_n6660# VSS VSS sg13_lv_nmos ad=0.13395p pd=1.085u as=0.2397p ps=2.09u w=0.705u l=0.13u
X219 a_115_n6622# a_n217_n6660# VSS VSS sg13_lv_nmos ad=91.2f pd=0.86u as=91.2f ps=0.86u w=0.48u l=0.13u
X220 VDD PULSE_H a_5019_n6569# VDD sg13_lv_pmos ad=0.14818p pd=1.205u as=0.1972p ps=1.84u w=0.58u l=0.13u
X221 a_5873_n7154# a_5725_n7395# VDD VDD sg13_lv_pmos ad=0.1632p pd=1.64u as=91.2f ps=0.86u w=0.48u l=0.13u
X222 a_319_n6622# a_137_n6072# a_n13_n6660# VSS sg13_lv_nmos ad=0.1653p pd=1.25u as=0.13605p ps=1.25u w=0.87u l=0.13u
X223 ECLK a_6133_n6622# VDD VDD sg13_lv_pmos ad=0.3078p pd=2u as=0.3078p ps=2u w=1.62u l=0.13u
X224 VSS CS_I a_1747_n6990# VSS sg13_lv_nmos ad=0.1064p pd=0.94u as=0.1064p ps=0.94u w=0.56u l=0.13u
X225 a_1033_n6992# a_727_n6622# a_696_n7125# VSS sg13_lv_nmos ad=0.1653p pd=1.25u as=0.13605p ps=1.25u w=0.87u l=0.13u
X226 VDD a_5929_n6622# a_6133_n6622# VDD sg13_lv_pmos ad=0.5508p pd=3.92u as=0.3078p ps=2u w=1.62u l=0.13u
X227 VSS BIST_EN a_2163_n6562# VSS sg13_lv_nmos ad=0.1064p pd=0.94u as=0.1904p ps=1.8u w=0.56u l=0.13u
X228 VSS a_1415_n7500# a_803_n5820# VSS sg13_lv_nmos ad=0.12308p pd=1.085u as=0.2397p ps=2.09u w=0.705u l=0.13u
X229 a_1543_n6242# BIST_CK_I VDD VDD sg13_lv_pmos ad=0.18715p pd=1.365u as=0.26017p ps=2u w=0.985u l=0.13u
X230 a_n523_n6660# a_n217_n6660# a_n293_n6622# VSS sg13_lv_nmos ad=0.3332p pd=2.64u as=0.1862p ps=1.36u w=0.98u l=0.13u
X231 a_3889_n6238# a_2877_n6622# a_3787_n6620# VDD sg13_lv_pmos ad=91.2f pd=0.86u as=0.1511p ps=1.37u w=0.48u l=0.13u
X232 a_2359_n7395# WE_I VDD VDD sg13_lv_pmos ad=0.18715p pd=1.365u as=0.16165p ps=1.365u w=0.985u l=0.13u
X233 a_3175_n6622# a_2877_n6622# a_3073_n6240# VDD sg13_lv_pmos ad=0.14927p pd=1.355u as=0.18525p ps=1.355u w=0.975u l=0.13u
X234 VSS a_5458_n7124# a_6235_n7014# VSS sg13_lv_nmos ad=0.16557p pd=1.36u as=0.1862p ps=1.36u w=0.98u l=0.13u
X235 RCLK a_4501_n6300# VDD VDD sg13_lv_pmos ad=0.3078p pd=2u as=0.5508p ps=3.92u w=1.62u l=0.13u
X236 a_2767_n6591# a_2461_n6562# VSS VSS sg13_lv_nmos ad=0.2397p pd=2.09u as=0.12308p ps=1.085u w=0.705u l=0.13u
X237 a_3073_n6622# a_2767_n6591# VSS VSS sg13_lv_nmos ad=0.1653p pd=1.25u as=0.13717p ps=1.25u w=0.87u l=0.13u
X238 B_TIEL_O a_n1033_n7500# VSS VSS sg13_lv_nmos ad=0.1632p pd=1.64u as=0.1632p ps=1.64u w=0.48u l=0.13u
X239 a_n1033_n7500# a_n1033_n7500# VDD VDD sg13_lv_pmos ad=0.1632p pd=1.64u as=0.1632p ps=1.64u w=0.48u l=0.13u
X240 a_1007_n6660# a_5458_n7124# a_1149_n6217# VDD sg13_lv_pmos ad=0.408p pd=3.08u as=0.144p ps=1.44u w=1.2u l=0.2u
X241 a_2767_n6591# a_2461_n6562# VDD VDD sg13_lv_pmos ad=0.5508p pd=3.92u as=0.26017p ps=2u w=1.62u l=0.13u
X242 a_3277_n6234# a_727_n6622# a_3175_n6622# VDD sg13_lv_pmos ad=91.2f pd=0.86u as=0.14927p ps=1.355u w=0.48u l=0.13u
X243 a_5215_n6569# PULSE_L VDD VDD sg13_lv_pmos ad=0.15675p pd=1.205u as=0.14818p ps=1.205u w=0.825u l=0.13u
X244 VSS a_4501_n7464# WCLK VSS sg13_lv_nmos ad=0.2397p pd=2.09u as=0.13395p ps=1.085u w=0.705u l=0.13u
X245 VSS a_1007_n6660# a_n319_n6660# VSS sg13_lv_nmos ad=0.10507p pd=1.085u as=0.2397p ps=2.09u w=0.705u l=0.13u
X246 a_1584_n6031# BIST_EN VDD VDD sg13_lv_pmos ad=0.2193p pd=1.97u as=0.16165p ps=1.365u w=0.645u l=0.13u
X247 DCLK a_6141_n7014# VSS VSS sg13_lv_nmos ad=0.13395p pd=1.085u as=0.16557p ps=1.36u w=0.705u l=0.13u
X248 ROW_CS a_n829_n7500# VDD VDD sg13_lv_pmos ad=0.3078p pd=2u as=0.3078p ps=2u w=1.62u l=0.13u
X249 VDD a_191_n5717# a_115_n5618# VDD sg13_lv_pmos ad=91.2f pd=0.86u as=91.2f ps=0.86u w=0.48u l=0.13u
X250 a_3889_n6546# a_727_n6622# a_3787_n6620# VSS sg13_lv_nmos ad=91.2f pd=0.86u as=0.13375p ps=1.23u w=0.48u l=0.13u
X251 a_5019_n6918# a_905_n5820# VDD VDD sg13_lv_pmos ad=0.1634p pd=1.24u as=0.2924p ps=2.4u w=0.86u l=0.13u
X252 a_n1007_n5784# PULSE_O VSS VSS sg13_lv_nmos ad=0.2397p pd=2.09u as=0.2397p ps=2.09u w=0.705u l=0.13u
X253 a_n599_n5715# a_n897_n5715# a_n701_n5715# VDD sg13_lv_pmos ad=0.14927p pd=1.355u as=0.18525p ps=1.355u w=0.975u l=0.13u
X254 VSS a_3353_n6580# a_3277_n6544# VSS sg13_lv_nmos ad=91.2f pd=0.86u as=91.2f ps=0.86u w=0.48u l=0.13u
X255 a_5827_n6914# a_5458_n7124# a_5725_n7395# VSS sg13_lv_nmos ad=91.2f pd=0.86u as=0.13605p ps=1.25u w=0.48u l=0.13u
X256 VDD a_n115_n7500# a_21_n7466# VDD sg13_lv_pmos ad=91.2f pd=0.86u as=0.1632p ps=1.64u w=0.48u l=0.13u
X257 a_421_n7398# a_727_n6622# a_n115_n7500# VDD sg13_lv_pmos ad=0.1881p pd=1.37u as=0.1511p ps=1.37u w=0.99u l=0.13u
X258 a_n115_n7500# a_259_n7466# a_217_n7298# VDD sg13_lv_pmos ad=0.1511p pd=1.37u as=91.2f ps=0.86u w=0.48u l=0.13u
X259 a_5317_n6569# PULSE_H a_5215_n6569# VDD sg13_lv_pmos ad=0.15675p pd=1.205u as=0.15675p ps=1.205u w=0.825u l=0.13u
X260 VSS a_497_n7434# a_421_n6990# VSS sg13_lv_nmos ad=0.289p pd=2.38u as=0.1783p ps=1.44u w=0.85u l=0.13u
X261 a_5623_n7395# a_5317_n7464# VDD VDD sg13_lv_pmos ad=0.18525p pd=1.355u as=0.14962p ps=1.355u w=0.975u l=0.13u
X262 VDD a_1415_n7500# a_803_n5820# VDD sg13_lv_pmos ad=0.26017p pd=2u as=0.5508p ps=3.92u w=1.62u l=0.13u
X263 VSS BIST_WE_I a_2563_n6990# VSS sg13_lv_nmos ad=0.12308p pd=1.085u as=0.1064p ps=0.94u w=0.56u l=0.13u
X264 VSS CK_I a_1747_n6562# VSS sg13_lv_nmos ad=0.1064p pd=0.94u as=0.1064p ps=0.94u w=0.56u l=0.13u
X265 a_727_n6622# a_n319_n6660# VDD VDD sg13_lv_pmos ad=0.3078p pd=2u as=0.5508p ps=3.92u w=1.62u l=0.13u
X266 a_3889_n7298# a_2877_n7395# a_3787_n7398# VDD sg13_lv_pmos ad=91.2f pd=0.86u as=0.1511p ps=1.37u w=0.48u l=0.13u
X267 a_3175_n7395# a_2877_n7395# a_3073_n7395# VDD sg13_lv_pmos ad=0.14927p pd=1.355u as=0.18525p ps=1.355u w=0.975u l=0.13u
X268 a_1584_n7469# BIST_EN VDD VDD sg13_lv_pmos ad=0.2193p pd=1.97u as=0.16165p ps=1.365u w=0.645u l=0.13u
X269 VDD a_n1033_n6660# ACLK_N VDD sg13_lv_pmos ad=0.5508p pd=3.92u as=0.3078p ps=2u w=1.62u l=0.13u
X270 a_1543_n7395# BIST_CS_I VDD VDD sg13_lv_pmos ad=0.18715p pd=1.365u as=0.26017p ps=2u w=0.985u l=0.13u
X271 ECLK a_6133_n6622# VSS VSS sg13_lv_nmos ad=0.13395p pd=1.085u as=0.13395p ps=1.085u w=0.705u l=0.13u
X272 VDD a_803_n5820# a_1033_n7395# VDD sg13_lv_pmos ad=0.14812p pd=1.355u as=0.18525p ps=1.355u w=0.975u l=0.13u
X273 a_829_n7302# a_497_n7434# VDD VDD sg13_lv_pmos ad=91.2f pd=0.86u as=91.2f ps=0.86u w=0.48u l=0.13u
.ends

.subckt RM_IHPSG13_1P_COLDRV13_FILL4C2 m3_0_n8450# m3_0_n9266# m3_0_n9062#
X0 a_59_n8122# a_21_n8302# m3_0_n9062# m3_0_n9062# sg13_lv_pmos ad=0.3078p pd=2u as=0.5508p ps=3.92u w=1.62u l=0.385u
X1 m3_0_n9266# a_59_n8744# a_21_n8664# m3_0_n9266# sg13_lv_nmos ad=0.1577p pd=1.21u as=0.2822p ps=2.34u w=0.83u l=0.13u
X2 m3_0_n9266# a_59_n8744# a_21_n8664# m3_0_n9266# sg13_lv_nmos ad=0.2822p pd=2.34u as=0.1577p ps=1.21u w=0.83u l=0.13u
X3 m3_0_n9266# a_59_n8122# a_21_n8302# m3_0_n9266# sg13_lv_nmos ad=0.1577p pd=1.21u as=0.2822p ps=2.34u w=0.83u l=0.13u
X4 m3_0_n9266# a_59_n8122# a_21_n8302# m3_0_n9266# sg13_lv_nmos ad=0.2822p pd=2.34u as=0.1577p ps=1.21u w=0.83u l=0.13u
X5 a_59_n8744# a_21_n8664# m3_0_n9062# m3_0_n9062# sg13_lv_pmos ad=0.3078p pd=2u as=0.5508p ps=3.92u w=1.62u l=0.385u
X6 m3_0_n9062# a_21_n8302# a_59_n8122# m3_0_n9062# sg13_lv_pmos ad=0.5508p pd=3.92u as=0.3078p ps=2u w=1.62u l=0.385u
X7 m3_0_n9062# a_21_n8664# a_59_n8744# m3_0_n9062# sg13_lv_pmos ad=0.5508p pd=3.92u as=0.3078p ps=2u w=1.62u l=0.385u
X8 a_21_n8664# a_59_n8744# m3_0_n9266# m3_0_n9266# sg13_lv_nmos ad=0.1577p pd=1.21u as=0.1577p ps=1.21u w=0.83u l=0.13u
X9 a_21_n8302# a_59_n8122# m3_0_n9266# m3_0_n9266# sg13_lv_nmos ad=0.1577p pd=1.21u as=0.1577p ps=1.21u w=0.83u l=0.13u
.ends

.subckt RM_IHPSG13_1P_DLY_MUX a_89_1220# a_n81_96# dw_n306_n60# w_n306_1197# w_n408_n105#
+ a_n50_1148#
X0 a_13_998# a_n50_1148# dw_n306_n60# dw_n306_n60# sg13_lv_nmos ad=91.2f pd=0.86u as=0.1632p ps=1.64u w=0.48u l=0.13u
X1 a_n13_60# a_89_1220# a_13_1318# w_n306_1197# sg13_lv_pmos ad=0.18715p pd=1.365u as=0.18715p ps=1.365u w=0.985u l=0.13u
X2 a_905_60# a_633_938# a_937_1434# w_n306_1197# sg13_lv_pmos ad=0.2448p pd=2.12u as=0.1152p ps=1.04u w=0.72u l=0.16u
X3 a_937_938# a_633_938# dw_n306_n60# dw_n306_n60# sg13_lv_nmos ad=48f pd=0.62u as=57f ps=0.68u w=0.3u l=0.16u
X4 dw_n306_n60# a_701_60# a_733_682# dw_n306_n60# sg13_lv_nmos ad=57f pd=0.68u as=48f ps=0.62u w=0.3u l=0.16u
X5 w_n306_1197# a_123_102# a_217_1318# w_n306_1197# sg13_lv_pmos ad=0.16165p pd=1.365u as=0.18715p ps=1.365u w=0.985u l=0.13u
X6 w_n408_n105# a_701_60# a_733_102# w_n408_n105# sg13_lv_pmos ad=0.1368p pd=1.1u as=0.1152p ps=1.04u w=0.72u l=0.16u
X7 a_905_60# a_633_938# a_937_938# dw_n306_n60# sg13_lv_nmos ad=0.102p pd=1.28u as=48f ps=0.62u w=0.3u l=0.16u
X8 a_733_682# a_701_60# a_395_60# dw_n306_n60# sg13_lv_nmos ad=48f pd=0.62u as=0.102p ps=1.28u w=0.3u l=0.16u
X9 a_937_1434# a_633_938# w_n306_1197# w_n306_1197# sg13_lv_pmos ad=0.1152p pd=1.04u as=0.1368p ps=1.1u w=0.72u l=0.16u
X10 dw_n306_n60# a_n13_60# a_n81_96# dw_n306_n60# sg13_lv_nmos ad=0.2397p pd=2.09u as=0.2397p ps=2.09u w=0.705u l=0.13u
X11 a_733_102# a_701_60# a_395_60# w_n408_n105# sg13_lv_pmos ad=0.1152p pd=1.04u as=0.2448p ps=2.12u w=0.72u l=0.16u
X12 a_937_682# a_905_60# dw_n306_n60# dw_n306_n60# sg13_lv_nmos ad=48f pd=0.62u as=57f ps=0.68u w=0.3u l=0.16u
X13 a_937_102# a_905_60# w_n408_n105# w_n408_n105# sg13_lv_pmos ad=0.1152p pd=1.04u as=0.1368p ps=1.1u w=0.72u l=0.16u
X14 a_701_60# a_905_60# a_937_682# dw_n306_n60# sg13_lv_nmos ad=0.102p pd=1.28u as=48f ps=0.62u w=0.3u l=0.16u
X15 a_701_60# a_905_60# a_937_102# w_n408_n105# sg13_lv_pmos ad=0.2448p pd=2.12u as=0.1152p ps=1.04u w=0.72u l=0.16u
X16 a_50_1124# a_89_1220# w_n306_1197# w_n306_1197# sg13_lv_pmos ad=0.2193p pd=1.97u as=0.16165p ps=1.365u w=0.645u l=0.13u
X17 w_n306_1197# a_n50_1148# a_733_1434# w_n306_1197# sg13_lv_pmos ad=0.1368p pd=1.1u as=0.1152p ps=1.04u w=0.72u l=0.16u
X18 a_217_998# a_89_1220# a_n13_60# dw_n306_n60# sg13_lv_nmos ad=91.2f pd=0.86u as=91.2f ps=0.86u w=0.48u l=0.13u
X19 dw_n306_n60# a_123_102# a_217_998# dw_n306_n60# sg13_lv_nmos ad=91.2f pd=0.86u as=91.2f ps=0.86u w=0.48u l=0.13u
X20 a_50_1124# a_89_1220# dw_n306_n60# dw_n306_n60# sg13_lv_nmos ad=0.1632p pd=1.64u as=91.2f ps=0.86u w=0.48u l=0.13u
X21 dw_n306_n60# a_n50_1148# a_733_938# dw_n306_n60# sg13_lv_nmos ad=57f pd=0.68u as=48f ps=0.62u w=0.3u l=0.16u
X22 w_n408_n105# a_n13_60# a_n81_96# w_n408_n105# sg13_lv_pmos ad=0.5508p pd=3.92u as=0.5508p ps=3.92u w=1.62u l=0.13u
X23 a_223_682# a_191_60# a_123_102# dw_n306_n60# sg13_lv_nmos ad=48f pd=0.62u as=0.102p ps=1.28u w=0.3u l=0.16u
X24 a_733_1434# a_n50_1148# a_633_938# w_n306_1197# sg13_lv_pmos ad=0.1152p pd=1.04u as=0.2448p ps=2.12u w=0.72u l=0.16u
X25 dw_n306_n60# a_191_60# a_223_682# dw_n306_n60# sg13_lv_nmos ad=57f pd=0.68u as=48f ps=0.62u w=0.3u l=0.16u
X26 a_223_102# a_191_60# a_123_102# w_n408_n105# sg13_lv_pmos ad=0.1152p pd=1.04u as=0.2448p ps=2.12u w=0.72u l=0.16u
X27 w_n408_n105# a_191_60# a_223_102# w_n408_n105# sg13_lv_pmos ad=0.1368p pd=1.1u as=0.1152p ps=1.04u w=0.72u l=0.16u
X28 a_217_1318# a_50_1124# a_n13_60# w_n306_1197# sg13_lv_pmos ad=0.18715p pd=1.365u as=0.18715p ps=1.365u w=0.985u l=0.13u
X29 a_191_60# a_395_60# a_427_682# dw_n306_n60# sg13_lv_nmos ad=0.102p pd=1.28u as=48f ps=0.62u w=0.3u l=0.16u
X30 a_427_682# a_395_60# dw_n306_n60# dw_n306_n60# sg13_lv_nmos ad=48f pd=0.62u as=57f ps=0.68u w=0.3u l=0.16u
X31 a_191_60# a_395_60# a_427_102# w_n408_n105# sg13_lv_pmos ad=0.2448p pd=2.12u as=0.1152p ps=1.04u w=0.72u l=0.16u
X32 a_n13_60# a_50_1124# a_13_998# dw_n306_n60# sg13_lv_nmos ad=91.2f pd=0.86u as=91.2f ps=0.86u w=0.48u l=0.13u
X33 a_733_938# a_n50_1148# a_633_938# dw_n306_n60# sg13_lv_nmos ad=48f pd=0.62u as=0.102p ps=1.28u w=0.3u l=0.16u
X34 a_427_102# a_395_60# w_n408_n105# w_n408_n105# sg13_lv_pmos ad=0.1152p pd=1.04u as=0.1368p ps=1.1u w=0.72u l=0.16u
X35 a_13_1318# a_n50_1148# w_n306_1197# w_n306_1197# sg13_lv_pmos ad=0.18715p pd=1.365u as=0.3349p ps=2.65u w=0.985u l=0.13u
.ends

.subckt RM_IHPSG13_1P_BITKIT_EDGE_LR VDD VSS LWL dw_n311_n199#
X0 VSS LWL VSS dw_n311_n199# sg13_lv_nmos ad=57f pd=0.68u as=0 ps=0 w=0.3u l=0.13u
X1 VSS a_n263_38# VSS dw_n311_n199# sg13_lv_nmos ad=0.1095p pd=1.33u as=0 ps=0 w=0.3u l=0.13u
.ends

.subckt RM_IHPSG13_1P_BITKIT_16x2_EDGE_LR LWL<15> LWL<14> LWL<12> LWL<10> LWL<9> LWL<8>
+ LWL<7> LWL<6> LWL<4> LWL<3> LWL<1> LWL<0> LWL<11> LWL<13> RM_IHPSG13_1P_BITKIT_EDGE_LR_9/VSS
+ LWL<5> LWL<2> RM_IHPSG13_1P_BITKIT_EDGE_LR_9/VDD
XRM_IHPSG13_1P_BITKIT_EDGE_LR_0 RM_IHPSG13_1P_BITKIT_EDGE_LR_9/VDD RM_IHPSG13_1P_BITKIT_EDGE_LR_9/VSS
+ LWL<12> RM_IHPSG13_1P_BITKIT_EDGE_LR_9/VSS RM_IHPSG13_1P_BITKIT_EDGE_LR
XRM_IHPSG13_1P_BITKIT_EDGE_LR_1 RM_IHPSG13_1P_BITKIT_EDGE_LR_9/VDD RM_IHPSG13_1P_BITKIT_EDGE_LR_9/VSS
+ LWL<10> RM_IHPSG13_1P_BITKIT_EDGE_LR_9/VSS RM_IHPSG13_1P_BITKIT_EDGE_LR
XRM_IHPSG13_1P_BITKIT_EDGE_LR_2 RM_IHPSG13_1P_BITKIT_EDGE_LR_9/VDD RM_IHPSG13_1P_BITKIT_EDGE_LR_9/VSS
+ LWL<0> RM_IHPSG13_1P_BITKIT_EDGE_LR_9/VSS RM_IHPSG13_1P_BITKIT_EDGE_LR
XRM_IHPSG13_1P_BITKIT_EDGE_LR_3 RM_IHPSG13_1P_BITKIT_EDGE_LR_9/VDD RM_IHPSG13_1P_BITKIT_EDGE_LR_9/VSS
+ LWL<8> RM_IHPSG13_1P_BITKIT_EDGE_LR_9/VSS RM_IHPSG13_1P_BITKIT_EDGE_LR
XRM_IHPSG13_1P_BITKIT_EDGE_LR_4 RM_IHPSG13_1P_BITKIT_EDGE_LR_9/VDD RM_IHPSG13_1P_BITKIT_EDGE_LR_9/VSS
+ LWL<6> RM_IHPSG13_1P_BITKIT_EDGE_LR_9/VSS RM_IHPSG13_1P_BITKIT_EDGE_LR
XRM_IHPSG13_1P_BITKIT_EDGE_LR_5 RM_IHPSG13_1P_BITKIT_EDGE_LR_9/VDD RM_IHPSG13_1P_BITKIT_EDGE_LR_9/VSS
+ LWL<4> RM_IHPSG13_1P_BITKIT_EDGE_LR_9/VSS RM_IHPSG13_1P_BITKIT_EDGE_LR
XRM_IHPSG13_1P_BITKIT_EDGE_LR_6 RM_IHPSG13_1P_BITKIT_EDGE_LR_9/VDD RM_IHPSG13_1P_BITKIT_EDGE_LR_9/VSS
+ LWL<2> RM_IHPSG13_1P_BITKIT_EDGE_LR_9/VSS RM_IHPSG13_1P_BITKIT_EDGE_LR
XRM_IHPSG13_1P_BITKIT_EDGE_LR_7 RM_IHPSG13_1P_BITKIT_EDGE_LR_9/VDD RM_IHPSG13_1P_BITKIT_EDGE_LR_9/VSS
+ LWL<14> RM_IHPSG13_1P_BITKIT_EDGE_LR_9/VSS RM_IHPSG13_1P_BITKIT_EDGE_LR
XRM_IHPSG13_1P_BITKIT_EDGE_LR_8 RM_IHPSG13_1P_BITKIT_EDGE_LR_9/VDD RM_IHPSG13_1P_BITKIT_EDGE_LR_9/VSS
+ LWL<15> RM_IHPSG13_1P_BITKIT_EDGE_LR_9/VSS RM_IHPSG13_1P_BITKIT_EDGE_LR
XRM_IHPSG13_1P_BITKIT_EDGE_LR_10 RM_IHPSG13_1P_BITKIT_EDGE_LR_9/VDD RM_IHPSG13_1P_BITKIT_EDGE_LR_9/VSS
+ LWL<9> RM_IHPSG13_1P_BITKIT_EDGE_LR_9/VSS RM_IHPSG13_1P_BITKIT_EDGE_LR
XRM_IHPSG13_1P_BITKIT_EDGE_LR_9 RM_IHPSG13_1P_BITKIT_EDGE_LR_9/VDD RM_IHPSG13_1P_BITKIT_EDGE_LR_9/VSS
+ LWL<13> RM_IHPSG13_1P_BITKIT_EDGE_LR_9/VSS RM_IHPSG13_1P_BITKIT_EDGE_LR
XRM_IHPSG13_1P_BITKIT_EDGE_LR_11 RM_IHPSG13_1P_BITKIT_EDGE_LR_9/VDD RM_IHPSG13_1P_BITKIT_EDGE_LR_9/VSS
+ LWL<7> RM_IHPSG13_1P_BITKIT_EDGE_LR_9/VSS RM_IHPSG13_1P_BITKIT_EDGE_LR
XRM_IHPSG13_1P_BITKIT_EDGE_LR_12 RM_IHPSG13_1P_BITKIT_EDGE_LR_9/VDD RM_IHPSG13_1P_BITKIT_EDGE_LR_9/VSS
+ LWL<5> RM_IHPSG13_1P_BITKIT_EDGE_LR_9/VSS RM_IHPSG13_1P_BITKIT_EDGE_LR
XRM_IHPSG13_1P_BITKIT_EDGE_LR_13 RM_IHPSG13_1P_BITKIT_EDGE_LR_9/VDD RM_IHPSG13_1P_BITKIT_EDGE_LR_9/VSS
+ LWL<3> RM_IHPSG13_1P_BITKIT_EDGE_LR_9/VSS RM_IHPSG13_1P_BITKIT_EDGE_LR
XRM_IHPSG13_1P_BITKIT_EDGE_LR_14 RM_IHPSG13_1P_BITKIT_EDGE_LR_9/VDD RM_IHPSG13_1P_BITKIT_EDGE_LR_9/VSS
+ LWL<1> RM_IHPSG13_1P_BITKIT_EDGE_LR_9/VSS RM_IHPSG13_1P_BITKIT_EDGE_LR
XRM_IHPSG13_1P_BITKIT_EDGE_LR_15 RM_IHPSG13_1P_BITKIT_EDGE_LR_9/VDD RM_IHPSG13_1P_BITKIT_EDGE_LR_9/VSS
+ LWL<11> RM_IHPSG13_1P_BITKIT_EDGE_LR_9/VSS RM_IHPSG13_1P_BITKIT_EDGE_LR
.ends

.subckt RM_IHPSG13_1P_BITKIT_CELL BLC_BOT BLC_TOP VDD VSS BLT_BOT BLT_TOP LWL RWL
+ VSS_uq0 dw_n311_n199# w_n115_n199#
X0 VDD a_n263_38# a_n229_n38# w_n115_n199# sg13_lv_pmos ad=74.24999f pd=1.19u as=86.99999f ps=1.36u w=0.15u l=0.13u
R0 BLT_TOP BLT_BOT 0.264000
X1 a_n229_n38# LWL BLT_BOT dw_n311_n199# sg13_lv_nmos ad=57f pd=0.68u as=0.1095p ps=1.33u w=0.3u l=0.13u
X2 a_n263_38# a_n229_n38# VDD w_n115_n199# sg13_lv_pmos ad=86.99999f pd=1.36u as=74.24999f ps=1.19u w=0.15u l=0.13u
X3 VSS a_n263_38# a_n229_n38# dw_n311_n199# sg13_lv_nmos ad=0.1095p pd=1.33u as=57f ps=0.68u w=0.3u l=0.13u
R1 BLC_TOP BLC_BOT 0.264000
R2 LWL RWL 0.264000
X4 a_n263_38# a_n229_n38# VSS_uq0 dw_n311_n199# sg13_lv_nmos ad=57f pd=0.68u as=0.1095p ps=1.33u w=0.3u l=0.13u
X5 BLC_TOP RWL a_n263_38# dw_n311_n199# sg13_lv_nmos ad=0.1095p pd=1.33u as=57f ps=0.68u w=0.3u l=0.13u
.ends

.subckt RM_IHPSG13_1P_BITKIT_CELL_2x1 RM_IHPSG13_1P_BITKIT_CELL_0/BLT_BOT RM_IHPSG13_1P_BITKIT_CELL_1/BLC_BOT
+ RM_IHPSG13_1P_BITKIT_CELL_0/RWL RM_IHPSG13_1P_BITKIT_CELL_1/LWL RM_IHPSG13_1P_BITKIT_CELL_1/BLT_BOT
+ RM_IHPSG13_1P_BITKIT_CELL_1/w_n115_n199# RM_IHPSG13_1P_BITKIT_CELL_1/RWL RM_IHPSG13_1P_BITKIT_CELL_1/VDD
+ RM_IHPSG13_1P_BITKIT_CELL_1/VSS w_115_n199# RM_IHPSG13_1P_BITKIT_CELL_0/BLC_BOT
+ RM_IHPSG13_1P_BITKIT_CELL_0/LWL
XRM_IHPSG13_1P_BITKIT_CELL_0 RM_IHPSG13_1P_BITKIT_CELL_0/BLC_BOT RM_IHPSG13_1P_BITKIT_CELL_1/BLC_TOP
+ RM_IHPSG13_1P_BITKIT_CELL_1/VDD RM_IHPSG13_1P_BITKIT_CELL_1/VSS RM_IHPSG13_1P_BITKIT_CELL_0/BLT_BOT
+ RM_IHPSG13_1P_BITKIT_CELL_1/BLT_TOP RM_IHPSG13_1P_BITKIT_CELL_0/LWL RM_IHPSG13_1P_BITKIT_CELL_0/RWL
+ RM_IHPSG13_1P_BITKIT_CELL_1/VSS w_115_n199# RM_IHPSG13_1P_BITKIT_CELL_1/w_n115_n199#
+ RM_IHPSG13_1P_BITKIT_CELL
XRM_IHPSG13_1P_BITKIT_CELL_1 RM_IHPSG13_1P_BITKIT_CELL_1/BLC_BOT RM_IHPSG13_1P_BITKIT_CELL_1/BLC_TOP
+ RM_IHPSG13_1P_BITKIT_CELL_1/VDD RM_IHPSG13_1P_BITKIT_CELL_1/VSS RM_IHPSG13_1P_BITKIT_CELL_1/BLT_BOT
+ RM_IHPSG13_1P_BITKIT_CELL_1/BLT_TOP RM_IHPSG13_1P_BITKIT_CELL_1/LWL RM_IHPSG13_1P_BITKIT_CELL_1/RWL
+ RM_IHPSG13_1P_BITKIT_CELL_1/VSS w_115_n199# RM_IHPSG13_1P_BITKIT_CELL_1/w_n115_n199#
+ RM_IHPSG13_1P_BITKIT_CELL
.ends

.subckt RM_IHPSG13_1P_BITKIT_16x2_SRAM A_BLT_TOP<0> A_BLT_BOT<0> A_BLC_TOP<0> A_BLC_BOT<0>
+ A_BLC_TOP<1> A_BLC_BOT<1> A_BLT_TOP<1> A_BLT_BOT<1> A_RWL<2> A_RWL<4> A_RWL<5> A_RWL<7>
+ A_RWL<0> A_RWL<15> A_RWL<13> A_RWL<12> A_RWL<10> A_LWL<0> A_LWL<1> A_LWL<2> A_LWL<7>
+ A_LWL<9> A_LWL<10> A_LWL<12> A_LWL<15> A_RWL<3> A_LWL<3> A_RWL<9> A_LWL<5> A_LWL<8>
+ A_LWL<11> A_LWL<14> A_RWL<8> A_RWL<1> A_LWL<13> A_RWL<6> A_LWL<4> A_RWL<14> VSS
+ A_RWL<11> A_LWL<6> VDD
XRM_IHPSG13_1P_BITKIT_CELL_2x1_3 RM_IHPSG13_1P_BITKIT_CELL_2x1_8/RM_IHPSG13_1P_BITKIT_CELL_0/BLT_BOT
+ RM_IHPSG13_1P_BITKIT_CELL_2x1_9/RM_IHPSG13_1P_BITKIT_CELL_1/BLC_BOT RM_IHPSG13_1P_BITKIT_CELL_2x1_3/RM_IHPSG13_1P_BITKIT_CELL_0/RWL
+ A_RWL<8> RM_IHPSG13_1P_BITKIT_CELL_2x1_9/RM_IHPSG13_1P_BITKIT_CELL_1/BLT_BOT VDD
+ RM_IHPSG13_1P_BITKIT_CELL_2x1_3/RM_IHPSG13_1P_BITKIT_CELL_1/RWL VDD VSS VSS RM_IHPSG13_1P_BITKIT_CELL_2x1_8/RM_IHPSG13_1P_BITKIT_CELL_0/BLC_BOT
+ A_RWL<9> RM_IHPSG13_1P_BITKIT_CELL_2x1
XRM_IHPSG13_1P_BITKIT_CELL_2x1_4 RM_IHPSG13_1P_BITKIT_CELL_2x1_4/RM_IHPSG13_1P_BITKIT_CELL_0/BLT_BOT
+ A_BLC_TOP<0> RM_IHPSG13_1P_BITKIT_CELL_2x1_4/RM_IHPSG13_1P_BITKIT_CELL_0/RWL A_LWL<15>
+ A_BLT_TOP<0> VDD RM_IHPSG13_1P_BITKIT_CELL_2x1_4/RM_IHPSG13_1P_BITKIT_CELL_1/RWL
+ VDD VSS VSS RM_IHPSG13_1P_BITKIT_CELL_2x1_4/RM_IHPSG13_1P_BITKIT_CELL_0/BLC_BOT
+ A_LWL<14> RM_IHPSG13_1P_BITKIT_CELL_2x1
XRM_IHPSG13_1P_BITKIT_CELL_2x1_5 RM_IHPSG13_1P_BITKIT_CELL_2x1_5/RM_IHPSG13_1P_BITKIT_CELL_0/BLT_BOT
+ RM_IHPSG13_1P_BITKIT_CELL_2x1_5/RM_IHPSG13_1P_BITKIT_CELL_1/BLC_BOT RM_IHPSG13_1P_BITKIT_CELL_2x1_9/RM_IHPSG13_1P_BITKIT_CELL_0/RWL
+ A_LWL<7> RM_IHPSG13_1P_BITKIT_CELL_2x1_5/RM_IHPSG13_1P_BITKIT_CELL_1/BLT_BOT VDD
+ RM_IHPSG13_1P_BITKIT_CELL_2x1_9/RM_IHPSG13_1P_BITKIT_CELL_1/RWL VDD VSS VSS RM_IHPSG13_1P_BITKIT_CELL_2x1_5/RM_IHPSG13_1P_BITKIT_CELL_0/BLC_BOT
+ A_LWL<6> RM_IHPSG13_1P_BITKIT_CELL_2x1
XRM_IHPSG13_1P_BITKIT_CELL_2x1_7 RM_IHPSG13_1P_BITKIT_CELL_2x1_7/RM_IHPSG13_1P_BITKIT_CELL_0/BLT_BOT
+ RM_IHPSG13_1P_BITKIT_CELL_2x1_7/RM_IHPSG13_1P_BITKIT_CELL_1/BLC_BOT RM_IHPSG13_1P_BITKIT_CELL_2x1_8/RM_IHPSG13_1P_BITKIT_CELL_0/RWL
+ A_LWL<11> RM_IHPSG13_1P_BITKIT_CELL_2x1_7/RM_IHPSG13_1P_BITKIT_CELL_1/BLT_BOT VDD
+ RM_IHPSG13_1P_BITKIT_CELL_2x1_8/RM_IHPSG13_1P_BITKIT_CELL_1/RWL VDD VSS VSS RM_IHPSG13_1P_BITKIT_CELL_2x1_7/RM_IHPSG13_1P_BITKIT_CELL_0/BLC_BOT
+ A_LWL<10> RM_IHPSG13_1P_BITKIT_CELL_2x1
XRM_IHPSG13_1P_BITKIT_CELL_2x1_6 RM_IHPSG13_1P_BITKIT_CELL_2x1_6/RM_IHPSG13_1P_BITKIT_CELL_0/BLT_BOT
+ RM_IHPSG13_1P_BITKIT_CELL_2x1_6/RM_IHPSG13_1P_BITKIT_CELL_1/BLC_BOT RM_IHPSG13_1P_BITKIT_CELL_2x1_6/RM_IHPSG13_1P_BITKIT_CELL_0/RWL
+ A_LWL<3> RM_IHPSG13_1P_BITKIT_CELL_2x1_6/RM_IHPSG13_1P_BITKIT_CELL_1/BLT_BOT VDD
+ RM_IHPSG13_1P_BITKIT_CELL_2x1_6/RM_IHPSG13_1P_BITKIT_CELL_1/RWL VDD VSS VSS RM_IHPSG13_1P_BITKIT_CELL_2x1_6/RM_IHPSG13_1P_BITKIT_CELL_0/BLC_BOT
+ A_LWL<2> RM_IHPSG13_1P_BITKIT_CELL_2x1
XRM_IHPSG13_1P_BITKIT_CELL_2x1_8 RM_IHPSG13_1P_BITKIT_CELL_2x1_8/RM_IHPSG13_1P_BITKIT_CELL_0/BLT_BOT
+ RM_IHPSG13_1P_BITKIT_CELL_2x1_8/RM_IHPSG13_1P_BITKIT_CELL_1/BLC_BOT RM_IHPSG13_1P_BITKIT_CELL_2x1_8/RM_IHPSG13_1P_BITKIT_CELL_0/RWL
+ A_RWL<11> RM_IHPSG13_1P_BITKIT_CELL_2x1_8/RM_IHPSG13_1P_BITKIT_CELL_1/BLT_BOT VDD
+ RM_IHPSG13_1P_BITKIT_CELL_2x1_8/RM_IHPSG13_1P_BITKIT_CELL_1/RWL VDD VSS VSS RM_IHPSG13_1P_BITKIT_CELL_2x1_8/RM_IHPSG13_1P_BITKIT_CELL_0/BLC_BOT
+ A_RWL<10> RM_IHPSG13_1P_BITKIT_CELL_2x1
XRM_IHPSG13_1P_BITKIT_CELL_2x1_9 RM_IHPSG13_1P_BITKIT_CELL_2x1_9/RM_IHPSG13_1P_BITKIT_CELL_0/BLT_BOT
+ RM_IHPSG13_1P_BITKIT_CELL_2x1_9/RM_IHPSG13_1P_BITKIT_CELL_1/BLC_BOT RM_IHPSG13_1P_BITKIT_CELL_2x1_9/RM_IHPSG13_1P_BITKIT_CELL_0/RWL
+ A_RWL<7> RM_IHPSG13_1P_BITKIT_CELL_2x1_9/RM_IHPSG13_1P_BITKIT_CELL_1/BLT_BOT VDD
+ RM_IHPSG13_1P_BITKIT_CELL_2x1_9/RM_IHPSG13_1P_BITKIT_CELL_1/RWL VDD VSS VSS RM_IHPSG13_1P_BITKIT_CELL_2x1_9/RM_IHPSG13_1P_BITKIT_CELL_0/BLC_BOT
+ A_RWL<6> RM_IHPSG13_1P_BITKIT_CELL_2x1
XRM_IHPSG13_1P_BITKIT_CELL_2x1_10 RM_IHPSG13_1P_BITKIT_CELL_2x1_2/RM_IHPSG13_1P_BITKIT_CELL_0/BLT_BOT
+ A_BLC_TOP<1> RM_IHPSG13_1P_BITKIT_CELL_2x1_4/RM_IHPSG13_1P_BITKIT_CELL_0/RWL A_RWL<15>
+ A_BLT_TOP<1> VDD RM_IHPSG13_1P_BITKIT_CELL_2x1_4/RM_IHPSG13_1P_BITKIT_CELL_1/RWL
+ VDD VSS VSS RM_IHPSG13_1P_BITKIT_CELL_2x1_2/RM_IHPSG13_1P_BITKIT_CELL_0/BLC_BOT
+ A_RWL<14> RM_IHPSG13_1P_BITKIT_CELL_2x1
XRM_IHPSG13_1P_BITKIT_CELL_2x1_11 RM_IHPSG13_1P_BITKIT_CELL_2x1_0/RM_IHPSG13_1P_BITKIT_CELL_0/BLT_BOT
+ RM_IHPSG13_1P_BITKIT_CELL_2x1_1/RM_IHPSG13_1P_BITKIT_CELL_1/BLC_BOT RM_IHPSG13_1P_BITKIT_CELL_2x1_6/RM_IHPSG13_1P_BITKIT_CELL_0/RWL
+ A_RWL<3> RM_IHPSG13_1P_BITKIT_CELL_2x1_1/RM_IHPSG13_1P_BITKIT_CELL_1/BLT_BOT VDD
+ RM_IHPSG13_1P_BITKIT_CELL_2x1_6/RM_IHPSG13_1P_BITKIT_CELL_1/RWL VDD VSS VSS RM_IHPSG13_1P_BITKIT_CELL_2x1_0/RM_IHPSG13_1P_BITKIT_CELL_0/BLC_BOT
+ A_RWL<2> RM_IHPSG13_1P_BITKIT_CELL_2x1
XRM_IHPSG13_1P_BITKIT_CELL_2x1_12 RM_IHPSG13_1P_BITKIT_CELL_2x1_7/RM_IHPSG13_1P_BITKIT_CELL_0/BLT_BOT
+ RM_IHPSG13_1P_BITKIT_CELL_2x1_5/RM_IHPSG13_1P_BITKIT_CELL_1/BLC_BOT RM_IHPSG13_1P_BITKIT_CELL_2x1_3/RM_IHPSG13_1P_BITKIT_CELL_0/RWL
+ A_LWL<8> RM_IHPSG13_1P_BITKIT_CELL_2x1_5/RM_IHPSG13_1P_BITKIT_CELL_1/BLT_BOT VDD
+ RM_IHPSG13_1P_BITKIT_CELL_2x1_3/RM_IHPSG13_1P_BITKIT_CELL_1/RWL VDD VSS VSS RM_IHPSG13_1P_BITKIT_CELL_2x1_7/RM_IHPSG13_1P_BITKIT_CELL_0/BLC_BOT
+ A_LWL<9> RM_IHPSG13_1P_BITKIT_CELL_2x1
XRM_IHPSG13_1P_BITKIT_CELL_2x1_13 RM_IHPSG13_1P_BITKIT_CELL_2x1_5/RM_IHPSG13_1P_BITKIT_CELL_0/BLT_BOT
+ RM_IHPSG13_1P_BITKIT_CELL_2x1_6/RM_IHPSG13_1P_BITKIT_CELL_1/BLC_BOT RM_IHPSG13_1P_BITKIT_CELL_2x1_1/RM_IHPSG13_1P_BITKIT_CELL_0/RWL
+ A_LWL<4> RM_IHPSG13_1P_BITKIT_CELL_2x1_6/RM_IHPSG13_1P_BITKIT_CELL_1/BLT_BOT VDD
+ RM_IHPSG13_1P_BITKIT_CELL_2x1_1/RM_IHPSG13_1P_BITKIT_CELL_1/RWL VDD VSS VSS RM_IHPSG13_1P_BITKIT_CELL_2x1_5/RM_IHPSG13_1P_BITKIT_CELL_0/BLC_BOT
+ A_LWL<5> RM_IHPSG13_1P_BITKIT_CELL_2x1
XRM_IHPSG13_1P_BITKIT_CELL_2x1_14 RM_IHPSG13_1P_BITKIT_CELL_2x1_4/RM_IHPSG13_1P_BITKIT_CELL_0/BLT_BOT
+ RM_IHPSG13_1P_BITKIT_CELL_2x1_7/RM_IHPSG13_1P_BITKIT_CELL_1/BLC_BOT RM_IHPSG13_1P_BITKIT_CELL_2x1_2/RM_IHPSG13_1P_BITKIT_CELL_0/RWL
+ A_LWL<12> RM_IHPSG13_1P_BITKIT_CELL_2x1_7/RM_IHPSG13_1P_BITKIT_CELL_1/BLT_BOT VDD
+ RM_IHPSG13_1P_BITKIT_CELL_2x1_2/RM_IHPSG13_1P_BITKIT_CELL_1/RWL VDD VSS VSS RM_IHPSG13_1P_BITKIT_CELL_2x1_4/RM_IHPSG13_1P_BITKIT_CELL_0/BLC_BOT
+ A_LWL<13> RM_IHPSG13_1P_BITKIT_CELL_2x1
XRM_IHPSG13_1P_BITKIT_CELL_2x1_15 RM_IHPSG13_1P_BITKIT_CELL_2x1_6/RM_IHPSG13_1P_BITKIT_CELL_0/BLT_BOT
+ A_BLC_BOT<0> RM_IHPSG13_1P_BITKIT_CELL_2x1_0/RM_IHPSG13_1P_BITKIT_CELL_0/RWL A_LWL<0>
+ A_BLT_BOT<0> VDD RM_IHPSG13_1P_BITKIT_CELL_2x1_0/RM_IHPSG13_1P_BITKIT_CELL_1/RWL
+ VDD VSS VSS RM_IHPSG13_1P_BITKIT_CELL_2x1_6/RM_IHPSG13_1P_BITKIT_CELL_0/BLC_BOT
+ A_LWL<1> RM_IHPSG13_1P_BITKIT_CELL_2x1
XRM_IHPSG13_1P_BITKIT_CELL_2x1_0 RM_IHPSG13_1P_BITKIT_CELL_2x1_0/RM_IHPSG13_1P_BITKIT_CELL_0/BLT_BOT
+ A_BLC_BOT<1> RM_IHPSG13_1P_BITKIT_CELL_2x1_0/RM_IHPSG13_1P_BITKIT_CELL_0/RWL A_RWL<0>
+ A_BLT_BOT<1> VDD RM_IHPSG13_1P_BITKIT_CELL_2x1_0/RM_IHPSG13_1P_BITKIT_CELL_1/RWL
+ VDD VSS VSS RM_IHPSG13_1P_BITKIT_CELL_2x1_0/RM_IHPSG13_1P_BITKIT_CELL_0/BLC_BOT
+ A_RWL<1> RM_IHPSG13_1P_BITKIT_CELL_2x1
XRM_IHPSG13_1P_BITKIT_CELL_2x1_1 RM_IHPSG13_1P_BITKIT_CELL_2x1_9/RM_IHPSG13_1P_BITKIT_CELL_0/BLT_BOT
+ RM_IHPSG13_1P_BITKIT_CELL_2x1_1/RM_IHPSG13_1P_BITKIT_CELL_1/BLC_BOT RM_IHPSG13_1P_BITKIT_CELL_2x1_1/RM_IHPSG13_1P_BITKIT_CELL_0/RWL
+ A_RWL<4> RM_IHPSG13_1P_BITKIT_CELL_2x1_1/RM_IHPSG13_1P_BITKIT_CELL_1/BLT_BOT VDD
+ RM_IHPSG13_1P_BITKIT_CELL_2x1_1/RM_IHPSG13_1P_BITKIT_CELL_1/RWL VDD VSS VSS RM_IHPSG13_1P_BITKIT_CELL_2x1_9/RM_IHPSG13_1P_BITKIT_CELL_0/BLC_BOT
+ A_RWL<5> RM_IHPSG13_1P_BITKIT_CELL_2x1
XRM_IHPSG13_1P_BITKIT_CELL_2x1_2 RM_IHPSG13_1P_BITKIT_CELL_2x1_2/RM_IHPSG13_1P_BITKIT_CELL_0/BLT_BOT
+ RM_IHPSG13_1P_BITKIT_CELL_2x1_8/RM_IHPSG13_1P_BITKIT_CELL_1/BLC_BOT RM_IHPSG13_1P_BITKIT_CELL_2x1_2/RM_IHPSG13_1P_BITKIT_CELL_0/RWL
+ A_RWL<12> RM_IHPSG13_1P_BITKIT_CELL_2x1_8/RM_IHPSG13_1P_BITKIT_CELL_1/BLT_BOT VDD
+ RM_IHPSG13_1P_BITKIT_CELL_2x1_2/RM_IHPSG13_1P_BITKIT_CELL_1/RWL VDD VSS VSS RM_IHPSG13_1P_BITKIT_CELL_2x1_2/RM_IHPSG13_1P_BITKIT_CELL_0/BLC_BOT
+ A_RWL<13> RM_IHPSG13_1P_BITKIT_CELL_2x1
.ends

.subckt RM_IHPSG13_1P_COLUMN_256 RM_IHPSG13_1P_BITKIT_16x2_SRAM_0[0]/A_BLT_BOT<0>
+ RM_IHPSG13_1P_BITKIT_16x2_SRAM_3[1]/A_LWL<10> RM_IHPSG13_1P_BITKIT_16x2_SRAM_3[0]/A_LWL<13>
+ RM_IHPSG13_1P_BITKIT_16x2_SRAM_0[0]/A_BLT_BOT<1> RM_IHPSG13_1P_BITKIT_16x2_SRAM_1[2]/A_LWL<9>
+ RM_IHPSG13_1P_BITKIT_16x2_SRAM_0[0]/A_BLC_BOT<0> RM_IHPSG13_1P_BITKIT_16x2_SRAM_3[2]/A_LWL<8>
+ RM_IHPSG13_1P_BITKIT_16x2_SRAM_0[3]/A_RWL<11> RM_IHPSG13_1P_BITKIT_16x2_SRAM_2[3]/A_RWL<5>
+ RM_IHPSG13_1P_BITKIT_16x2_SRAM_0[0]/A_BLC_BOT<1> RM_IHPSG13_1P_BITKIT_16x2_SRAM_1[3]/A_LWL<0>
+ RM_IHPSG13_1P_BITKIT_16x2_SRAM_3[1]/A_LWL<13> RM_IHPSG13_1P_BITKIT_16x2_SRAM_1[3]/A_LWL<3>
+ RM_IHPSG13_1P_BITKIT_16x2_SRAM_1[3]/A_RWL<9> RM_IHPSG13_1P_BITKIT_16x2_SRAM_2[3]/A_LWL<1>
+ RM_IHPSG13_1P_BITKIT_16x2_SRAM_0[0]/A_RWL<1> RM_IHPSG13_1P_BITKIT_16x2_SRAM_0[3]/A_LWL<6>
+ RM_IHPSG13_1P_BITKIT_16x2_SRAM_2[3]/A_RWL<7> RM_IHPSG13_1P_BITKIT_16x2_SRAM_3[2]/A_LWL<13>
+ RM_IHPSG13_1P_BITKIT_16x2_SRAM_2[3]/A_LWL<2> RM_IHPSG13_1P_BITKIT_16x2_SRAM_3[3]/A_LWL<5>
+ RM_IHPSG13_1P_BITKIT_16x2_SRAM_0[2]/A_RWL<14> RM_IHPSG13_1P_BITKIT_16x2_SRAM_0[3]/A_LWL<8>
+ RM_IHPSG13_1P_BITKIT_16x2_SRAM_3[3]/A_LWL<11> RM_IHPSG13_1P_BITKIT_16x2_SRAM_3[0]/A_RWL<12>
+ RM_IHPSG13_1P_BITKIT_16x2_SRAM_3[1]/A_RWL<10> RM_IHPSG13_1P_BITKIT_16x2_SRAM_0[3]/A_RWL<7>
+ RM_IHPSG13_1P_BITKIT_16x2_SRAM_0[3]/A_LWL<2> RM_IHPSG13_1P_BITKIT_16x2_SRAM_3[0]/A_RWL<14>
+ RM_IHPSG13_1P_BITKIT_16x2_SRAM_1[0]/A_RWL<4> RM_IHPSG13_1P_BITKIT_16x2_SRAM_3[2]/A_LWL<11>
+ RM_IHPSG13_1P_BITKIT_16x2_SRAM_3[2]/A_LWL<14> RM_IHPSG13_1P_BITKIT_16x2_SRAM_2[0]/A_LWL<15>
+ RM_IHPSG13_1P_BITKIT_16x2_SRAM_0[0]/A_RWL<5> RM_IHPSG13_1P_BITKIT_16x2_SRAM_2[3]/A_LWL<7>
+ RM_IHPSG13_1P_BITKIT_16x2_SRAM_1[3]/A_LWL<9> RM_IHPSG13_1P_BITKIT_16x2_SRAM_2[1]/A_LWL<12>
+ RM_IHPSG13_1P_BITKIT_16x2_SRAM_0[3]/A_LWL<4> RM_IHPSG13_1P_BITKIT_16x2_SRAM_3[3]/A_LWL<13>
+ RM_IHPSG13_1P_BITKIT_16x2_SRAM_3[1]/A_RWL<12> RM_IHPSG13_1P_BITKIT_16x2_SRAM_0[0]/A_RWL<2>
+ RM_IHPSG13_1P_BITKIT_16x2_SRAM_0[3]/A_RWL<14> RM_IHPSG13_1P_BITKIT_16x2_SRAM_3[0]/A_RWL<10>
+ RM_IHPSG13_1P_BITKIT_16x2_SRAM_2[0]/A_RWL<3> RM_IHPSG13_1P_BITKIT_16x2_SRAM_3[3]/A_RWL<8>
+ RM_IHPSG13_1P_BITKIT_16x2_SRAM_0[0]/A_RWL<6> RM_IHPSG13_1P_BITKIT_16x2_SRAM_3[3]/A_LWL<8>
+ RM_IHPSG13_1P_BITKIT_16x2_SRAM_2[0]/A_RWL<0> RM_IHPSG13_1P_BITKIT_16x2_SRAM_0[0]/A_LWL<1>
+ RM_IHPSG13_1P_BITKIT_16x2_SRAM_3[0]/A_RWL<4> RM_IHPSG13_1P_BITKIT_16x2_SRAM_2[0]/A_RWL<5>
+ RM_IHPSG13_1P_BITKIT_16x2_SRAM_3[3]/A_LWL<14> RM_IHPSG13_1P_BITKIT_16x2_SRAM_3[1]/A_LWL<11>
+ RM_IHPSG13_1P_BITKIT_16x2_SRAM_2[0]/A_LWL<0> RM_IHPSG13_1P_BITKIT_16x2_SRAM_3[2]/A_RWL<10>
+ RM_IHPSG13_1P_BITKIT_16x2_SRAM_1[3]/A_LWL<5> RM_IHPSG13_1P_BITKIT_16x2_SRAM_3[1]/A_LWL<14>
+ RM_IHPSG13_1P_BITKIT_16x2_SRAM_0[3]/A_LWL<7> RM_IHPSG13_1P_BITKIT_16x2_SRAM_1[2]/A_LWL<8>
+ RM_IHPSG13_1P_BITKIT_16x2_SRAM_3[3]/A_LWL<4> RM_IHPSG13_1P_BITKIT_16x2_SRAM_2[2]/A_LWL<7>
+ RM_IHPSG13_1P_BITKIT_16x2_SRAM_0[3]/A_RWL<13> RM_IHPSG13_1P_BITKIT_16x2_SRAM_1[0]/A_LWL<10>
+ RM_IHPSG13_1P_BITKIT_16x2_SRAM_3[0]/A_RWL<2> RM_IHPSG13_1P_BITKIT_16x2_SRAM_2[0]/A_RWL<6>
+ RM_IHPSG13_1P_BITKIT_16x2_SRAM_3[1]/A_RWL<14> RM_IHPSG13_1P_BITKIT_16x2_SRAM_1[3]/A_RWL<8>
+ RM_IHPSG13_1P_BITKIT_16x2_SRAM_0[0]/A_RWL<8> RM_IHPSG13_1P_BITKIT_16x2_SRAM_0[0]/A_RWL<0>
+ RM_IHPSG13_1P_BITKIT_16x2_SRAM_3[3]/A_RWL<6> RM_IHPSG13_1P_BITKIT_16x2_SRAM_2[1]/A_LWL<15>
+ RM_IHPSG13_1P_BITKIT_16x2_SRAM_2[3]/A_RWL<4> RM_IHPSG13_1P_BITKIT_16x2_SRAM_2[0]/A_RWL<7>
+ RM_IHPSG13_1P_BITKIT_16x2_SRAM_2[2]/A_LWL<9> RM_IHPSG13_1P_BITKIT_16x2_SRAM_2[2]/A_LWL<12>
+ RM_IHPSG13_1P_BITKIT_16x2_SRAM_0[1]/A_RWL<0> RM_IHPSG13_1P_BITKIT_16x2_SRAM_3[0]/A_LWL<1>
+ RM_IHPSG13_1P_BITKIT_16x2_SRAM_2[0]/A_RWL<11> RM_IHPSG13_1P_BITKIT_16x2_SRAM_2[0]/A_LWL<2>
+ RM_IHPSG13_1P_BITKIT_16x2_SRAM_3[2]/A_RWL<12> RM_IHPSG13_1P_BITKIT_16x2_SRAM_3[0]/A_LWL<14>
+ RM_IHPSG13_1P_BITKIT_16x2_SRAM_1[0]/A_LWL<3> RM_IHPSG13_1P_BITKIT_16x2_SRAM_0[0]/A_LWL<4>
+ RM_IHPSG13_1P_BITKIT_16x2_SRAM_0[2]/A_RWL<13> RM_IHPSG13_1P_BITKIT_16x2_SRAM_1[0]/A_RWL<9>
+ RM_IHPSG13_1P_BITKIT_16x2_SRAM_1[3]/A_LWL<8> RM_IHPSG13_1P_BITKIT_16x2_SRAM_3[1]/A_LWL<12>
+ RM_IHPSG13_1P_BITKIT_16x2_SRAM_0[0]/A_RWL<7> RM_IHPSG13_1P_BITKIT_16x2_SRAM_1[3]/A_RWL<6>
+ RM_IHPSG13_1P_BITKIT_16x2_SRAM_1[0]/A_LWL<4> RM_IHPSG13_1P_BITKIT_16x2_SRAM_0[0]/A_LWL<2>
+ RM_IHPSG13_1P_BITKIT_16x2_SRAM_3[0]/A_RWL<15> RM_IHPSG13_1P_BITKIT_16x2_SRAM_3[3]/A_RWL<10>
+ RM_IHPSG13_1P_BITKIT_16x2_SRAM_2[1]/A_RWL<0> RM_IHPSG13_1P_BITKIT_16x2_SRAM_1[0]/A_LWL<13>
+ RM_IHPSG13_1P_BITKIT_16x2_SRAM_1[0]/A_LWL<11> RM_IHPSG13_1P_BITKIT_16x2_SRAM_2[3]/A_LWL<10>
+ RM_IHPSG13_1P_BITKIT_16x2_SRAM_1[1]/A_LWL<10> RM_IHPSG13_1P_BITKIT_16x2_SRAM_0[1]/A_RWL<2>
+ RM_IHPSG13_1P_BITKIT_16x2_SRAM_3[0]/A_LWL<3> RM_IHPSG13_1P_BITKIT_16x2_SRAM_0[3]/A_LWL<1>
+ RM_IHPSG13_1P_BITKIT_16x2_SRAM_3[2]/A_RWL<14> RM_IHPSG13_1P_BITKIT_16x2_SRAM_2[3]/A_LWL<0>
+ RM_IHPSG13_1P_BITKIT_16x2_SRAM_1[0]/A_LWL<5> RM_IHPSG13_1P_BITKIT_16x2_SRAM_3[3]/A_RWL<11>
+ RM_IHPSG13_1P_BITKIT_16x2_SRAM_3[3]/A_LWL<6> RM_IHPSG13_1P_BITKIT_16x2_SRAM_0[0]/A_LWL<6>
+ RM_IHPSG13_1P_BITKIT_16x2_SRAM_3[0]/A_RWL<9> RM_IHPSG13_1P_BITKIT_16x2_SRAM_2[3]/A_LWL<9>
+ RM_IHPSG13_1P_BITKIT_16x2_SRAM_1[0]/A_LWL<14> RM_IHPSG13_1P_BITKIT_16x2_SRAM_2[0]/A_RWL<13>
+ RM_IHPSG13_1P_BITKIT_16x2_SRAM_2[2]/A_LWL<15> RM_IHPSG13_1P_BITKIT_16x2_SRAM_1[1]/A_LWL<11>
+ RM_IHPSG13_1P_BITKIT_16x2_SRAM_3[0]/A_LWL<4> RM_IHPSG13_1P_BITKIT_16x2_SRAM_3[0]/A_RWL<8>
+ RM_IHPSG13_1P_BITKIT_16x2_SRAM_2[3]/A_LWL<12> RM_IHPSG13_1P_BITKIT_16x2_SRAM_2[0]/A_LWL<5>
+ RM_IHPSG13_1P_BITKIT_16x2_SRAM_1[1]/A_RWL<1> RM_IHPSG13_1P_BITKIT_16x2_SRAM_2[1]/A_RWL<11>
+ RM_IHPSG13_1P_BITKIT_16x2_SRAM_3[1]/A_RWL<1> RM_IHPSG13_1P_BITKIT_16x2_SRAM_3[0]/A_RWL<1>
+ RM_IHPSG13_1P_BITKIT_16x2_SRAM_3[3]/A_RWL<12> RM_IHPSG13_1P_BITKIT_16x2_SRAM_2[1]/A_RWL<2>
+ RM_IHPSG13_1P_BITKIT_16x2_SRAM_1[1]/A_RWL<3> RM_IHPSG13_1P_BITKIT_16x2_SRAM_3[3]/A_LWL<1>
+ RM_IHPSG13_1P_BITKIT_16x2_SRAM_2[2]/A_LWL<10> RM_IHPSG13_1P_BITKIT_16x2_SRAM_3[2]/A_LWL<12>
+ RM_IHPSG13_1P_BITKIT_16x2_SRAM_2[0]/A_RWL<15> RM_IHPSG13_1P_BITKIT_16x2_SRAM_2[0]/A_LWL<6>
+ RM_IHPSG13_1P_BITKIT_16x2_SRAM_3[2]/A_RWL<11> RM_IHPSG13_1P_BITKIT_16x2_SRAM_3[1]/A_RWL<15>
+ RM_IHPSG13_1P_BITKIT_16x2_SRAM_0[0]/A_LWL<7> RM_IHPSG13_1P_BITKIT_16x2_SRAM_1[3]/A_LWL<6>
+ RM_IHPSG13_1P_BITKIT_16x2_SRAM_3[1]/A_RWL<2> RM_IHPSG13_1P_BITKIT_16x2_SRAM_2[1]/A_RWL<3>
+ RM_IHPSG13_1P_BITKIT_16x2_SRAM_2[3]/A_LWL<3> RM_IHPSG13_1P_BITKIT_16x2_SRAM_1[1]/A_RWL<4>
+ RM_IHPSG13_1P_BITKIT_16x2_SRAM_0[0]/A_LWL<0> RM_IHPSG13_1P_BITKIT_16x2_SRAM_1[1]/A_LWL<13>
+ RM_IHPSG13_1P_BITKIT_16x2_SRAM_1[0]/A_RWL<8> RM_IHPSG13_1P_BITKIT_16x2_SRAM_0[1]/A_RWL<5>
+ RM_IHPSG13_1P_BITKIT_16x2_SRAM_2[3]/A_RWL<9> RM_IHPSG13_1P_BITKIT_16x2_SRAM_2[0]/A_LWL<7>
+ RM_IHPSG13_1P_BITKIT_16x2_SRAM_1[2]/A_LWL<10> RM_IHPSG13_1P_BITKIT_16x2_SRAM_1[0]/A_RWL<1>
+ RM_IHPSG13_1P_BITKIT_16x2_SRAM_2[1]/A_RWL<13> RM_IHPSG13_1P_BITKIT_16x2_SRAM_3[0]/A_RWL<6>
+ RM_IHPSG13_1P_BITKIT_16x2_SRAM_1[0]/A_LWL<8> RM_IHPSG13_1P_BITKIT_16x2_SRAM_0[2]/A_RWL<15>
+ RM_IHPSG13_1P_BITKIT_16x2_SRAM_3[3]/A_LWL<15> RM_IHPSG13_1P_BITKIT_16x2_SRAM_0[1]/A_RWL<4>
+ RM_IHPSG13_1P_BITKIT_16x2_SRAM_3[3]/A_RWL<14> RM_IHPSG13_1P_BITKIT_16x2_SRAM_0[0]/A_LWL<9>
+ RM_IHPSG13_1P_BITKIT_16x2_SRAM_2[1]/A_RWL<4> RM_IHPSG13_1P_BITKIT_16x2_SRAM_2[0]/A_RWL<4>
+ RM_IHPSG13_1P_BITKIT_16x2_SRAM_3[3]/A_RWL<5> RM_IHPSG13_1P_BITKIT_16x2_SRAM_2[1]/A_LWL<10>
+ RM_IHPSG13_1P_BITKIT_16x2_SRAM_1[1]/A_LWL<14> RM_IHPSG13_1P_BITKIT_16x2_SRAM_0[1]/A_RWL<6>
+ RM_IHPSG13_1P_BITKIT_16x2_SRAM_2[3]/A_LWL<15> RM_IHPSG13_1P_BITKIT_16x2_SRAM_2[0]/A_LWL<8>
+ RM_IHPSG13_1P_BITKIT_16x2_SRAM_3[1]/A_RWL<11> RM_IHPSG13_1P_BITKIT_16x2_SRAM_1[2]/A_LWL<11>
+ RM_IHPSG13_1P_BITKIT_16x2_SRAM_0[1]/A_LWL<1> RM_IHPSG13_1P_BITKIT_16x2_SRAM_1[0]/A_RWL<10>
+ RM_IHPSG13_1P_BITKIT_16x2_SRAM_1[0]/A_LWL<1> RM_IHPSG13_1P_BITKIT_16x2_SRAM_0[3]/A_LWL<3>
+ RM_IHPSG13_1P_BITKIT_16x2_SRAM_2[1]/A_RWL<5> RM_IHPSG13_1P_BITKIT_16x2_SRAM_3[0]/A_LWL<0>
+ RM_IHPSG13_1P_BITKIT_16x2_SRAM_2[2]/A_RWL<11> RM_IHPSG13_1P_BITKIT_16x2_SRAM_3[3]/A_LWL<12>
+ RM_IHPSG13_1P_BITKIT_16x2_SRAM_1[1]/A_RWL<6> RM_IHPSG13_1P_BITKIT_16x2_SRAM_0[3]/A_RWL<9>
+ RM_IHPSG13_1P_BITKIT_16x2_SRAM_2[1]/A_LWL<0> RM_IHPSG13_1P_BITKIT_16x2_SRAM_0[1]/A_RWL<7>
+ RM_IHPSG13_1P_BITKIT_16x2_SRAM_3[2]/A_RWL<15> RM_IHPSG13_1P_BITKIT_16x2_SRAM_2[0]/A_LWL<9>
+ RM_IHPSG13_1P_BITKIT_16x2_SRAM_1[0]/A_RWL<6> RM_IHPSG13_1P_BITKIT_16x2_SRAM_2[1]/A_RWL<15>
+ RM_IHPSG13_1P_BITKIT_16x2_SRAM_0[1]/A_LWL<2> RM_IHPSG13_1P_BITKIT_16x2_SRAM_3[2]/A_LWL<15>
+ RM_IHPSG13_1P_BITKIT_16x2_SRAM_0[0]/A_RWL<4> RM_IHPSG13_1P_BITKIT_16x2_SRAM_1[3]/A_RWL<5>
+ RM_IHPSG13_1P_BITKIT_16x2_SRAM_0[1]/A_LWL<0> RM_IHPSG13_1P_BITKIT_16x2_SRAM_2[0]/A_LWL<10>
+ RM_IHPSG13_1P_BITKIT_16x2_SRAM_3[0]/A_LWL<9> RM_IHPSG13_1P_BITKIT_16x2_SRAM_0[0]/A_LWL<12>
+ RM_IHPSG13_1P_BITKIT_16x2_SRAM_0[0]/A_RWL<3> RM_IHPSG13_1P_BITKIT_16x2_SRAM_0[3]/A_RWL<15>
+ RM_IHPSG13_1P_BITKIT_16x2_SRAM_3[0]/A_RWL<11> RM_IHPSG13_1P_BITKIT_16x2_SRAM_1[2]/A_LWL<13>
+ RM_IHPSG13_1P_BITKIT_16x2_SRAM_1[0]/A_RWL<12> RM_IHPSG13_1P_BITKIT_16x2_SRAM_3[1]/A_RWL<6>
+ RM_IHPSG13_1P_BITKIT_16x2_SRAM_3[0]/A_LWL<6> RM_IHPSG13_1P_BITKIT_16x2_SRAM_2[1]/A_RWL<7>
+ RM_IHPSG13_1P_BITKIT_16x2_SRAM_2[2]/A_RWL<13> RM_IHPSG13_1P_BITKIT_16x2_SRAM_0[2]/A_RWL<0>
+ RM_IHPSG13_1P_BITKIT_16x2_SRAM_3[1]/A_LWL<1> RM_IHPSG13_1P_BITKIT_16x2_SRAM_1[1]/A_RWL<8>
+ RM_IHPSG13_1P_BITKIT_16x2_SRAM_2[1]/A_LWL<2> RM_IHPSG13_1P_BITKIT_16x2_SRAM_1[1]/A_LWL<3>
+ RM_IHPSG13_1P_BITKIT_16x2_SRAM_1[1]/A_LWL<1> RM_IHPSG13_1P_BITKIT_16x2_SRAM_1[2]/A_LWL<14>
+ RM_IHPSG13_1P_BITKIT_16x2_SRAM_1[0]/A_LWL<12> RM_IHPSG13_1P_BITKIT_16x2_SRAM_0[1]/A_LWL<10>
+ RM_IHPSG13_1P_BITKIT_16x2_SRAM_0[1]/A_LWL<4> RM_IHPSG13_1P_BITKIT_16x2_SRAM_1[3]/A_LWL<4>
+ RM_IHPSG13_1P_BITKIT_16x2_SRAM_3[1]/A_LWL<0> RM_IHPSG13_1P_BITKIT_16x2_SRAM_3[1]/A_LWL<15>
+ RM_IHPSG13_1P_BITKIT_16x2_SRAM_1[3]/A_LWL<11> RM_IHPSG13_1P_BITKIT_16x2_SRAM_1[0]/A_RWL<2>
+ RM_IHPSG13_1P_BITKIT_16x2_SRAM_1[1]/A_RWL<10> RM_IHPSG13_1P_BITKIT_16x2_SRAM_3[1]/A_RWL<5>
+ RM_IHPSG13_1P_BITKIT_16x2_SRAM_0[0]/A_LWL<10> RM_IHPSG13_1P_BITKIT_16x2_SRAM_0[3]/A_RWL<12>
+ RM_IHPSG13_1P_BITKIT_16x2_SRAM_3[0]/A_RWL<3> RM_IHPSG13_1P_BITKIT_16x2_SRAM_1[1]/A_RWL<9>
+ RM_IHPSG13_1P_BITKIT_16x2_SRAM_3[3]/A_RWL<15> RM_IHPSG13_1P_BITKIT_16x2_SRAM_2[2]/A_RWL<12>
+ RM_IHPSG13_1P_BITKIT_16x2_SRAM_2[1]/A_LWL<3> RM_IHPSG13_1P_BITKIT_16x2_SRAM_1[0]/A_RWL<11>
+ RM_IHPSG13_1P_BITKIT_16x2_SRAM_2[3]/A_RWL<10> RM_IHPSG13_1P_BITKIT_16x2_SRAM_1[1]/A_LWL<4>
+ RM_IHPSG13_1P_BITKIT_16x2_SRAM_1[2]/A_LWL<15> RM_IHPSG13_1P_BITKIT_16x2_SRAM_2[2]/A_RWL<0>
+ RM_IHPSG13_1P_BITKIT_16x2_SRAM_1[0]/A_LWL<6> RM_IHPSG13_1P_BITKIT_16x2_SRAM_1[0]/A_RWL<14>
+ RM_IHPSG13_1P_BITKIT_16x2_SRAM_3[1]/A_RWL<8> RM_IHPSG13_1P_BITKIT_16x2_SRAM_3[3]/A_RWL<7>
+ RM_IHPSG13_1P_BITKIT_16x2_SRAM_1[2]/A_RWL<1> RM_IHPSG13_1P_BITKIT_16x2_SRAM_0[1]/A_LWL<3>
+ RM_IHPSG13_1P_BITKIT_16x2_SRAM_2[1]/A_RWL<9> RM_IHPSG13_1P_BITKIT_16x2_SRAM_2[2]/A_RWL<15>
+ RM_IHPSG13_1P_BITKIT_16x2_SRAM_1[1]/A_RWL<11> RM_IHPSG13_1P_BITKIT_16x2_SRAM_2[0]/A_LWL<3>
+ RM_IHPSG13_1P_BITKIT_16x2_SRAM_0[2]/A_RWL<2> RM_IHPSG13_1P_BITKIT_16x2_SRAM_3[1]/A_LWL<3>
+ RM_IHPSG13_1P_BITKIT_16x2_SRAM_0[2]/A_LWL<9> RM_IHPSG13_1P_BITKIT_16x2_SRAM_2[0]/A_LWL<13>
+ RM_IHPSG13_1P_BITKIT_16x2_SRAM_3[3]/A_LWL<2> RM_IHPSG13_1P_BITKIT_16x2_SRAM_0[1]/A_RWL<3>
+ RM_IHPSG13_1P_BITKIT_16x2_SRAM_0[1]/A_RWL<9> RM_IHPSG13_1P_BITKIT_16x2_SRAM_2[3]/A_RWL<12>
+ RM_IHPSG13_1P_BITKIT_16x2_SRAM_2[3]/A_LWL<5> RM_IHPSG13_1P_BITKIT_16x2_SRAM_2[2]/A_LWL<8>
+ RM_IHPSG13_1P_BITKIT_16x2_SRAM_0[0]/A_LWL<15> RM_IHPSG13_1P_BITKIT_16x2_SRAM_2[0]/A_RWL<9>
+ RM_IHPSG13_1P_BITKIT_16x2_SRAM_1[1]/A_LWL<5> RM_IHPSG13_1P_BITKIT_16x2_SRAM_3[2]/A_RWL<0>
+ RM_IHPSG13_1P_BITKIT_16x2_SRAM_1[1]/A_LWL<15> RM_IHPSG13_1P_BITKIT_16x2_SRAM_0[1]/A_LWL<12>
+ RM_IHPSG13_1P_BITKIT_16x2_SRAM_0[1]/A_LWL<6> RM_IHPSG13_1P_BITKIT_16x2_SRAM_3[0]/A_LWL<15>
+ RM_IHPSG13_1P_BITKIT_16x2_SRAM_3[1]/A_RWL<9> RM_IHPSG13_1P_BITKIT_16x2_SRAM_1[3]/A_LWL<13>
+ RM_IHPSG13_1P_BITKIT_16x2_SRAM_1[1]/A_RWL<5> RM_IHPSG13_1P_BITKIT_16x2_SRAM_1[1]/A_RWL<12>
+ RM_IHPSG13_1P_BITKIT_16x2_SRAM_3[0]/A_RWL<5> RM_IHPSG13_1P_BITKIT_16x2_SRAM_3[1]/A_LWL<4>
+ RM_IHPSG13_1P_BITKIT_16x2_SRAM_2[3]/A_RWL<13> RM_IHPSG13_1P_BITKIT_16x2_SRAM_2[1]/A_RWL<12>
+ RM_IHPSG13_1P_BITKIT_16x2_SRAM_2[1]/A_LWL<5> RM_IHPSG13_1P_BITKIT_16x2_SRAM_0[3]/A_RWL<10>
+ RM_IHPSG13_1P_BITKIT_16x2_SRAM_1[1]/A_LWL<12> RM_IHPSG13_1P_BITKIT_16x2_SRAM_2[2]/A_RWL<10>
+ RM_IHPSG13_1P_BITKIT_16x2_SRAM_1[1]/A_LWL<6> RM_IHPSG13_1P_BITKIT_16x2_SRAM_3[2]/A_RWL<1>
+ RM_IHPSG13_1P_BITKIT_16x2_SRAM_0[1]/A_LWL<13> RM_IHPSG13_1P_BITKIT_16x2_SRAM_1[3]/A_RWL<7>
+ RM_IHPSG13_1P_BITKIT_16x2_SRAM_0[1]/A_LWL<7> RM_IHPSG13_1P_BITKIT_16x2_SRAM_2[2]/A_RWL<2>
+ RM_IHPSG13_1P_BITKIT_16x2_SRAM_1[1]/A_RWL<2> RM_IHPSG13_1P_BITKIT_16x2_SRAM_1[2]/A_RWL<0>
+ RM_IHPSG13_1P_BITKIT_16x2_SRAM_1[0]/A_RWL<15> RM_IHPSG13_1P_BITKIT_16x2_SRAM_3[2]/A_LWL<9>
+ RM_IHPSG13_1P_BITKIT_16x2_SRAM_1[3]/A_LWL<14> RM_IHPSG13_1P_BITKIT_16x2_SRAM_3[1]/A_RWL<0>
+ RM_IHPSG13_1P_BITKIT_16x2_SRAM_3[1]/A_RWL<3> RM_IHPSG13_1P_BITKIT_16x2_SRAM_0[0]/A_LWL<3>
+ RM_IHPSG13_1P_BITKIT_16x2_SRAM_1[2]/A_RWL<3> RM_IHPSG13_1P_BITKIT_16x2_SRAM_0[2]/A_LWL<10>
+ RM_IHPSG13_1P_BITKIT_16x2_SRAM_1[3]/A_LWL<2> RM_IHPSG13_1P_BITKIT_16x2_SRAM_0[2]/A_RWL<4>
+ RM_IHPSG13_1P_BITKIT_16x2_SRAM_0[0]/A_RWL<9> RM_IHPSG13_1P_BITKIT_16x2_SRAM_2[1]/A_LWL<6>
+ RM_IHPSG13_1P_BITKIT_16x2_SRAM_1[2]/A_RWL<10> RM_IHPSG13_1P_BITKIT_16x2_SRAM_2[3]/A_LWL<11>
+ RM_IHPSG13_1P_BITKIT_16x2_SRAM_3[2]/A_RWL<2> RM_IHPSG13_1P_BITKIT_16x2_SRAM_1[0]/A_LWL<15>
+ RM_IHPSG13_1P_BITKIT_16x2_SRAM_0[3]/A_LWL<0> RM_IHPSG13_1P_BITKIT_16x2_SRAM_2[3]/A_LWL<14>
+ RM_IHPSG13_1P_BITKIT_16x2_SRAM_2[2]/A_RWL<3> RM_IHPSG13_1P_BITKIT_16x2_SRAM_0[0]/A_LWL<5>
+ RM_IHPSG13_1P_BITKIT_16x2_SRAM_1[3]/A_LWL<15> RM_IHPSG13_1P_BITKIT_16x2_SRAM_1[0]/A_RWL<5>
+ RM_IHPSG13_1P_BITKIT_16x2_SRAM_2[1]/A_LWL<13> RM_IHPSG13_1P_BITKIT_16x2_SRAM_0[3]/A_LWL<9>
+ RM_IHPSG13_1P_BITKIT_16x2_SRAM_0[2]/A_RWL<3> RM_IHPSG13_1P_BITKIT_16x2_SRAM_3[3]/A_LWL<7>
+ RM_IHPSG13_1P_BITKIT_16x2_SRAM_2[0]/A_LWL<4> RM_IHPSG13_1P_BITKIT_16x2_SRAM_1[1]/A_RWL<14>
+ RM_IHPSG13_1P_BITKIT_16x2_SRAM_0[2]/A_RWL<5> RM_IHPSG13_1P_BITKIT_16x2_SRAM_2[3]/A_LWL<8>
+ RM_IHPSG13_1P_BITKIT_16x2_SRAM_3[1]/A_LWL<6> RM_IHPSG13_1P_BITKIT_16x2_SRAM_2[0]/A_RWL<12>
+ RM_IHPSG13_1P_BITKIT_16x2_SRAM_2[3]/A_RWL<15> RM_IHPSG13_1P_BITKIT_16x2_SRAM_1[2]/A_RWL<11>
+ RM_IHPSG13_1P_BITKIT_16x2_SRAM_2[1]/A_LWL<7> RM_IHPSG13_1P_BITKIT_16x2_SRAM_2[0]/A_RWL<14>
+ RM_IHPSG13_1P_BITKIT_16x2_SRAM_3[3]/A_RWL<13> RM_IHPSG13_1P_BITKIT_16x2_SRAM_0[2]/A_LWL<0>
+ RM_IHPSG13_1P_BITKIT_16x2_SRAM_2[1]/A_RWL<10> RM_IHPSG13_1P_BITKIT_16x2_SRAM_1[1]/A_LWL<8>
+ RM_IHPSG13_1P_BITKIT_16x2_SRAM_0[1]/A_LWL<15> RM_IHPSG13_1P_BITKIT_16x2_SRAM_0[1]/A_LWL<9>
+ RM_IHPSG13_1P_BITKIT_16x2_SRAM_2[2]/A_RWL<4> RM_IHPSG13_1P_BITKIT_16x2_SRAM_1[1]/A_RWL<0>
+ RM_IHPSG13_1P_BITKIT_16x2_SRAM_3[1]/A_RWL<7> RM_IHPSG13_1P_BITKIT_16x2_SRAM_3[0]/A_RWL<0>
+ RM_IHPSG13_1P_BITKIT_16x2_SRAM_1[2]/A_RWL<5> RM_IHPSG13_1P_BITKIT_16x2_SRAM_0[2]/A_LWL<12>
+ RM_IHPSG13_1P_BITKIT_16x2_SRAM_0[0]/A_RWL<11> RM_IHPSG13_1P_BITKIT_16x2_SRAM_1[3]/A_LWL<1>
+ RM_IHPSG13_1P_BITKIT_16x2_SRAM_3[1]/A_LWL<2> RM_IHPSG13_1P_BITKIT_16x2_SRAM_1[2]/A_LWL<12>
+ RM_IHPSG13_1P_BITKIT_16x2_SRAM_1[2]/A_LWL<0> RM_IHPSG13_1P_BITKIT_16x2_SRAM_3[3]/A_LWL<0>
+ RM_IHPSG13_1P_BITKIT_16x2_SRAM_1[2]/A_RWL<12> RM_IHPSG13_1P_BITKIT_16x2_SRAM_2[1]/A_LWL<8>
+ RM_IHPSG13_1P_BITKIT_16x2_SRAM_2[2]/A_LWL<11> RM_IHPSG13_1P_BITKIT_16x2_SRAM_0[2]/A_LWL<1>
+ RM_IHPSG13_1P_BITKIT_16x2_SRAM_1[2]/A_RWL<2> RM_IHPSG13_1P_BITKIT_16x2_SRAM_3[0]/A_LWL<5>
+ RM_IHPSG13_1P_BITKIT_16x2_SRAM_1[1]/A_RWL<15> RM_IHPSG13_1P_BITKIT_16x2_SRAM_3[3]/A_LWL<9>
+ RM_IHPSG13_1P_BITKIT_16x2_SRAM_2[2]/A_LWL<14> RM_IHPSG13_1P_BITKIT_16x2_SRAM_3[2]/A_RWL<3>
+ RM_IHPSG13_1P_BITKIT_16x2_SRAM_2[2]/A_RWL<5> RM_IHPSG13_1P_BITKIT_16x2_SRAM_1[3]/A_LWL<7>
+ RM_IHPSG13_1P_BITKIT_16x2_SRAM_1[2]/A_RWL<6> RM_IHPSG13_1P_BITKIT_16x2_SRAM_0[2]/A_LWL<13>
+ RM_IHPSG13_1P_BITKIT_16x2_SRAM_3[2]/A_LWL<7> RM_IHPSG13_1P_BITKIT_16x2_SRAM_2[2]/A_LWL<0>
+ RM_IHPSG13_1P_BITKIT_16x2_SRAM_0[0]/A_RWL<12> RM_IHPSG13_1P_BITKIT_16x2_SRAM_0[2]/A_RWL<7>
+ RM_IHPSG13_1P_BITKIT_16x2_SRAM_0[3]/A_LWL<10> RM_IHPSG13_1P_BITKIT_16x2_SRAM_1[2]/A_LWL<1>
+ RM_IHPSG13_1P_BITKIT_16x2_SRAM_3[2]/A_RWL<13> RM_IHPSG13_1P_BITKIT_16x2_SRAM_2[1]/A_LWL<9>
+ RM_IHPSG13_1P_BITKIT_16x2_SRAM_2[0]/A_RWL<10> RM_IHPSG13_1P_BITKIT_16x2_SRAM_0[2]/A_LWL<2>
+ RM_IHPSG13_1P_BITKIT_16x2_SRAM_2[3]/A_RWL<8> RM_IHPSG13_1P_BITKIT_16x2_SRAM_3[2]/A_RWL<5>
+ RM_IHPSG13_1P_BITKIT_16x2_SRAM_1[3]/A_RWL<10> RM_IHPSG13_1P_BITKIT_16x2_SRAM_0[1]/A_LWL<5>
+ RM_IHPSG13_1P_BITKIT_16x2_SRAM_0[0]/A_LWL<8> RM_IHPSG13_1P_BITKIT_16x2_SRAM_1[1]/A_RWL<7>
+ RM_IHPSG13_1P_BITKIT_16x2_SRAM_2[2]/A_LWL<13> RM_IHPSG13_1P_BITKIT_16x2_SRAM_1[0]/A_RWL<0>
+ RM_IHPSG13_1P_BITKIT_16x2_SRAM_2[1]/A_LWL<4> RM_IHPSG13_1P_BITKIT_16x2_SRAM_3[0]/A_RWL<7>
+ RM_IHPSG13_1P_BITKIT_16x2_SRAM_3[2]/A_LWL<0> RM_IHPSG13_1P_BITKIT_16x2_SRAM_1[2]/A_RWL<7>
+ RM_IHPSG13_1P_BITKIT_16x2_SRAM_1[1]/A_LWL<2> RM_IHPSG13_1P_BITKIT_16x2_SRAM_0[0]/A_RWL<13>
+ RM_IHPSG13_1P_BITKIT_16x2_SRAM_2[1]/A_RWL<14> RM_IHPSG13_1P_BITKIT_16x2_SRAM_2[2]/A_LWL<1>
+ RM_IHPSG13_1P_BITKIT_16x2_SRAM_3[1]/A_LWL<9> RM_IHPSG13_1P_BITKIT_16x2_SRAM_3[0]/A_LWL<2>
+ RM_IHPSG13_1P_BITKIT_16x2_SRAM_3[3]/A_RWL<4> RM_IHPSG13_1P_BITKIT_16x2_SRAM_0[2]/A_LWL<11>
+ RM_IHPSG13_1P_BITKIT_16x2_SRAM_0[3]/A_LWL<11> RM_IHPSG13_1P_BITKIT_16x2_SRAM_1[2]/A_LWL<2>
+ RM_IHPSG13_1P_BITKIT_16x2_SRAM_1[2]/A_RWL<14> RM_IHPSG13_1P_BITKIT_16x2_SRAM_2[1]/A_LWL<11>
+ RM_IHPSG13_1P_BITKIT_16x2_SRAM_0[1]/A_RWL<10> RM_IHPSG13_1P_BITKIT_16x2_SRAM_0[2]/A_LWL<3>
+ RM_IHPSG13_1P_BITKIT_16x2_SRAM_0[2]/A_LWL<14> RM_IHPSG13_1P_BITKIT_16x2_SRAM_3[2]/A_RWL<6>
+ RM_IHPSG13_1P_BITKIT_16x2_SRAM_1[3]/A_RWL<11> RM_IHPSG13_1P_BITKIT_16x2_SRAM_2[1]/A_LWL<14>
+ RM_IHPSG13_1P_BITKIT_16x2_SRAM_2[2]/A_RWL<7> RM_IHPSG13_1P_BITKIT_16x2_SRAM_0[3]/A_RWL<0>
+ RM_IHPSG13_1P_BITKIT_16x2_SRAM_1[0]/A_LWL<0> RM_IHPSG13_1P_BITKIT_16x2_SRAM_1[2]/A_RWL<8>
+ RM_IHPSG13_1P_BITKIT_16x2_SRAM_3[2]/A_LWL<1> RM_IHPSG13_1P_BITKIT_16x2_SRAM_0[2]/A_LWL<15>
+ RM_IHPSG13_1P_BITKIT_16x2_SRAM_1[3]/A_LWL<12> RM_IHPSG13_1P_BITKIT_16x2_SRAM_3[1]/A_LWL<7>
+ RM_IHPSG13_1P_BITKIT_16x2_SRAM_0[2]/A_RWL<9> RM_IHPSG13_1P_BITKIT_16x2_SRAM_0[0]/A_RWL<14>
+ RM_IHPSG13_1P_BITKIT_16x2_SRAM_2[2]/A_LWL<2> RM_IHPSG13_1P_BITKIT_16x2_SRAM_1[2]/A_RWL<13>
+ RM_IHPSG13_1P_BITKIT_16x2_SRAM_1[0]/A_LWL<9> RM_IHPSG13_1P_BITKIT_16x2_SRAM_0[3]/A_LWL<12>
+ RM_IHPSG13_1P_BITKIT_16x2_SRAM_1[2]/A_LWL<3> RM_IHPSG13_1P_BITKIT_16x2_SRAM_3[1]/A_RWL<13>
+ RM_IHPSG13_1P_BITKIT_16x2_SRAM_3[1]/A_LWL<5> RM_IHPSG13_1P_BITKIT_16x2_SRAM_0[0]/A_RWL<10>
+ RM_IHPSG13_1P_BITKIT_16x2_SRAM_0[3]/A_RWL<8> RM_IHPSG13_1P_BITKIT_16x2_SRAM_1[2]/A_RWL<15>
+ RM_IHPSG13_1P_BITKIT_16x2_SRAM_3[0]/A_LWL<8> RM_IHPSG13_1P_BITKIT_16x2_SRAM_0[1]/A_RWL<11>
+ RM_IHPSG13_1P_BITKIT_16x2_SRAM_3[3]/A_RWL<3> RM_IHPSG13_1P_BITKIT_16x2_SRAM_0[2]/A_LWL<4>
+ RM_IHPSG13_1P_BITKIT_16x2_SRAM_3[2]/A_RWL<7> RM_IHPSG13_1P_BITKIT_16x2_SRAM_1[3]/A_RWL<12>
+ RM_IHPSG13_1P_BITKIT_16x2_SRAM_1[0]/A_RWL<7> RM_IHPSG13_1P_BITKIT_16x2_SRAM_1[3]/A_RWL<0>
+ RM_IHPSG13_1P_BITKIT_16x2_SRAM_2[2]/A_RWL<8> RM_IHPSG13_1P_BITKIT_16x2_SRAM_2[3]/A_RWL<6>
+ RM_IHPSG13_1P_BITKIT_16x2_SRAM_2[2]/A_RWL<1> RM_IHPSG13_1P_BITKIT_16x2_SRAM_0[3]/A_RWL<1>
+ RM_IHPSG13_1P_BITKIT_16x2_SRAM_3[2]/A_LWL<2> RM_IHPSG13_1P_BITKIT_16x2_SRAM_1[2]/A_RWL<9>
+ RM_IHPSG13_1P_BITKIT_16x2_SRAM_1[0]/A_LWL<2> RM_IHPSG13_1P_BITKIT_16x2_SRAM_2[2]/A_LWL<3>
+ RM_IHPSG13_1P_BITKIT_16x2_SRAM_0[0]/A_RWL<15> RM_IHPSG13_1P_BITKIT_16x2_SRAM_0[1]/A_LWL<11>
+ RM_IHPSG13_1P_BITKIT_16x2_SRAM_3[2]/A_RWL<4> RM_IHPSG13_1P_BITKIT_16x2_SRAM_0[3]/A_LWL<13>
+ RM_IHPSG13_1P_BITKIT_16x2_SRAM_1[2]/A_LWL<4> RM_IHPSG13_1P_BITKIT_16x2_SRAM_2[0]/A_LWL<11>
+ RM_IHPSG13_1P_BITKIT_16x2_SRAM_0[1]/A_RWL<12> RM_IHPSG13_1P_BITKIT_16x2_SRAM_3[3]/A_LWL<10>
+ RM_IHPSG13_1P_BITKIT_16x2_SRAM_2[0]/A_LWL<1> RM_IHPSG13_1P_BITKIT_16x2_SRAM_0[1]/A_LWL<8>
+ RM_IHPSG13_1P_BITKIT_16x2_SRAM_0[1]/A_LWL<14> RM_IHPSG13_1P_BITKIT_16x2_SRAM_0[2]/A_LWL<5>
+ RM_IHPSG13_1P_BITKIT_16x2_SRAM_2[3]/A_RWL<0> RM_IHPSG13_1P_BITKIT_16x2_SRAM_2[3]/A_LWL<13>
+ RM_IHPSG13_1P_BITKIT_16x2_SRAM_3[2]/A_RWL<8> RM_IHPSG13_1P_BITKIT_16x2_SRAM_1[3]/A_RWL<13>
+ RM_IHPSG13_1P_BITKIT_16x2_SRAM_2[0]/A_LWL<14> RM_IHPSG13_1P_BITKIT_16x2_SRAM_1[3]/A_RWL<1>
+ RM_IHPSG13_1P_BITKIT_16x2_SRAM_2[2]/A_RWL<9> RM_IHPSG13_1P_BITKIT_16x2_SRAM_1[1]/A_LWL<7>
+ RM_IHPSG13_1P_BITKIT_16x2_SRAM_2[2]/A_RWL<14> RM_IHPSG13_1P_BITKIT_16x2_SRAM_0[3]/A_RWL<2>
+ RM_IHPSG13_1P_BITKIT_16x2_SRAM_3[2]/A_LWL<3> RM_IHPSG13_1P_BITKIT_16x2_SRAM_3[0]/A_LWL<7>
+ RM_IHPSG13_1P_BITKIT_16x2_SRAM_2[2]/A_LWL<4> RM_IHPSG13_1P_BITKIT_16x2_SRAM_1[1]/A_RWL<13>
+ RM_IHPSG13_1P_BITKIT_16x2_SRAM_0[3]/A_LWL<14> RM_IHPSG13_1P_BITKIT_16x2_SRAM_3[0]/A_RWL<13>
+ RM_IHPSG13_1P_BITKIT_16x2_SRAM_1[2]/A_LWL<5> RM_IHPSG13_1P_BITKIT_16x2_SRAM_3[3]/A_RWL<0>
+ RM_IHPSG13_1P_BITKIT_16x2_SRAM_0[2]/A_RWL<8> RM_IHPSG13_1P_BITKIT_16x2_SRAM_0[1]/A_RWL<13>
+ RM_IHPSG13_1P_BITKIT_16x2_SRAM_3[0]/A_LWL<10> RM_IHPSG13_1P_BITKIT_16x2_SRAM_2[1]/A_RWL<8>
+ RM_IHPSG13_1P_BITKIT_16x2_SRAM_0[2]/A_LWL<6> RM_IHPSG13_1P_BITKIT_16x2_SRAM_2[3]/A_RWL<1>
+ RM_IHPSG13_1P_BITKIT_16x2_SRAM_3[2]/A_RWL<9> RM_IHPSG13_1P_BITKIT_16x2_SRAM_0[3]/A_RWL<6>
+ RM_IHPSG13_1P_BITKIT_16x2_SRAM_1[3]/A_RWL<14> RM_IHPSG13_1P_BITKIT_16x2_SRAM_0[2]/A_RWL<1>
+ RM_IHPSG13_1P_BITKIT_16x2_SRAM_1[1]/A_LWL<0> RM_IHPSG13_1P_BITKIT_16x2_SRAM_0[2]/A_RWL<10>
+ RM_IHPSG13_1P_BITKIT_16x2_SRAM_1[3]/A_RWL<2> RM_IHPSG13_1P_BITKIT_16x2_SRAM_2[2]/A_RWL<6>
+ RM_IHPSG13_1P_BITKIT_16x2_SRAM_2[1]/A_RWL<1> RM_IHPSG13_1P_BITKIT_16x2_SRAM_0[3]/A_RWL<3>
+ RM_IHPSG13_1P_BITKIT_16x2_SRAM_3[2]/A_LWL<4> RM_IHPSG13_1P_BITKIT_16x2_SRAM_1[1]/A_LWL<9>
+ RM_IHPSG13_1P_BITKIT_16x2_SRAM_1[2]/A_RWL<4> RM_IHPSG13_1P_BITKIT_16x2_SRAM_1[0]/A_RWL<3>
+ RM_IHPSG13_1P_BITKIT_16x2_SRAM_2[2]/A_LWL<5> RM_IHPSG13_1P_BITKIT_16x2_SRAM_3[1]/A_LWL<8>
+ RM_IHPSG13_1P_BITKIT_16x2_SRAM_0[0]/A_LWL<11> RM_IHPSG13_1P_BITKIT_16x2_SRAM_3[1]/A_RWL<4>
+ RM_IHPSG13_1P_BITKIT_16x2_SRAM_0[3]/A_LWL<15> RM_IHPSG13_1P_BITKIT_16x2_SRAM_1[3]/A_LWL<10>
+ RM_IHPSG13_1P_BITKIT_16x2_SRAM_1[2]/A_LWL<6> RM_IHPSG13_1P_BITKIT_16x2_SRAM_3[3]/A_RWL<1>
+ RM_IHPSG13_1P_BITKIT_16x2_SRAM_0[1]/A_RWL<14> RM_IHPSG13_1P_BITKIT_16x2_SRAM_3[2]/A_LWL<10>
+ RM_IHPSG13_1P_BITKIT_16x2_SRAM_3[0]/A_LWL<11> RM_IHPSG13_1P_BITKIT_16x2_SRAM_0[0]/A_LWL<14>
+ RM_IHPSG13_1P_BITKIT_16x2_SRAM_0[2]/A_LWL<7> RM_IHPSG13_1P_BITKIT_16x2_SRAM_2[3]/A_RWL<2>
+ RM_IHPSG13_1P_BITKIT_16x2_SRAM_2[3]/A_RWL<11> RM_IHPSG13_1P_BITKIT_16x2_SRAM_1[3]/A_RWL<15>
+ RM_IHPSG13_1P_BITKIT_16x2_SRAM_0[2]/A_RWL<11> RM_IHPSG13_1P_BITKIT_16x2_SRAM_1[3]/A_RWL<3>
+ RM_IHPSG13_1P_BITKIT_16x2_SRAM_1[0]/A_LWL<7> RM_IHPSG13_1P_BITKIT_16x2_SRAM_0[3]/A_RWL<4>
+ RM_IHPSG13_1P_BITKIT_16x2_SRAM_2[3]/A_LWL<6> RM_IHPSG13_1P_BITKIT_16x2_SRAM_3[2]/A_LWL<5>
+ RM_IHPSG13_1P_BITKIT_16x2_SRAM_0[0]/A_LWL<13> RM_IHPSG13_1P_BITKIT_16x2_SRAM_2[2]/A_LWL<6>
+ RM_IHPSG13_1P_BITKIT_16x2_SRAM_1[0]/A_RWL<13> RM_IHPSG13_1P_BITKIT_16x2_SRAM_2[1]/A_LWL<1>
+ RM_IHPSG13_1P_BITKIT_16x2_SRAM_0[3]/A_LWL<5> RM_IHPSG13_1P_BITKIT_16x2_SRAM_2[0]/A_LWL<12>
+ RM_IHPSG13_1P_BITKIT_16x2_SRAM_3[3]/A_LWL<3> RM_IHPSG13_1P_BITKIT_16x2_SRAM_1[2]/A_LWL<7>
+ RM_IHPSG13_1P_BITKIT_16x2_SRAM_3[3]/A_RWL<2> RM_IHPSG13_1P_BITKIT_16x2_SRAM_0[1]/A_RWL<8>
+ RM_IHPSG13_1P_BITKIT_16x2_SRAM_2[3]/A_LWL<4> RM_IHPSG13_1P_BITKIT_16x2_SRAM_0[1]/A_RWL<15>
+ RM_IHPSG13_1P_BITKIT_16x2_SRAM_3[0]/A_LWL<12> RM_IHPSG13_1P_BITKIT_16x2_SRAM_2[0]/A_RWL<8>
+ RM_IHPSG13_1P_BITKIT_16x2_SRAM_0[2]/A_LWL<8> RM_IHPSG13_1P_BITKIT_16x2_SRAM_2[3]/A_RWL<3>
+ RM_IHPSG13_1P_BITKIT_16x2_SRAM_2[0]/A_RWL<2> RM_IHPSG13_1P_BITKIT_16x2_SRAM_3[3]/A_RWL<9>
+ RM_IHPSG13_1P_BITKIT_16x2_SRAM_0[2]/A_RWL<6> RM_IHPSG13_1P_BITKIT_16x2_SRAM_0[1]/A_RWL<1>
+ RM_IHPSG13_1P_BITKIT_16x2_SRAM_2[3]/A_RWL<14> RM_IHPSG13_1P_BITKIT_16x2_SRAM_0[2]/A_RWL<12>
+ RM_IHPSG13_1P_BITKIT_16x2_SRAM_1[3]/A_RWL<4> RM_IHPSG13_1P_BITKIT_16x2_SRAM_2[1]/A_RWL<6>
+ RM_IHPSG13_1P_BITKIT_16x2_SRAM_2[0]/A_RWL<1> RM_IHPSG13_1P_BITKIT_16x2_SRAM_3[3]/VSS
+ RM_IHPSG13_1P_BITKIT_16x2_SRAM_3[3]/VDD RM_IHPSG13_1P_BITKIT_16x2_SRAM_0[3]/A_RWL<5>
+ RM_IHPSG13_1P_BITKIT_16x2_SRAM_3[2]/A_LWL<6>
XRM_IHPSG13_1P_BITKIT_16x2_SRAM_0[0] RM_IHPSG13_1P_BITKIT_16x2_SRAM_2[1]/A_BLT_BOT<0>
+ RM_IHPSG13_1P_BITKIT_16x2_SRAM_0[0]/A_BLT_BOT<0> RM_IHPSG13_1P_BITKIT_16x2_SRAM_2[1]/A_BLC_BOT<0>
+ RM_IHPSG13_1P_BITKIT_16x2_SRAM_0[0]/A_BLC_BOT<0> RM_IHPSG13_1P_BITKIT_16x2_SRAM_2[1]/A_BLC_BOT<1>
+ RM_IHPSG13_1P_BITKIT_16x2_SRAM_0[0]/A_BLC_BOT<1> RM_IHPSG13_1P_BITKIT_16x2_SRAM_2[1]/A_BLT_BOT<1>
+ RM_IHPSG13_1P_BITKIT_16x2_SRAM_0[0]/A_BLT_BOT<1> RM_IHPSG13_1P_BITKIT_16x2_SRAM_0[0]/A_RWL<2>
+ RM_IHPSG13_1P_BITKIT_16x2_SRAM_0[0]/A_RWL<4> RM_IHPSG13_1P_BITKIT_16x2_SRAM_0[0]/A_RWL<5>
+ RM_IHPSG13_1P_BITKIT_16x2_SRAM_0[0]/A_RWL<7> RM_IHPSG13_1P_BITKIT_16x2_SRAM_0[0]/A_RWL<0>
+ RM_IHPSG13_1P_BITKIT_16x2_SRAM_0[0]/A_RWL<15> RM_IHPSG13_1P_BITKIT_16x2_SRAM_0[0]/A_RWL<13>
+ RM_IHPSG13_1P_BITKIT_16x2_SRAM_0[0]/A_RWL<12> RM_IHPSG13_1P_BITKIT_16x2_SRAM_0[0]/A_RWL<10>
+ RM_IHPSG13_1P_BITKIT_16x2_SRAM_0[0]/A_LWL<0> RM_IHPSG13_1P_BITKIT_16x2_SRAM_0[0]/A_LWL<1>
+ RM_IHPSG13_1P_BITKIT_16x2_SRAM_0[0]/A_LWL<2> RM_IHPSG13_1P_BITKIT_16x2_SRAM_0[0]/A_LWL<7>
+ RM_IHPSG13_1P_BITKIT_16x2_SRAM_0[0]/A_LWL<9> RM_IHPSG13_1P_BITKIT_16x2_SRAM_0[0]/A_LWL<10>
+ RM_IHPSG13_1P_BITKIT_16x2_SRAM_0[0]/A_LWL<12> RM_IHPSG13_1P_BITKIT_16x2_SRAM_0[0]/A_LWL<15>
+ RM_IHPSG13_1P_BITKIT_16x2_SRAM_0[0]/A_RWL<3> RM_IHPSG13_1P_BITKIT_16x2_SRAM_0[0]/A_LWL<3>
+ RM_IHPSG13_1P_BITKIT_16x2_SRAM_0[0]/A_RWL<9> RM_IHPSG13_1P_BITKIT_16x2_SRAM_0[0]/A_LWL<5>
+ RM_IHPSG13_1P_BITKIT_16x2_SRAM_0[0]/A_LWL<8> RM_IHPSG13_1P_BITKIT_16x2_SRAM_0[0]/A_LWL<11>
+ RM_IHPSG13_1P_BITKIT_16x2_SRAM_0[0]/A_LWL<14> RM_IHPSG13_1P_BITKIT_16x2_SRAM_0[0]/A_RWL<8>
+ RM_IHPSG13_1P_BITKIT_16x2_SRAM_0[0]/A_RWL<1> RM_IHPSG13_1P_BITKIT_16x2_SRAM_0[0]/A_LWL<13>
+ RM_IHPSG13_1P_BITKIT_16x2_SRAM_0[0]/A_RWL<6> RM_IHPSG13_1P_BITKIT_16x2_SRAM_0[0]/A_LWL<4>
+ RM_IHPSG13_1P_BITKIT_16x2_SRAM_0[0]/A_RWL<14> RM_IHPSG13_1P_BITKIT_16x2_SRAM_3[3]/VSS
+ RM_IHPSG13_1P_BITKIT_16x2_SRAM_0[0]/A_RWL<11> RM_IHPSG13_1P_BITKIT_16x2_SRAM_0[0]/A_LWL<6>
+ RM_IHPSG13_1P_BITKIT_16x2_SRAM_3[3]/VDD RM_IHPSG13_1P_BITKIT_16x2_SRAM
XRM_IHPSG13_1P_BITKIT_16x2_SRAM_0[1] RM_IHPSG13_1P_BITKIT_16x2_SRAM_2[2]/A_BLT_BOT<0>
+ RM_IHPSG13_1P_BITKIT_16x2_SRAM_2[1]/A_BLT_BOT<0> RM_IHPSG13_1P_BITKIT_16x2_SRAM_2[2]/A_BLC_BOT<0>
+ RM_IHPSG13_1P_BITKIT_16x2_SRAM_2[1]/A_BLC_BOT<0> RM_IHPSG13_1P_BITKIT_16x2_SRAM_2[2]/A_BLC_BOT<1>
+ RM_IHPSG13_1P_BITKIT_16x2_SRAM_2[1]/A_BLC_BOT<1> RM_IHPSG13_1P_BITKIT_16x2_SRAM_2[2]/A_BLT_BOT<1>
+ RM_IHPSG13_1P_BITKIT_16x2_SRAM_2[1]/A_BLT_BOT<1> RM_IHPSG13_1P_BITKIT_16x2_SRAM_0[1]/A_RWL<2>
+ RM_IHPSG13_1P_BITKIT_16x2_SRAM_0[1]/A_RWL<4> RM_IHPSG13_1P_BITKIT_16x2_SRAM_0[1]/A_RWL<5>
+ RM_IHPSG13_1P_BITKIT_16x2_SRAM_0[1]/A_RWL<7> RM_IHPSG13_1P_BITKIT_16x2_SRAM_0[1]/A_RWL<0>
+ RM_IHPSG13_1P_BITKIT_16x2_SRAM_0[1]/A_RWL<15> RM_IHPSG13_1P_BITKIT_16x2_SRAM_0[1]/A_RWL<13>
+ RM_IHPSG13_1P_BITKIT_16x2_SRAM_0[1]/A_RWL<12> RM_IHPSG13_1P_BITKIT_16x2_SRAM_0[1]/A_RWL<10>
+ RM_IHPSG13_1P_BITKIT_16x2_SRAM_0[1]/A_LWL<0> RM_IHPSG13_1P_BITKIT_16x2_SRAM_0[1]/A_LWL<1>
+ RM_IHPSG13_1P_BITKIT_16x2_SRAM_0[1]/A_LWL<2> RM_IHPSG13_1P_BITKIT_16x2_SRAM_0[1]/A_LWL<7>
+ RM_IHPSG13_1P_BITKIT_16x2_SRAM_0[1]/A_LWL<9> RM_IHPSG13_1P_BITKIT_16x2_SRAM_0[1]/A_LWL<10>
+ RM_IHPSG13_1P_BITKIT_16x2_SRAM_0[1]/A_LWL<12> RM_IHPSG13_1P_BITKIT_16x2_SRAM_0[1]/A_LWL<15>
+ RM_IHPSG13_1P_BITKIT_16x2_SRAM_0[1]/A_RWL<3> RM_IHPSG13_1P_BITKIT_16x2_SRAM_0[1]/A_LWL<3>
+ RM_IHPSG13_1P_BITKIT_16x2_SRAM_0[1]/A_RWL<9> RM_IHPSG13_1P_BITKIT_16x2_SRAM_0[1]/A_LWL<5>
+ RM_IHPSG13_1P_BITKIT_16x2_SRAM_0[1]/A_LWL<8> RM_IHPSG13_1P_BITKIT_16x2_SRAM_0[1]/A_LWL<11>
+ RM_IHPSG13_1P_BITKIT_16x2_SRAM_0[1]/A_LWL<14> RM_IHPSG13_1P_BITKIT_16x2_SRAM_0[1]/A_RWL<8>
+ RM_IHPSG13_1P_BITKIT_16x2_SRAM_0[1]/A_RWL<1> RM_IHPSG13_1P_BITKIT_16x2_SRAM_0[1]/A_LWL<13>
+ RM_IHPSG13_1P_BITKIT_16x2_SRAM_0[1]/A_RWL<6> RM_IHPSG13_1P_BITKIT_16x2_SRAM_0[1]/A_LWL<4>
+ RM_IHPSG13_1P_BITKIT_16x2_SRAM_0[1]/A_RWL<14> RM_IHPSG13_1P_BITKIT_16x2_SRAM_3[3]/VSS
+ RM_IHPSG13_1P_BITKIT_16x2_SRAM_0[1]/A_RWL<11> RM_IHPSG13_1P_BITKIT_16x2_SRAM_0[1]/A_LWL<6>
+ RM_IHPSG13_1P_BITKIT_16x2_SRAM_3[3]/VDD RM_IHPSG13_1P_BITKIT_16x2_SRAM
XRM_IHPSG13_1P_BITKIT_16x2_SRAM_0[2] RM_IHPSG13_1P_BITKIT_16x2_SRAM_2[3]/A_BLT_BOT<0>
+ RM_IHPSG13_1P_BITKIT_16x2_SRAM_2[2]/A_BLT_BOT<0> RM_IHPSG13_1P_BITKIT_16x2_SRAM_2[3]/A_BLC_BOT<0>
+ RM_IHPSG13_1P_BITKIT_16x2_SRAM_2[2]/A_BLC_BOT<0> RM_IHPSG13_1P_BITKIT_16x2_SRAM_2[3]/A_BLC_BOT<1>
+ RM_IHPSG13_1P_BITKIT_16x2_SRAM_2[2]/A_BLC_BOT<1> RM_IHPSG13_1P_BITKIT_16x2_SRAM_2[3]/A_BLT_BOT<1>
+ RM_IHPSG13_1P_BITKIT_16x2_SRAM_2[2]/A_BLT_BOT<1> RM_IHPSG13_1P_BITKIT_16x2_SRAM_0[2]/A_RWL<2>
+ RM_IHPSG13_1P_BITKIT_16x2_SRAM_0[2]/A_RWL<4> RM_IHPSG13_1P_BITKIT_16x2_SRAM_0[2]/A_RWL<5>
+ RM_IHPSG13_1P_BITKIT_16x2_SRAM_0[2]/A_RWL<7> RM_IHPSG13_1P_BITKIT_16x2_SRAM_0[2]/A_RWL<0>
+ RM_IHPSG13_1P_BITKIT_16x2_SRAM_0[2]/A_RWL<15> RM_IHPSG13_1P_BITKIT_16x2_SRAM_0[2]/A_RWL<13>
+ RM_IHPSG13_1P_BITKIT_16x2_SRAM_0[2]/A_RWL<12> RM_IHPSG13_1P_BITKIT_16x2_SRAM_0[2]/A_RWL<10>
+ RM_IHPSG13_1P_BITKIT_16x2_SRAM_0[2]/A_LWL<0> RM_IHPSG13_1P_BITKIT_16x2_SRAM_0[2]/A_LWL<1>
+ RM_IHPSG13_1P_BITKIT_16x2_SRAM_0[2]/A_LWL<2> RM_IHPSG13_1P_BITKIT_16x2_SRAM_0[2]/A_LWL<7>
+ RM_IHPSG13_1P_BITKIT_16x2_SRAM_0[2]/A_LWL<9> RM_IHPSG13_1P_BITKIT_16x2_SRAM_0[2]/A_LWL<10>
+ RM_IHPSG13_1P_BITKIT_16x2_SRAM_0[2]/A_LWL<12> RM_IHPSG13_1P_BITKIT_16x2_SRAM_0[2]/A_LWL<15>
+ RM_IHPSG13_1P_BITKIT_16x2_SRAM_0[2]/A_RWL<3> RM_IHPSG13_1P_BITKIT_16x2_SRAM_0[2]/A_LWL<3>
+ RM_IHPSG13_1P_BITKIT_16x2_SRAM_0[2]/A_RWL<9> RM_IHPSG13_1P_BITKIT_16x2_SRAM_0[2]/A_LWL<5>
+ RM_IHPSG13_1P_BITKIT_16x2_SRAM_0[2]/A_LWL<8> RM_IHPSG13_1P_BITKIT_16x2_SRAM_0[2]/A_LWL<11>
+ RM_IHPSG13_1P_BITKIT_16x2_SRAM_0[2]/A_LWL<14> RM_IHPSG13_1P_BITKIT_16x2_SRAM_0[2]/A_RWL<8>
+ RM_IHPSG13_1P_BITKIT_16x2_SRAM_0[2]/A_RWL<1> RM_IHPSG13_1P_BITKIT_16x2_SRAM_0[2]/A_LWL<13>
+ RM_IHPSG13_1P_BITKIT_16x2_SRAM_0[2]/A_RWL<6> RM_IHPSG13_1P_BITKIT_16x2_SRAM_0[2]/A_LWL<4>
+ RM_IHPSG13_1P_BITKIT_16x2_SRAM_0[2]/A_RWL<14> RM_IHPSG13_1P_BITKIT_16x2_SRAM_3[3]/VSS
+ RM_IHPSG13_1P_BITKIT_16x2_SRAM_0[2]/A_RWL<11> RM_IHPSG13_1P_BITKIT_16x2_SRAM_0[2]/A_LWL<6>
+ RM_IHPSG13_1P_BITKIT_16x2_SRAM_3[3]/VDD RM_IHPSG13_1P_BITKIT_16x2_SRAM
XRM_IHPSG13_1P_BITKIT_16x2_SRAM_0[3] RM_IHPSG13_1P_BITKIT_16x2_SRAM_1[0]/A_BLT_BOT<0>
+ RM_IHPSG13_1P_BITKIT_16x2_SRAM_2[3]/A_BLT_BOT<0> RM_IHPSG13_1P_BITKIT_16x2_SRAM_1[0]/A_BLC_BOT<0>
+ RM_IHPSG13_1P_BITKIT_16x2_SRAM_2[3]/A_BLC_BOT<0> RM_IHPSG13_1P_BITKIT_16x2_SRAM_1[0]/A_BLC_BOT<1>
+ RM_IHPSG13_1P_BITKIT_16x2_SRAM_2[3]/A_BLC_BOT<1> RM_IHPSG13_1P_BITKIT_16x2_SRAM_1[0]/A_BLT_BOT<1>
+ RM_IHPSG13_1P_BITKIT_16x2_SRAM_2[3]/A_BLT_BOT<1> RM_IHPSG13_1P_BITKIT_16x2_SRAM_0[3]/A_RWL<2>
+ RM_IHPSG13_1P_BITKIT_16x2_SRAM_0[3]/A_RWL<4> RM_IHPSG13_1P_BITKIT_16x2_SRAM_0[3]/A_RWL<5>
+ RM_IHPSG13_1P_BITKIT_16x2_SRAM_0[3]/A_RWL<7> RM_IHPSG13_1P_BITKIT_16x2_SRAM_0[3]/A_RWL<0>
+ RM_IHPSG13_1P_BITKIT_16x2_SRAM_0[3]/A_RWL<15> RM_IHPSG13_1P_BITKIT_16x2_SRAM_0[3]/A_RWL<13>
+ RM_IHPSG13_1P_BITKIT_16x2_SRAM_0[3]/A_RWL<12> RM_IHPSG13_1P_BITKIT_16x2_SRAM_0[3]/A_RWL<10>
+ RM_IHPSG13_1P_BITKIT_16x2_SRAM_0[3]/A_LWL<0> RM_IHPSG13_1P_BITKIT_16x2_SRAM_0[3]/A_LWL<1>
+ RM_IHPSG13_1P_BITKIT_16x2_SRAM_0[3]/A_LWL<2> RM_IHPSG13_1P_BITKIT_16x2_SRAM_0[3]/A_LWL<7>
+ RM_IHPSG13_1P_BITKIT_16x2_SRAM_0[3]/A_LWL<9> RM_IHPSG13_1P_BITKIT_16x2_SRAM_0[3]/A_LWL<10>
+ RM_IHPSG13_1P_BITKIT_16x2_SRAM_0[3]/A_LWL<12> RM_IHPSG13_1P_BITKIT_16x2_SRAM_0[3]/A_LWL<15>
+ RM_IHPSG13_1P_BITKIT_16x2_SRAM_0[3]/A_RWL<3> RM_IHPSG13_1P_BITKIT_16x2_SRAM_0[3]/A_LWL<3>
+ RM_IHPSG13_1P_BITKIT_16x2_SRAM_0[3]/A_RWL<9> RM_IHPSG13_1P_BITKIT_16x2_SRAM_0[3]/A_LWL<5>
+ RM_IHPSG13_1P_BITKIT_16x2_SRAM_0[3]/A_LWL<8> RM_IHPSG13_1P_BITKIT_16x2_SRAM_0[3]/A_LWL<11>
+ RM_IHPSG13_1P_BITKIT_16x2_SRAM_0[3]/A_LWL<14> RM_IHPSG13_1P_BITKIT_16x2_SRAM_0[3]/A_RWL<8>
+ RM_IHPSG13_1P_BITKIT_16x2_SRAM_0[3]/A_RWL<1> RM_IHPSG13_1P_BITKIT_16x2_SRAM_0[3]/A_LWL<13>
+ RM_IHPSG13_1P_BITKIT_16x2_SRAM_0[3]/A_RWL<6> RM_IHPSG13_1P_BITKIT_16x2_SRAM_0[3]/A_LWL<4>
+ RM_IHPSG13_1P_BITKIT_16x2_SRAM_0[3]/A_RWL<14> RM_IHPSG13_1P_BITKIT_16x2_SRAM_3[3]/VSS
+ RM_IHPSG13_1P_BITKIT_16x2_SRAM_0[3]/A_RWL<11> RM_IHPSG13_1P_BITKIT_16x2_SRAM_0[3]/A_LWL<6>
+ RM_IHPSG13_1P_BITKIT_16x2_SRAM_3[3]/VDD RM_IHPSG13_1P_BITKIT_16x2_SRAM
XRM_IHPSG13_1P_BITKIT_16x2_SRAM_1[0] RM_IHPSG13_1P_BITKIT_16x2_SRAM_2[1]/A_BLT_BOT<0>
+ RM_IHPSG13_1P_BITKIT_16x2_SRAM_1[0]/A_BLT_BOT<0> RM_IHPSG13_1P_BITKIT_16x2_SRAM_2[1]/A_BLC_BOT<0>
+ RM_IHPSG13_1P_BITKIT_16x2_SRAM_1[0]/A_BLC_BOT<0> RM_IHPSG13_1P_BITKIT_16x2_SRAM_2[1]/A_BLC_BOT<1>
+ RM_IHPSG13_1P_BITKIT_16x2_SRAM_1[0]/A_BLC_BOT<1> RM_IHPSG13_1P_BITKIT_16x2_SRAM_2[1]/A_BLT_BOT<1>
+ RM_IHPSG13_1P_BITKIT_16x2_SRAM_1[0]/A_BLT_BOT<1> RM_IHPSG13_1P_BITKIT_16x2_SRAM_1[0]/A_RWL<2>
+ RM_IHPSG13_1P_BITKIT_16x2_SRAM_1[0]/A_RWL<4> RM_IHPSG13_1P_BITKIT_16x2_SRAM_1[0]/A_RWL<5>
+ RM_IHPSG13_1P_BITKIT_16x2_SRAM_1[0]/A_RWL<7> RM_IHPSG13_1P_BITKIT_16x2_SRAM_1[0]/A_RWL<0>
+ RM_IHPSG13_1P_BITKIT_16x2_SRAM_1[0]/A_RWL<15> RM_IHPSG13_1P_BITKIT_16x2_SRAM_1[0]/A_RWL<13>
+ RM_IHPSG13_1P_BITKIT_16x2_SRAM_1[0]/A_RWL<12> RM_IHPSG13_1P_BITKIT_16x2_SRAM_1[0]/A_RWL<10>
+ RM_IHPSG13_1P_BITKIT_16x2_SRAM_1[0]/A_LWL<0> RM_IHPSG13_1P_BITKIT_16x2_SRAM_1[0]/A_LWL<1>
+ RM_IHPSG13_1P_BITKIT_16x2_SRAM_1[0]/A_LWL<2> RM_IHPSG13_1P_BITKIT_16x2_SRAM_1[0]/A_LWL<7>
+ RM_IHPSG13_1P_BITKIT_16x2_SRAM_1[0]/A_LWL<9> RM_IHPSG13_1P_BITKIT_16x2_SRAM_1[0]/A_LWL<10>
+ RM_IHPSG13_1P_BITKIT_16x2_SRAM_1[0]/A_LWL<12> RM_IHPSG13_1P_BITKIT_16x2_SRAM_1[0]/A_LWL<15>
+ RM_IHPSG13_1P_BITKIT_16x2_SRAM_1[0]/A_RWL<3> RM_IHPSG13_1P_BITKIT_16x2_SRAM_1[0]/A_LWL<3>
+ RM_IHPSG13_1P_BITKIT_16x2_SRAM_1[0]/A_RWL<9> RM_IHPSG13_1P_BITKIT_16x2_SRAM_1[0]/A_LWL<5>
+ RM_IHPSG13_1P_BITKIT_16x2_SRAM_1[0]/A_LWL<8> RM_IHPSG13_1P_BITKIT_16x2_SRAM_1[0]/A_LWL<11>
+ RM_IHPSG13_1P_BITKIT_16x2_SRAM_1[0]/A_LWL<14> RM_IHPSG13_1P_BITKIT_16x2_SRAM_1[0]/A_RWL<8>
+ RM_IHPSG13_1P_BITKIT_16x2_SRAM_1[0]/A_RWL<1> RM_IHPSG13_1P_BITKIT_16x2_SRAM_1[0]/A_LWL<13>
+ RM_IHPSG13_1P_BITKIT_16x2_SRAM_1[0]/A_RWL<6> RM_IHPSG13_1P_BITKIT_16x2_SRAM_1[0]/A_LWL<4>
+ RM_IHPSG13_1P_BITKIT_16x2_SRAM_1[0]/A_RWL<14> RM_IHPSG13_1P_BITKIT_16x2_SRAM_3[3]/VSS
+ RM_IHPSG13_1P_BITKIT_16x2_SRAM_1[0]/A_RWL<11> RM_IHPSG13_1P_BITKIT_16x2_SRAM_1[0]/A_LWL<6>
+ RM_IHPSG13_1P_BITKIT_16x2_SRAM_3[3]/VDD RM_IHPSG13_1P_BITKIT_16x2_SRAM
XRM_IHPSG13_1P_BITKIT_16x2_SRAM_1[1] RM_IHPSG13_1P_BITKIT_16x2_SRAM_2[2]/A_BLT_BOT<0>
+ RM_IHPSG13_1P_BITKIT_16x2_SRAM_2[1]/A_BLT_BOT<0> RM_IHPSG13_1P_BITKIT_16x2_SRAM_2[2]/A_BLC_BOT<0>
+ RM_IHPSG13_1P_BITKIT_16x2_SRAM_2[1]/A_BLC_BOT<0> RM_IHPSG13_1P_BITKIT_16x2_SRAM_2[2]/A_BLC_BOT<1>
+ RM_IHPSG13_1P_BITKIT_16x2_SRAM_2[1]/A_BLC_BOT<1> RM_IHPSG13_1P_BITKIT_16x2_SRAM_2[2]/A_BLT_BOT<1>
+ RM_IHPSG13_1P_BITKIT_16x2_SRAM_2[1]/A_BLT_BOT<1> RM_IHPSG13_1P_BITKIT_16x2_SRAM_1[1]/A_RWL<2>
+ RM_IHPSG13_1P_BITKIT_16x2_SRAM_1[1]/A_RWL<4> RM_IHPSG13_1P_BITKIT_16x2_SRAM_1[1]/A_RWL<5>
+ RM_IHPSG13_1P_BITKIT_16x2_SRAM_1[1]/A_RWL<7> RM_IHPSG13_1P_BITKIT_16x2_SRAM_1[1]/A_RWL<0>
+ RM_IHPSG13_1P_BITKIT_16x2_SRAM_1[1]/A_RWL<15> RM_IHPSG13_1P_BITKIT_16x2_SRAM_1[1]/A_RWL<13>
+ RM_IHPSG13_1P_BITKIT_16x2_SRAM_1[1]/A_RWL<12> RM_IHPSG13_1P_BITKIT_16x2_SRAM_1[1]/A_RWL<10>
+ RM_IHPSG13_1P_BITKIT_16x2_SRAM_1[1]/A_LWL<0> RM_IHPSG13_1P_BITKIT_16x2_SRAM_1[1]/A_LWL<1>
+ RM_IHPSG13_1P_BITKIT_16x2_SRAM_1[1]/A_LWL<2> RM_IHPSG13_1P_BITKIT_16x2_SRAM_1[1]/A_LWL<7>
+ RM_IHPSG13_1P_BITKIT_16x2_SRAM_1[1]/A_LWL<9> RM_IHPSG13_1P_BITKIT_16x2_SRAM_1[1]/A_LWL<10>
+ RM_IHPSG13_1P_BITKIT_16x2_SRAM_1[1]/A_LWL<12> RM_IHPSG13_1P_BITKIT_16x2_SRAM_1[1]/A_LWL<15>
+ RM_IHPSG13_1P_BITKIT_16x2_SRAM_1[1]/A_RWL<3> RM_IHPSG13_1P_BITKIT_16x2_SRAM_1[1]/A_LWL<3>
+ RM_IHPSG13_1P_BITKIT_16x2_SRAM_1[1]/A_RWL<9> RM_IHPSG13_1P_BITKIT_16x2_SRAM_1[1]/A_LWL<5>
+ RM_IHPSG13_1P_BITKIT_16x2_SRAM_1[1]/A_LWL<8> RM_IHPSG13_1P_BITKIT_16x2_SRAM_1[1]/A_LWL<11>
+ RM_IHPSG13_1P_BITKIT_16x2_SRAM_1[1]/A_LWL<14> RM_IHPSG13_1P_BITKIT_16x2_SRAM_1[1]/A_RWL<8>
+ RM_IHPSG13_1P_BITKIT_16x2_SRAM_1[1]/A_RWL<1> RM_IHPSG13_1P_BITKIT_16x2_SRAM_1[1]/A_LWL<13>
+ RM_IHPSG13_1P_BITKIT_16x2_SRAM_1[1]/A_RWL<6> RM_IHPSG13_1P_BITKIT_16x2_SRAM_1[1]/A_LWL<4>
+ RM_IHPSG13_1P_BITKIT_16x2_SRAM_1[1]/A_RWL<14> RM_IHPSG13_1P_BITKIT_16x2_SRAM_3[3]/VSS
+ RM_IHPSG13_1P_BITKIT_16x2_SRAM_1[1]/A_RWL<11> RM_IHPSG13_1P_BITKIT_16x2_SRAM_1[1]/A_LWL<6>
+ RM_IHPSG13_1P_BITKIT_16x2_SRAM_3[3]/VDD RM_IHPSG13_1P_BITKIT_16x2_SRAM
XRM_IHPSG13_1P_BITKIT_16x2_SRAM_1[2] RM_IHPSG13_1P_BITKIT_16x2_SRAM_2[3]/A_BLT_BOT<0>
+ RM_IHPSG13_1P_BITKIT_16x2_SRAM_2[2]/A_BLT_BOT<0> RM_IHPSG13_1P_BITKIT_16x2_SRAM_2[3]/A_BLC_BOT<0>
+ RM_IHPSG13_1P_BITKIT_16x2_SRAM_2[2]/A_BLC_BOT<0> RM_IHPSG13_1P_BITKIT_16x2_SRAM_2[3]/A_BLC_BOT<1>
+ RM_IHPSG13_1P_BITKIT_16x2_SRAM_2[2]/A_BLC_BOT<1> RM_IHPSG13_1P_BITKIT_16x2_SRAM_2[3]/A_BLT_BOT<1>
+ RM_IHPSG13_1P_BITKIT_16x2_SRAM_2[2]/A_BLT_BOT<1> RM_IHPSG13_1P_BITKIT_16x2_SRAM_1[2]/A_RWL<2>
+ RM_IHPSG13_1P_BITKIT_16x2_SRAM_1[2]/A_RWL<4> RM_IHPSG13_1P_BITKIT_16x2_SRAM_1[2]/A_RWL<5>
+ RM_IHPSG13_1P_BITKIT_16x2_SRAM_1[2]/A_RWL<7> RM_IHPSG13_1P_BITKIT_16x2_SRAM_1[2]/A_RWL<0>
+ RM_IHPSG13_1P_BITKIT_16x2_SRAM_1[2]/A_RWL<15> RM_IHPSG13_1P_BITKIT_16x2_SRAM_1[2]/A_RWL<13>
+ RM_IHPSG13_1P_BITKIT_16x2_SRAM_1[2]/A_RWL<12> RM_IHPSG13_1P_BITKIT_16x2_SRAM_1[2]/A_RWL<10>
+ RM_IHPSG13_1P_BITKIT_16x2_SRAM_1[2]/A_LWL<0> RM_IHPSG13_1P_BITKIT_16x2_SRAM_1[2]/A_LWL<1>
+ RM_IHPSG13_1P_BITKIT_16x2_SRAM_1[2]/A_LWL<2> RM_IHPSG13_1P_BITKIT_16x2_SRAM_1[2]/A_LWL<7>
+ RM_IHPSG13_1P_BITKIT_16x2_SRAM_1[2]/A_LWL<9> RM_IHPSG13_1P_BITKIT_16x2_SRAM_1[2]/A_LWL<10>
+ RM_IHPSG13_1P_BITKIT_16x2_SRAM_1[2]/A_LWL<12> RM_IHPSG13_1P_BITKIT_16x2_SRAM_1[2]/A_LWL<15>
+ RM_IHPSG13_1P_BITKIT_16x2_SRAM_1[2]/A_RWL<3> RM_IHPSG13_1P_BITKIT_16x2_SRAM_1[2]/A_LWL<3>
+ RM_IHPSG13_1P_BITKIT_16x2_SRAM_1[2]/A_RWL<9> RM_IHPSG13_1P_BITKIT_16x2_SRAM_1[2]/A_LWL<5>
+ RM_IHPSG13_1P_BITKIT_16x2_SRAM_1[2]/A_LWL<8> RM_IHPSG13_1P_BITKIT_16x2_SRAM_1[2]/A_LWL<11>
+ RM_IHPSG13_1P_BITKIT_16x2_SRAM_1[2]/A_LWL<14> RM_IHPSG13_1P_BITKIT_16x2_SRAM_1[2]/A_RWL<8>
+ RM_IHPSG13_1P_BITKIT_16x2_SRAM_1[2]/A_RWL<1> RM_IHPSG13_1P_BITKIT_16x2_SRAM_1[2]/A_LWL<13>
+ RM_IHPSG13_1P_BITKIT_16x2_SRAM_1[2]/A_RWL<6> RM_IHPSG13_1P_BITKIT_16x2_SRAM_1[2]/A_LWL<4>
+ RM_IHPSG13_1P_BITKIT_16x2_SRAM_1[2]/A_RWL<14> RM_IHPSG13_1P_BITKIT_16x2_SRAM_3[3]/VSS
+ RM_IHPSG13_1P_BITKIT_16x2_SRAM_1[2]/A_RWL<11> RM_IHPSG13_1P_BITKIT_16x2_SRAM_1[2]/A_LWL<6>
+ RM_IHPSG13_1P_BITKIT_16x2_SRAM_3[3]/VDD RM_IHPSG13_1P_BITKIT_16x2_SRAM
XRM_IHPSG13_1P_BITKIT_16x2_SRAM_1[3] RM_IHPSG13_1P_BITKIT_16x2_SRAM_2[0]/A_BLT_BOT<0>
+ RM_IHPSG13_1P_BITKIT_16x2_SRAM_2[3]/A_BLT_BOT<0> RM_IHPSG13_1P_BITKIT_16x2_SRAM_2[0]/A_BLC_BOT<0>
+ RM_IHPSG13_1P_BITKIT_16x2_SRAM_2[3]/A_BLC_BOT<0> RM_IHPSG13_1P_BITKIT_16x2_SRAM_2[0]/A_BLC_BOT<1>
+ RM_IHPSG13_1P_BITKIT_16x2_SRAM_2[3]/A_BLC_BOT<1> RM_IHPSG13_1P_BITKIT_16x2_SRAM_2[0]/A_BLT_BOT<1>
+ RM_IHPSG13_1P_BITKIT_16x2_SRAM_2[3]/A_BLT_BOT<1> RM_IHPSG13_1P_BITKIT_16x2_SRAM_1[3]/A_RWL<2>
+ RM_IHPSG13_1P_BITKIT_16x2_SRAM_1[3]/A_RWL<4> RM_IHPSG13_1P_BITKIT_16x2_SRAM_1[3]/A_RWL<5>
+ RM_IHPSG13_1P_BITKIT_16x2_SRAM_1[3]/A_RWL<7> RM_IHPSG13_1P_BITKIT_16x2_SRAM_1[3]/A_RWL<0>
+ RM_IHPSG13_1P_BITKIT_16x2_SRAM_1[3]/A_RWL<15> RM_IHPSG13_1P_BITKIT_16x2_SRAM_1[3]/A_RWL<13>
+ RM_IHPSG13_1P_BITKIT_16x2_SRAM_1[3]/A_RWL<12> RM_IHPSG13_1P_BITKIT_16x2_SRAM_1[3]/A_RWL<10>
+ RM_IHPSG13_1P_BITKIT_16x2_SRAM_1[3]/A_LWL<0> RM_IHPSG13_1P_BITKIT_16x2_SRAM_1[3]/A_LWL<1>
+ RM_IHPSG13_1P_BITKIT_16x2_SRAM_1[3]/A_LWL<2> RM_IHPSG13_1P_BITKIT_16x2_SRAM_1[3]/A_LWL<7>
+ RM_IHPSG13_1P_BITKIT_16x2_SRAM_1[3]/A_LWL<9> RM_IHPSG13_1P_BITKIT_16x2_SRAM_1[3]/A_LWL<10>
+ RM_IHPSG13_1P_BITKIT_16x2_SRAM_1[3]/A_LWL<12> RM_IHPSG13_1P_BITKIT_16x2_SRAM_1[3]/A_LWL<15>
+ RM_IHPSG13_1P_BITKIT_16x2_SRAM_1[3]/A_RWL<3> RM_IHPSG13_1P_BITKIT_16x2_SRAM_1[3]/A_LWL<3>
+ RM_IHPSG13_1P_BITKIT_16x2_SRAM_1[3]/A_RWL<9> RM_IHPSG13_1P_BITKIT_16x2_SRAM_1[3]/A_LWL<5>
+ RM_IHPSG13_1P_BITKIT_16x2_SRAM_1[3]/A_LWL<8> RM_IHPSG13_1P_BITKIT_16x2_SRAM_1[3]/A_LWL<11>
+ RM_IHPSG13_1P_BITKIT_16x2_SRAM_1[3]/A_LWL<14> RM_IHPSG13_1P_BITKIT_16x2_SRAM_1[3]/A_RWL<8>
+ RM_IHPSG13_1P_BITKIT_16x2_SRAM_1[3]/A_RWL<1> RM_IHPSG13_1P_BITKIT_16x2_SRAM_1[3]/A_LWL<13>
+ RM_IHPSG13_1P_BITKIT_16x2_SRAM_1[3]/A_RWL<6> RM_IHPSG13_1P_BITKIT_16x2_SRAM_1[3]/A_LWL<4>
+ RM_IHPSG13_1P_BITKIT_16x2_SRAM_1[3]/A_RWL<14> RM_IHPSG13_1P_BITKIT_16x2_SRAM_3[3]/VSS
+ RM_IHPSG13_1P_BITKIT_16x2_SRAM_1[3]/A_RWL<11> RM_IHPSG13_1P_BITKIT_16x2_SRAM_1[3]/A_LWL<6>
+ RM_IHPSG13_1P_BITKIT_16x2_SRAM_3[3]/VDD RM_IHPSG13_1P_BITKIT_16x2_SRAM
XRM_IHPSG13_1P_BITKIT_16x2_SRAM_2[0] RM_IHPSG13_1P_BITKIT_16x2_SRAM_2[1]/A_BLT_BOT<0>
+ RM_IHPSG13_1P_BITKIT_16x2_SRAM_2[0]/A_BLT_BOT<0> RM_IHPSG13_1P_BITKIT_16x2_SRAM_2[1]/A_BLC_BOT<0>
+ RM_IHPSG13_1P_BITKIT_16x2_SRAM_2[0]/A_BLC_BOT<0> RM_IHPSG13_1P_BITKIT_16x2_SRAM_2[1]/A_BLC_BOT<1>
+ RM_IHPSG13_1P_BITKIT_16x2_SRAM_2[0]/A_BLC_BOT<1> RM_IHPSG13_1P_BITKIT_16x2_SRAM_2[1]/A_BLT_BOT<1>
+ RM_IHPSG13_1P_BITKIT_16x2_SRAM_2[0]/A_BLT_BOT<1> RM_IHPSG13_1P_BITKIT_16x2_SRAM_2[0]/A_RWL<2>
+ RM_IHPSG13_1P_BITKIT_16x2_SRAM_2[0]/A_RWL<4> RM_IHPSG13_1P_BITKIT_16x2_SRAM_2[0]/A_RWL<5>
+ RM_IHPSG13_1P_BITKIT_16x2_SRAM_2[0]/A_RWL<7> RM_IHPSG13_1P_BITKIT_16x2_SRAM_2[0]/A_RWL<0>
+ RM_IHPSG13_1P_BITKIT_16x2_SRAM_2[0]/A_RWL<15> RM_IHPSG13_1P_BITKIT_16x2_SRAM_2[0]/A_RWL<13>
+ RM_IHPSG13_1P_BITKIT_16x2_SRAM_2[0]/A_RWL<12> RM_IHPSG13_1P_BITKIT_16x2_SRAM_2[0]/A_RWL<10>
+ RM_IHPSG13_1P_BITKIT_16x2_SRAM_2[0]/A_LWL<0> RM_IHPSG13_1P_BITKIT_16x2_SRAM_2[0]/A_LWL<1>
+ RM_IHPSG13_1P_BITKIT_16x2_SRAM_2[0]/A_LWL<2> RM_IHPSG13_1P_BITKIT_16x2_SRAM_2[0]/A_LWL<7>
+ RM_IHPSG13_1P_BITKIT_16x2_SRAM_2[0]/A_LWL<9> RM_IHPSG13_1P_BITKIT_16x2_SRAM_2[0]/A_LWL<10>
+ RM_IHPSG13_1P_BITKIT_16x2_SRAM_2[0]/A_LWL<12> RM_IHPSG13_1P_BITKIT_16x2_SRAM_2[0]/A_LWL<15>
+ RM_IHPSG13_1P_BITKIT_16x2_SRAM_2[0]/A_RWL<3> RM_IHPSG13_1P_BITKIT_16x2_SRAM_2[0]/A_LWL<3>
+ RM_IHPSG13_1P_BITKIT_16x2_SRAM_2[0]/A_RWL<9> RM_IHPSG13_1P_BITKIT_16x2_SRAM_2[0]/A_LWL<5>
+ RM_IHPSG13_1P_BITKIT_16x2_SRAM_2[0]/A_LWL<8> RM_IHPSG13_1P_BITKIT_16x2_SRAM_2[0]/A_LWL<11>
+ RM_IHPSG13_1P_BITKIT_16x2_SRAM_2[0]/A_LWL<14> RM_IHPSG13_1P_BITKIT_16x2_SRAM_2[0]/A_RWL<8>
+ RM_IHPSG13_1P_BITKIT_16x2_SRAM_2[0]/A_RWL<1> RM_IHPSG13_1P_BITKIT_16x2_SRAM_2[0]/A_LWL<13>
+ RM_IHPSG13_1P_BITKIT_16x2_SRAM_2[0]/A_RWL<6> RM_IHPSG13_1P_BITKIT_16x2_SRAM_2[0]/A_LWL<4>
+ RM_IHPSG13_1P_BITKIT_16x2_SRAM_2[0]/A_RWL<14> RM_IHPSG13_1P_BITKIT_16x2_SRAM_3[3]/VSS
+ RM_IHPSG13_1P_BITKIT_16x2_SRAM_2[0]/A_RWL<11> RM_IHPSG13_1P_BITKIT_16x2_SRAM_2[0]/A_LWL<6>
+ RM_IHPSG13_1P_BITKIT_16x2_SRAM_3[3]/VDD RM_IHPSG13_1P_BITKIT_16x2_SRAM
XRM_IHPSG13_1P_BITKIT_16x2_SRAM_2[1] RM_IHPSG13_1P_BITKIT_16x2_SRAM_2[2]/A_BLT_BOT<0>
+ RM_IHPSG13_1P_BITKIT_16x2_SRAM_2[1]/A_BLT_BOT<0> RM_IHPSG13_1P_BITKIT_16x2_SRAM_2[2]/A_BLC_BOT<0>
+ RM_IHPSG13_1P_BITKIT_16x2_SRAM_2[1]/A_BLC_BOT<0> RM_IHPSG13_1P_BITKIT_16x2_SRAM_2[2]/A_BLC_BOT<1>
+ RM_IHPSG13_1P_BITKIT_16x2_SRAM_2[1]/A_BLC_BOT<1> RM_IHPSG13_1P_BITKIT_16x2_SRAM_2[2]/A_BLT_BOT<1>
+ RM_IHPSG13_1P_BITKIT_16x2_SRAM_2[1]/A_BLT_BOT<1> RM_IHPSG13_1P_BITKIT_16x2_SRAM_2[1]/A_RWL<2>
+ RM_IHPSG13_1P_BITKIT_16x2_SRAM_2[1]/A_RWL<4> RM_IHPSG13_1P_BITKIT_16x2_SRAM_2[1]/A_RWL<5>
+ RM_IHPSG13_1P_BITKIT_16x2_SRAM_2[1]/A_RWL<7> RM_IHPSG13_1P_BITKIT_16x2_SRAM_2[1]/A_RWL<0>
+ RM_IHPSG13_1P_BITKIT_16x2_SRAM_2[1]/A_RWL<15> RM_IHPSG13_1P_BITKIT_16x2_SRAM_2[1]/A_RWL<13>
+ RM_IHPSG13_1P_BITKIT_16x2_SRAM_2[1]/A_RWL<12> RM_IHPSG13_1P_BITKIT_16x2_SRAM_2[1]/A_RWL<10>
+ RM_IHPSG13_1P_BITKIT_16x2_SRAM_2[1]/A_LWL<0> RM_IHPSG13_1P_BITKIT_16x2_SRAM_2[1]/A_LWL<1>
+ RM_IHPSG13_1P_BITKIT_16x2_SRAM_2[1]/A_LWL<2> RM_IHPSG13_1P_BITKIT_16x2_SRAM_2[1]/A_LWL<7>
+ RM_IHPSG13_1P_BITKIT_16x2_SRAM_2[1]/A_LWL<9> RM_IHPSG13_1P_BITKIT_16x2_SRAM_2[1]/A_LWL<10>
+ RM_IHPSG13_1P_BITKIT_16x2_SRAM_2[1]/A_LWL<12> RM_IHPSG13_1P_BITKIT_16x2_SRAM_2[1]/A_LWL<15>
+ RM_IHPSG13_1P_BITKIT_16x2_SRAM_2[1]/A_RWL<3> RM_IHPSG13_1P_BITKIT_16x2_SRAM_2[1]/A_LWL<3>
+ RM_IHPSG13_1P_BITKIT_16x2_SRAM_2[1]/A_RWL<9> RM_IHPSG13_1P_BITKIT_16x2_SRAM_2[1]/A_LWL<5>
+ RM_IHPSG13_1P_BITKIT_16x2_SRAM_2[1]/A_LWL<8> RM_IHPSG13_1P_BITKIT_16x2_SRAM_2[1]/A_LWL<11>
+ RM_IHPSG13_1P_BITKIT_16x2_SRAM_2[1]/A_LWL<14> RM_IHPSG13_1P_BITKIT_16x2_SRAM_2[1]/A_RWL<8>
+ RM_IHPSG13_1P_BITKIT_16x2_SRAM_2[1]/A_RWL<1> RM_IHPSG13_1P_BITKIT_16x2_SRAM_2[1]/A_LWL<13>
+ RM_IHPSG13_1P_BITKIT_16x2_SRAM_2[1]/A_RWL<6> RM_IHPSG13_1P_BITKIT_16x2_SRAM_2[1]/A_LWL<4>
+ RM_IHPSG13_1P_BITKIT_16x2_SRAM_2[1]/A_RWL<14> RM_IHPSG13_1P_BITKIT_16x2_SRAM_3[3]/VSS
+ RM_IHPSG13_1P_BITKIT_16x2_SRAM_2[1]/A_RWL<11> RM_IHPSG13_1P_BITKIT_16x2_SRAM_2[1]/A_LWL<6>
+ RM_IHPSG13_1P_BITKIT_16x2_SRAM_3[3]/VDD RM_IHPSG13_1P_BITKIT_16x2_SRAM
XRM_IHPSG13_1P_BITKIT_16x2_SRAM_2[2] RM_IHPSG13_1P_BITKIT_16x2_SRAM_2[3]/A_BLT_BOT<0>
+ RM_IHPSG13_1P_BITKIT_16x2_SRAM_2[2]/A_BLT_BOT<0> RM_IHPSG13_1P_BITKIT_16x2_SRAM_2[3]/A_BLC_BOT<0>
+ RM_IHPSG13_1P_BITKIT_16x2_SRAM_2[2]/A_BLC_BOT<0> RM_IHPSG13_1P_BITKIT_16x2_SRAM_2[3]/A_BLC_BOT<1>
+ RM_IHPSG13_1P_BITKIT_16x2_SRAM_2[2]/A_BLC_BOT<1> RM_IHPSG13_1P_BITKIT_16x2_SRAM_2[3]/A_BLT_BOT<1>
+ RM_IHPSG13_1P_BITKIT_16x2_SRAM_2[2]/A_BLT_BOT<1> RM_IHPSG13_1P_BITKIT_16x2_SRAM_2[2]/A_RWL<2>
+ RM_IHPSG13_1P_BITKIT_16x2_SRAM_2[2]/A_RWL<4> RM_IHPSG13_1P_BITKIT_16x2_SRAM_2[2]/A_RWL<5>
+ RM_IHPSG13_1P_BITKIT_16x2_SRAM_2[2]/A_RWL<7> RM_IHPSG13_1P_BITKIT_16x2_SRAM_2[2]/A_RWL<0>
+ RM_IHPSG13_1P_BITKIT_16x2_SRAM_2[2]/A_RWL<15> RM_IHPSG13_1P_BITKIT_16x2_SRAM_2[2]/A_RWL<13>
+ RM_IHPSG13_1P_BITKIT_16x2_SRAM_2[2]/A_RWL<12> RM_IHPSG13_1P_BITKIT_16x2_SRAM_2[2]/A_RWL<10>
+ RM_IHPSG13_1P_BITKIT_16x2_SRAM_2[2]/A_LWL<0> RM_IHPSG13_1P_BITKIT_16x2_SRAM_2[2]/A_LWL<1>
+ RM_IHPSG13_1P_BITKIT_16x2_SRAM_2[2]/A_LWL<2> RM_IHPSG13_1P_BITKIT_16x2_SRAM_2[2]/A_LWL<7>
+ RM_IHPSG13_1P_BITKIT_16x2_SRAM_2[2]/A_LWL<9> RM_IHPSG13_1P_BITKIT_16x2_SRAM_2[2]/A_LWL<10>
+ RM_IHPSG13_1P_BITKIT_16x2_SRAM_2[2]/A_LWL<12> RM_IHPSG13_1P_BITKIT_16x2_SRAM_2[2]/A_LWL<15>
+ RM_IHPSG13_1P_BITKIT_16x2_SRAM_2[2]/A_RWL<3> RM_IHPSG13_1P_BITKIT_16x2_SRAM_2[2]/A_LWL<3>
+ RM_IHPSG13_1P_BITKIT_16x2_SRAM_2[2]/A_RWL<9> RM_IHPSG13_1P_BITKIT_16x2_SRAM_2[2]/A_LWL<5>
+ RM_IHPSG13_1P_BITKIT_16x2_SRAM_2[2]/A_LWL<8> RM_IHPSG13_1P_BITKIT_16x2_SRAM_2[2]/A_LWL<11>
+ RM_IHPSG13_1P_BITKIT_16x2_SRAM_2[2]/A_LWL<14> RM_IHPSG13_1P_BITKIT_16x2_SRAM_2[2]/A_RWL<8>
+ RM_IHPSG13_1P_BITKIT_16x2_SRAM_2[2]/A_RWL<1> RM_IHPSG13_1P_BITKIT_16x2_SRAM_2[2]/A_LWL<13>
+ RM_IHPSG13_1P_BITKIT_16x2_SRAM_2[2]/A_RWL<6> RM_IHPSG13_1P_BITKIT_16x2_SRAM_2[2]/A_LWL<4>
+ RM_IHPSG13_1P_BITKIT_16x2_SRAM_2[2]/A_RWL<14> RM_IHPSG13_1P_BITKIT_16x2_SRAM_3[3]/VSS
+ RM_IHPSG13_1P_BITKIT_16x2_SRAM_2[2]/A_RWL<11> RM_IHPSG13_1P_BITKIT_16x2_SRAM_2[2]/A_LWL<6>
+ RM_IHPSG13_1P_BITKIT_16x2_SRAM_3[3]/VDD RM_IHPSG13_1P_BITKIT_16x2_SRAM
XRM_IHPSG13_1P_BITKIT_16x2_SRAM_2[3] RM_IHPSG13_1P_BITKIT_16x2_SRAM_3[0]/A_BLT_BOT<0>
+ RM_IHPSG13_1P_BITKIT_16x2_SRAM_2[3]/A_BLT_BOT<0> RM_IHPSG13_1P_BITKIT_16x2_SRAM_3[0]/A_BLC_BOT<0>
+ RM_IHPSG13_1P_BITKIT_16x2_SRAM_2[3]/A_BLC_BOT<0> RM_IHPSG13_1P_BITKIT_16x2_SRAM_3[0]/A_BLC_BOT<1>
+ RM_IHPSG13_1P_BITKIT_16x2_SRAM_2[3]/A_BLC_BOT<1> RM_IHPSG13_1P_BITKIT_16x2_SRAM_3[0]/A_BLT_BOT<1>
+ RM_IHPSG13_1P_BITKIT_16x2_SRAM_2[3]/A_BLT_BOT<1> RM_IHPSG13_1P_BITKIT_16x2_SRAM_2[3]/A_RWL<2>
+ RM_IHPSG13_1P_BITKIT_16x2_SRAM_2[3]/A_RWL<4> RM_IHPSG13_1P_BITKIT_16x2_SRAM_2[3]/A_RWL<5>
+ RM_IHPSG13_1P_BITKIT_16x2_SRAM_2[3]/A_RWL<7> RM_IHPSG13_1P_BITKIT_16x2_SRAM_2[3]/A_RWL<0>
+ RM_IHPSG13_1P_BITKIT_16x2_SRAM_2[3]/A_RWL<15> RM_IHPSG13_1P_BITKIT_16x2_SRAM_2[3]/A_RWL<13>
+ RM_IHPSG13_1P_BITKIT_16x2_SRAM_2[3]/A_RWL<12> RM_IHPSG13_1P_BITKIT_16x2_SRAM_2[3]/A_RWL<10>
+ RM_IHPSG13_1P_BITKIT_16x2_SRAM_2[3]/A_LWL<0> RM_IHPSG13_1P_BITKIT_16x2_SRAM_2[3]/A_LWL<1>
+ RM_IHPSG13_1P_BITKIT_16x2_SRAM_2[3]/A_LWL<2> RM_IHPSG13_1P_BITKIT_16x2_SRAM_2[3]/A_LWL<7>
+ RM_IHPSG13_1P_BITKIT_16x2_SRAM_2[3]/A_LWL<9> RM_IHPSG13_1P_BITKIT_16x2_SRAM_2[3]/A_LWL<10>
+ RM_IHPSG13_1P_BITKIT_16x2_SRAM_2[3]/A_LWL<12> RM_IHPSG13_1P_BITKIT_16x2_SRAM_2[3]/A_LWL<15>
+ RM_IHPSG13_1P_BITKIT_16x2_SRAM_2[3]/A_RWL<3> RM_IHPSG13_1P_BITKIT_16x2_SRAM_2[3]/A_LWL<3>
+ RM_IHPSG13_1P_BITKIT_16x2_SRAM_2[3]/A_RWL<9> RM_IHPSG13_1P_BITKIT_16x2_SRAM_2[3]/A_LWL<5>
+ RM_IHPSG13_1P_BITKIT_16x2_SRAM_2[3]/A_LWL<8> RM_IHPSG13_1P_BITKIT_16x2_SRAM_2[3]/A_LWL<11>
+ RM_IHPSG13_1P_BITKIT_16x2_SRAM_2[3]/A_LWL<14> RM_IHPSG13_1P_BITKIT_16x2_SRAM_2[3]/A_RWL<8>
+ RM_IHPSG13_1P_BITKIT_16x2_SRAM_2[3]/A_RWL<1> RM_IHPSG13_1P_BITKIT_16x2_SRAM_2[3]/A_LWL<13>
+ RM_IHPSG13_1P_BITKIT_16x2_SRAM_2[3]/A_RWL<6> RM_IHPSG13_1P_BITKIT_16x2_SRAM_2[3]/A_LWL<4>
+ RM_IHPSG13_1P_BITKIT_16x2_SRAM_2[3]/A_RWL<14> RM_IHPSG13_1P_BITKIT_16x2_SRAM_3[3]/VSS
+ RM_IHPSG13_1P_BITKIT_16x2_SRAM_2[3]/A_RWL<11> RM_IHPSG13_1P_BITKIT_16x2_SRAM_2[3]/A_LWL<6>
+ RM_IHPSG13_1P_BITKIT_16x2_SRAM_3[3]/VDD RM_IHPSG13_1P_BITKIT_16x2_SRAM
XRM_IHPSG13_1P_BITKIT_16x2_SRAM_3[0] RM_IHPSG13_1P_BITKIT_16x2_SRAM_3[0]/A_BLT_TOP<0>
+ RM_IHPSG13_1P_BITKIT_16x2_SRAM_3[0]/A_BLT_BOT<0> RM_IHPSG13_1P_BITKIT_16x2_SRAM_3[0]/A_BLC_TOP<0>
+ RM_IHPSG13_1P_BITKIT_16x2_SRAM_3[0]/A_BLC_BOT<0> RM_IHPSG13_1P_BITKIT_16x2_SRAM_3[0]/A_BLC_TOP<1>
+ RM_IHPSG13_1P_BITKIT_16x2_SRAM_3[0]/A_BLC_BOT<1> RM_IHPSG13_1P_BITKIT_16x2_SRAM_3[0]/A_BLT_TOP<1>
+ RM_IHPSG13_1P_BITKIT_16x2_SRAM_3[0]/A_BLT_BOT<1> RM_IHPSG13_1P_BITKIT_16x2_SRAM_3[0]/A_RWL<2>
+ RM_IHPSG13_1P_BITKIT_16x2_SRAM_3[0]/A_RWL<4> RM_IHPSG13_1P_BITKIT_16x2_SRAM_3[0]/A_RWL<5>
+ RM_IHPSG13_1P_BITKIT_16x2_SRAM_3[0]/A_RWL<7> RM_IHPSG13_1P_BITKIT_16x2_SRAM_3[0]/A_RWL<0>
+ RM_IHPSG13_1P_BITKIT_16x2_SRAM_3[0]/A_RWL<15> RM_IHPSG13_1P_BITKIT_16x2_SRAM_3[0]/A_RWL<13>
+ RM_IHPSG13_1P_BITKIT_16x2_SRAM_3[0]/A_RWL<12> RM_IHPSG13_1P_BITKIT_16x2_SRAM_3[0]/A_RWL<10>
+ RM_IHPSG13_1P_BITKIT_16x2_SRAM_3[0]/A_LWL<0> RM_IHPSG13_1P_BITKIT_16x2_SRAM_3[0]/A_LWL<1>
+ RM_IHPSG13_1P_BITKIT_16x2_SRAM_3[0]/A_LWL<2> RM_IHPSG13_1P_BITKIT_16x2_SRAM_3[0]/A_LWL<7>
+ RM_IHPSG13_1P_BITKIT_16x2_SRAM_3[0]/A_LWL<9> RM_IHPSG13_1P_BITKIT_16x2_SRAM_3[0]/A_LWL<10>
+ RM_IHPSG13_1P_BITKIT_16x2_SRAM_3[0]/A_LWL<12> RM_IHPSG13_1P_BITKIT_16x2_SRAM_3[0]/A_LWL<15>
+ RM_IHPSG13_1P_BITKIT_16x2_SRAM_3[0]/A_RWL<3> RM_IHPSG13_1P_BITKIT_16x2_SRAM_3[0]/A_LWL<3>
+ RM_IHPSG13_1P_BITKIT_16x2_SRAM_3[0]/A_RWL<9> RM_IHPSG13_1P_BITKIT_16x2_SRAM_3[0]/A_LWL<5>
+ RM_IHPSG13_1P_BITKIT_16x2_SRAM_3[0]/A_LWL<8> RM_IHPSG13_1P_BITKIT_16x2_SRAM_3[0]/A_LWL<11>
+ RM_IHPSG13_1P_BITKIT_16x2_SRAM_3[0]/A_LWL<14> RM_IHPSG13_1P_BITKIT_16x2_SRAM_3[0]/A_RWL<8>
+ RM_IHPSG13_1P_BITKIT_16x2_SRAM_3[0]/A_RWL<1> RM_IHPSG13_1P_BITKIT_16x2_SRAM_3[0]/A_LWL<13>
+ RM_IHPSG13_1P_BITKIT_16x2_SRAM_3[0]/A_RWL<6> RM_IHPSG13_1P_BITKIT_16x2_SRAM_3[0]/A_LWL<4>
+ RM_IHPSG13_1P_BITKIT_16x2_SRAM_3[0]/A_RWL<14> RM_IHPSG13_1P_BITKIT_16x2_SRAM_3[3]/VSS
+ RM_IHPSG13_1P_BITKIT_16x2_SRAM_3[0]/A_RWL<11> RM_IHPSG13_1P_BITKIT_16x2_SRAM_3[0]/A_LWL<6>
+ RM_IHPSG13_1P_BITKIT_16x2_SRAM_3[3]/VDD RM_IHPSG13_1P_BITKIT_16x2_SRAM
XRM_IHPSG13_1P_BITKIT_16x2_SRAM_3[1] RM_IHPSG13_1P_BITKIT_16x2_SRAM_3[1]/A_BLT_TOP<0>
+ RM_IHPSG13_1P_BITKIT_16x2_SRAM_3[1]/A_BLT_BOT<0> RM_IHPSG13_1P_BITKIT_16x2_SRAM_3[1]/A_BLC_TOP<0>
+ RM_IHPSG13_1P_BITKIT_16x2_SRAM_3[1]/A_BLC_BOT<0> RM_IHPSG13_1P_BITKIT_16x2_SRAM_3[1]/A_BLC_TOP<1>
+ RM_IHPSG13_1P_BITKIT_16x2_SRAM_3[1]/A_BLC_BOT<1> RM_IHPSG13_1P_BITKIT_16x2_SRAM_3[1]/A_BLT_TOP<1>
+ RM_IHPSG13_1P_BITKIT_16x2_SRAM_3[1]/A_BLT_BOT<1> RM_IHPSG13_1P_BITKIT_16x2_SRAM_3[1]/A_RWL<2>
+ RM_IHPSG13_1P_BITKIT_16x2_SRAM_3[1]/A_RWL<4> RM_IHPSG13_1P_BITKIT_16x2_SRAM_3[1]/A_RWL<5>
+ RM_IHPSG13_1P_BITKIT_16x2_SRAM_3[1]/A_RWL<7> RM_IHPSG13_1P_BITKIT_16x2_SRAM_3[1]/A_RWL<0>
+ RM_IHPSG13_1P_BITKIT_16x2_SRAM_3[1]/A_RWL<15> RM_IHPSG13_1P_BITKIT_16x2_SRAM_3[1]/A_RWL<13>
+ RM_IHPSG13_1P_BITKIT_16x2_SRAM_3[1]/A_RWL<12> RM_IHPSG13_1P_BITKIT_16x2_SRAM_3[1]/A_RWL<10>
+ RM_IHPSG13_1P_BITKIT_16x2_SRAM_3[1]/A_LWL<0> RM_IHPSG13_1P_BITKIT_16x2_SRAM_3[1]/A_LWL<1>
+ RM_IHPSG13_1P_BITKIT_16x2_SRAM_3[1]/A_LWL<2> RM_IHPSG13_1P_BITKIT_16x2_SRAM_3[1]/A_LWL<7>
+ RM_IHPSG13_1P_BITKIT_16x2_SRAM_3[1]/A_LWL<9> RM_IHPSG13_1P_BITKIT_16x2_SRAM_3[1]/A_LWL<10>
+ RM_IHPSG13_1P_BITKIT_16x2_SRAM_3[1]/A_LWL<12> RM_IHPSG13_1P_BITKIT_16x2_SRAM_3[1]/A_LWL<15>
+ RM_IHPSG13_1P_BITKIT_16x2_SRAM_3[1]/A_RWL<3> RM_IHPSG13_1P_BITKIT_16x2_SRAM_3[1]/A_LWL<3>
+ RM_IHPSG13_1P_BITKIT_16x2_SRAM_3[1]/A_RWL<9> RM_IHPSG13_1P_BITKIT_16x2_SRAM_3[1]/A_LWL<5>
+ RM_IHPSG13_1P_BITKIT_16x2_SRAM_3[1]/A_LWL<8> RM_IHPSG13_1P_BITKIT_16x2_SRAM_3[1]/A_LWL<11>
+ RM_IHPSG13_1P_BITKIT_16x2_SRAM_3[1]/A_LWL<14> RM_IHPSG13_1P_BITKIT_16x2_SRAM_3[1]/A_RWL<8>
+ RM_IHPSG13_1P_BITKIT_16x2_SRAM_3[1]/A_RWL<1> RM_IHPSG13_1P_BITKIT_16x2_SRAM_3[1]/A_LWL<13>
+ RM_IHPSG13_1P_BITKIT_16x2_SRAM_3[1]/A_RWL<6> RM_IHPSG13_1P_BITKIT_16x2_SRAM_3[1]/A_LWL<4>
+ RM_IHPSG13_1P_BITKIT_16x2_SRAM_3[1]/A_RWL<14> RM_IHPSG13_1P_BITKIT_16x2_SRAM_3[3]/VSS
+ RM_IHPSG13_1P_BITKIT_16x2_SRAM_3[1]/A_RWL<11> RM_IHPSG13_1P_BITKIT_16x2_SRAM_3[1]/A_LWL<6>
+ RM_IHPSG13_1P_BITKIT_16x2_SRAM_3[3]/VDD RM_IHPSG13_1P_BITKIT_16x2_SRAM
XRM_IHPSG13_1P_BITKIT_16x2_SRAM_3[2] RM_IHPSG13_1P_BITKIT_16x2_SRAM_3[2]/A_BLT_TOP<0>
+ RM_IHPSG13_1P_BITKIT_16x2_SRAM_3[2]/A_BLT_BOT<0> RM_IHPSG13_1P_BITKIT_16x2_SRAM_3[2]/A_BLC_TOP<0>
+ RM_IHPSG13_1P_BITKIT_16x2_SRAM_3[2]/A_BLC_BOT<0> RM_IHPSG13_1P_BITKIT_16x2_SRAM_3[2]/A_BLC_TOP<1>
+ RM_IHPSG13_1P_BITKIT_16x2_SRAM_3[2]/A_BLC_BOT<1> RM_IHPSG13_1P_BITKIT_16x2_SRAM_3[2]/A_BLT_TOP<1>
+ RM_IHPSG13_1P_BITKIT_16x2_SRAM_3[2]/A_BLT_BOT<1> RM_IHPSG13_1P_BITKIT_16x2_SRAM_3[2]/A_RWL<2>
+ RM_IHPSG13_1P_BITKIT_16x2_SRAM_3[2]/A_RWL<4> RM_IHPSG13_1P_BITKIT_16x2_SRAM_3[2]/A_RWL<5>
+ RM_IHPSG13_1P_BITKIT_16x2_SRAM_3[2]/A_RWL<7> RM_IHPSG13_1P_BITKIT_16x2_SRAM_3[2]/A_RWL<0>
+ RM_IHPSG13_1P_BITKIT_16x2_SRAM_3[2]/A_RWL<15> RM_IHPSG13_1P_BITKIT_16x2_SRAM_3[2]/A_RWL<13>
+ RM_IHPSG13_1P_BITKIT_16x2_SRAM_3[2]/A_RWL<12> RM_IHPSG13_1P_BITKIT_16x2_SRAM_3[2]/A_RWL<10>
+ RM_IHPSG13_1P_BITKIT_16x2_SRAM_3[2]/A_LWL<0> RM_IHPSG13_1P_BITKIT_16x2_SRAM_3[2]/A_LWL<1>
+ RM_IHPSG13_1P_BITKIT_16x2_SRAM_3[2]/A_LWL<2> RM_IHPSG13_1P_BITKIT_16x2_SRAM_3[2]/A_LWL<7>
+ RM_IHPSG13_1P_BITKIT_16x2_SRAM_3[2]/A_LWL<9> RM_IHPSG13_1P_BITKIT_16x2_SRAM_3[2]/A_LWL<10>
+ RM_IHPSG13_1P_BITKIT_16x2_SRAM_3[2]/A_LWL<12> RM_IHPSG13_1P_BITKIT_16x2_SRAM_3[2]/A_LWL<15>
+ RM_IHPSG13_1P_BITKIT_16x2_SRAM_3[2]/A_RWL<3> RM_IHPSG13_1P_BITKIT_16x2_SRAM_3[2]/A_LWL<3>
+ RM_IHPSG13_1P_BITKIT_16x2_SRAM_3[2]/A_RWL<9> RM_IHPSG13_1P_BITKIT_16x2_SRAM_3[2]/A_LWL<5>
+ RM_IHPSG13_1P_BITKIT_16x2_SRAM_3[2]/A_LWL<8> RM_IHPSG13_1P_BITKIT_16x2_SRAM_3[2]/A_LWL<11>
+ RM_IHPSG13_1P_BITKIT_16x2_SRAM_3[2]/A_LWL<14> RM_IHPSG13_1P_BITKIT_16x2_SRAM_3[2]/A_RWL<8>
+ RM_IHPSG13_1P_BITKIT_16x2_SRAM_3[2]/A_RWL<1> RM_IHPSG13_1P_BITKIT_16x2_SRAM_3[2]/A_LWL<13>
+ RM_IHPSG13_1P_BITKIT_16x2_SRAM_3[2]/A_RWL<6> RM_IHPSG13_1P_BITKIT_16x2_SRAM_3[2]/A_LWL<4>
+ RM_IHPSG13_1P_BITKIT_16x2_SRAM_3[2]/A_RWL<14> RM_IHPSG13_1P_BITKIT_16x2_SRAM_3[3]/VSS
+ RM_IHPSG13_1P_BITKIT_16x2_SRAM_3[2]/A_RWL<11> RM_IHPSG13_1P_BITKIT_16x2_SRAM_3[2]/A_LWL<6>
+ RM_IHPSG13_1P_BITKIT_16x2_SRAM_3[3]/VDD RM_IHPSG13_1P_BITKIT_16x2_SRAM
XRM_IHPSG13_1P_BITKIT_16x2_SRAM_3[3] RM_IHPSG13_1P_BITKIT_16x2_SRAM_3[3]/A_BLT_TOP<0>
+ RM_IHPSG13_1P_BITKIT_16x2_SRAM_3[3]/A_BLT_BOT<0> RM_IHPSG13_1P_BITKIT_16x2_SRAM_3[3]/A_BLC_TOP<0>
+ RM_IHPSG13_1P_BITKIT_16x2_SRAM_3[3]/A_BLC_BOT<0> RM_IHPSG13_1P_BITKIT_16x2_SRAM_3[3]/A_BLC_TOP<1>
+ RM_IHPSG13_1P_BITKIT_16x2_SRAM_3[3]/A_BLC_BOT<1> RM_IHPSG13_1P_BITKIT_16x2_SRAM_3[3]/A_BLT_TOP<1>
+ RM_IHPSG13_1P_BITKIT_16x2_SRAM_3[3]/A_BLT_BOT<1> RM_IHPSG13_1P_BITKIT_16x2_SRAM_3[3]/A_RWL<2>
+ RM_IHPSG13_1P_BITKIT_16x2_SRAM_3[3]/A_RWL<4> RM_IHPSG13_1P_BITKIT_16x2_SRAM_3[3]/A_RWL<5>
+ RM_IHPSG13_1P_BITKIT_16x2_SRAM_3[3]/A_RWL<7> RM_IHPSG13_1P_BITKIT_16x2_SRAM_3[3]/A_RWL<0>
+ RM_IHPSG13_1P_BITKIT_16x2_SRAM_3[3]/A_RWL<15> RM_IHPSG13_1P_BITKIT_16x2_SRAM_3[3]/A_RWL<13>
+ RM_IHPSG13_1P_BITKIT_16x2_SRAM_3[3]/A_RWL<12> RM_IHPSG13_1P_BITKIT_16x2_SRAM_3[3]/A_RWL<10>
+ RM_IHPSG13_1P_BITKIT_16x2_SRAM_3[3]/A_LWL<0> RM_IHPSG13_1P_BITKIT_16x2_SRAM_3[3]/A_LWL<1>
+ RM_IHPSG13_1P_BITKIT_16x2_SRAM_3[3]/A_LWL<2> RM_IHPSG13_1P_BITKIT_16x2_SRAM_3[3]/A_LWL<7>
+ RM_IHPSG13_1P_BITKIT_16x2_SRAM_3[3]/A_LWL<9> RM_IHPSG13_1P_BITKIT_16x2_SRAM_3[3]/A_LWL<10>
+ RM_IHPSG13_1P_BITKIT_16x2_SRAM_3[3]/A_LWL<12> RM_IHPSG13_1P_BITKIT_16x2_SRAM_3[3]/A_LWL<15>
+ RM_IHPSG13_1P_BITKIT_16x2_SRAM_3[3]/A_RWL<3> RM_IHPSG13_1P_BITKIT_16x2_SRAM_3[3]/A_LWL<3>
+ RM_IHPSG13_1P_BITKIT_16x2_SRAM_3[3]/A_RWL<9> RM_IHPSG13_1P_BITKIT_16x2_SRAM_3[3]/A_LWL<5>
+ RM_IHPSG13_1P_BITKIT_16x2_SRAM_3[3]/A_LWL<8> RM_IHPSG13_1P_BITKIT_16x2_SRAM_3[3]/A_LWL<11>
+ RM_IHPSG13_1P_BITKIT_16x2_SRAM_3[3]/A_LWL<14> RM_IHPSG13_1P_BITKIT_16x2_SRAM_3[3]/A_RWL<8>
+ RM_IHPSG13_1P_BITKIT_16x2_SRAM_3[3]/A_RWL<1> RM_IHPSG13_1P_BITKIT_16x2_SRAM_3[3]/A_LWL<13>
+ RM_IHPSG13_1P_BITKIT_16x2_SRAM_3[3]/A_RWL<6> RM_IHPSG13_1P_BITKIT_16x2_SRAM_3[3]/A_LWL<4>
+ RM_IHPSG13_1P_BITKIT_16x2_SRAM_3[3]/A_RWL<14> RM_IHPSG13_1P_BITKIT_16x2_SRAM_3[3]/VSS
+ RM_IHPSG13_1P_BITKIT_16x2_SRAM_3[3]/A_RWL<11> RM_IHPSG13_1P_BITKIT_16x2_SRAM_3[3]/A_LWL<6>
+ RM_IHPSG13_1P_BITKIT_16x2_SRAM_3[3]/VDD RM_IHPSG13_1P_BITKIT_16x2_SRAM
.ends

.subckt RM_IHPSG13_1P_MATRIX_256x16 RM_IHPSG13_1P_BITKIT_16x2_EDGE_LR_7[1]/LWL<10>
+ RM_IHPSG13_1P_COLUMN_256_0[4]/RM_IHPSG13_1P_BITKIT_16x2_SRAM_0[0]/A_BLT_BOT<0> RM_IHPSG13_1P_COLUMN_256_0[4]/RM_IHPSG13_1P_BITKIT_16x2_SRAM_0[0]/A_BLT_BOT<1>
+ RM_IHPSG13_1P_BITKIT_16x2_EDGE_LR_6[1]/LWL<14> RM_IHPSG13_1P_COLUMN_256_0[4]/RM_IHPSG13_1P_BITKIT_16x2_SRAM_0[0]/A_BLC_BOT<0>
+ RM_IHPSG13_1P_BITKIT_16x2_EDGE_LR_5[1]/LWL<8> RM_IHPSG13_1P_COLUMN_256_0[4]/RM_IHPSG13_1P_BITKIT_16x2_SRAM_0[0]/A_BLC_BOT<1>
+ RM_IHPSG13_1P_BITKIT_16x2_EDGE_LR_4[2]/LWL<9> RM_IHPSG13_1P_BITKIT_16x2_EDGE_LR_6[1]/LWL<1>
+ RM_IHPSG13_1P_BITKIT_16x2_EDGE_LR_6[0]/LWL<7> RM_IHPSG13_1P_BITKIT_16x2_EDGE_LR_5[2]/LWL<2>
+ RM_IHPSG13_1P_BITKIT_16x2_EDGE_LR_7[0]/LWL<0> RM_IHPSG13_1P_BITKIT_16x2_EDGE_LR_7[1]/LWL<15>
+ RM_IHPSG13_1P_BITKIT_16x2_EDGE_LR_5[2]/LWL<1> RM_IHPSG13_1P_COLUMN_256_0[7]/RM_IHPSG13_1P_BITKIT_16x2_SRAM_0[0]/A_BLT_BOT<0>
+ RM_IHPSG13_1P_BITKIT_16x2_EDGE_LR_7[0]/LWL<4> RM_IHPSG13_1P_BITKIT_16x2_EDGE_LR_7[3]/LWL<7>
+ RM_IHPSG13_1P_COLUMN_256_0[7]/RM_IHPSG13_1P_BITKIT_16x2_SRAM_0[0]/A_BLT_BOT<1> RM_IHPSG13_1P_BITKIT_16x2_EDGE_LR_5[1]/LWL<7>
+ RM_IHPSG13_1P_COLUMN_256_0[7]/RM_IHPSG13_1P_BITKIT_16x2_SRAM_0[0]/A_BLC_BOT<0> RM_IHPSG13_1P_BITKIT_16x2_EDGE_LR_4[3]/LWL<4>
+ RM_IHPSG13_1P_BITKIT_16x2_EDGE_LR_4[2]/LWL<13> RM_IHPSG13_1P_BITKIT_16x2_EDGE_LR_5[2]/LWL<13>
+ RM_IHPSG13_1P_BITKIT_16x2_EDGE_LR_4[3]/LWL<0> RM_IHPSG13_1P_COLUMN_256_0[7]/RM_IHPSG13_1P_BITKIT_16x2_SRAM_0[0]/A_BLC_BOT<1>
+ RM_IHPSG13_1P_BITKIT_16x2_EDGE_LR_6[1]/LWL<6> RM_IHPSG13_1P_COLUMN_256_0[2]/RM_IHPSG13_1P_BITKIT_16x2_SRAM_0[0]/A_BLT_BOT<0>
+ RM_IHPSG13_1P_BITKIT_16x2_EDGE_LR_7[0]/LWL<7> RM_IHPSG13_1P_BITKIT_16x2_EDGE_LR_5[2]/LWL<12>
+ RM_IHPSG13_1P_BITKIT_16x2_EDGE_LR_7[3]/LWL<6> RM_IHPSG13_1P_BITKIT_16x2_EDGE_LR_6[1]/LWL<7>
+ RM_IHPSG13_1P_BITKIT_16x2_EDGE_LR_4[3]/LWL<1> RM_IHPSG13_1P_COLUMN_256_0[2]/RM_IHPSG13_1P_BITKIT_16x2_SRAM_0[0]/A_BLT_BOT<1>
+ RM_IHPSG13_1P_BITKIT_16x2_EDGE_LR_6[2]/LWL<12> RM_IHPSG13_1P_COLUMN_256_0[2]/RM_IHPSG13_1P_BITKIT_16x2_SRAM_0[0]/A_BLC_BOT<0>
+ RM_IHPSG13_1P_BITKIT_16x2_EDGE_LR_5[2]/LWL<7> RM_IHPSG13_1P_BITKIT_16x2_EDGE_LR_4[2]/LWL<7>
+ RM_IHPSG13_1P_COLUMN_256_0[2]/RM_IHPSG13_1P_BITKIT_16x2_SRAM_0[0]/A_BLC_BOT<1> RM_IHPSG13_1P_BITKIT_16x2_EDGE_LR_5[2]/LWL<8>
+ RM_IHPSG13_1P_BITKIT_16x2_EDGE_LR_7[2]/LWL<10> RM_IHPSG13_1P_BITKIT_16x2_EDGE_LR_7[1]/LWL<0>
+ RM_IHPSG13_1P_BITKIT_16x2_EDGE_LR_5[1]/LWL<6> RM_IHPSG13_1P_BITKIT_16x2_EDGE_LR_7[1]/LWL<11>
+ RM_IHPSG13_1P_BITKIT_16x2_EDGE_LR_6[2]/LWL<14> RM_IHPSG13_1P_BITKIT_16x2_EDGE_LR_5[3]/LWL<0>
+ RM_IHPSG13_1P_BITKIT_16x2_EDGE_LR_7[1]/LWL<1> RM_IHPSG13_1P_BITKIT_16x2_EDGE_LR_4[3]/LWL<9>
+ RM_IHPSG13_1P_BITKIT_16x2_EDGE_LR_4[3]/LWL<7> RM_IHPSG13_1P_BITKIT_16x2_EDGE_LR_6[1]/LWL<15>
+ RM_IHPSG13_1P_BITKIT_16x2_EDGE_LR_7[0]/LWL<5> RM_IHPSG13_1P_BITKIT_16x2_EDGE_LR_6[2]/LWL<1>
+ RM_IHPSG13_1P_BITKIT_16x2_EDGE_LR_4[0]/LWL<1> RM_IHPSG13_1P_BITKIT_16x2_EDGE_LR_7[2]/LWL<11>
+ RM_IHPSG13_1P_BITKIT_16x2_EDGE_LR_6[2]/LWL<10> RM_IHPSG13_1P_BITKIT_16x2_EDGE_LR_5[3]/LWL<1>
+ RM_IHPSG13_1P_BITKIT_16x2_EDGE_LR_4[2]/LWL<8> RM_IHPSG13_1P_BITKIT_16x2_EDGE_LR_7[0]/LWL<2>
+ RM_IHPSG13_1P_BITKIT_16x2_EDGE_LR_5[3]/LWL<2> RM_IHPSG13_1P_COLUMN_256_0[5]/RM_IHPSG13_1P_BITKIT_16x2_SRAM_0[0]/A_BLT_BOT<0>
+ RM_IHPSG13_1P_BITKIT_16x2_EDGE_LR_5[2]/LWL<14> RM_IHPSG13_1P_BITKIT_16x2_EDGE_LR_6[2]/LWL<11>
+ RM_IHPSG13_1P_BITKIT_16x2_EDGE_LR_4[3]/LWL<13> RM_IHPSG13_1P_BITKIT_16x2_EDGE_LR_7[2]/LWL<14>
+ RM_IHPSG13_1P_BITKIT_16x2_EDGE_LR_7[1]/LWL<4> RM_IHPSG13_1P_COLUMN_256_0[5]/RM_IHPSG13_1P_BITKIT_16x2_SRAM_0[0]/A_BLT_BOT<1>
+ RM_IHPSG13_1P_BITKIT_16x2_EDGE_LR_6[1]/LWL<4> RM_IHPSG13_1P_COLUMN_256_0[5]/RM_IHPSG13_1P_BITKIT_16x2_SRAM_0[0]/A_BLC_BOT<0>
+ RM_IHPSG13_1P_BITKIT_16x2_EDGE_LR_4[0]/LWL<10> RM_IHPSG13_1P_BITKIT_16x2_EDGE_LR_7[2]/LWL<15>
+ RM_IHPSG13_1P_BITKIT_16x2_EDGE_LR_4[2]/LWL<12> RM_IHPSG13_1P_BITKIT_16x2_EDGE_LR_6[1]/LWL<5>
+ RM_IHPSG13_1P_BITKIT_16x2_EDGE_LR_7[1]/LWL<5> RM_IHPSG13_1P_BITKIT_16x2_EDGE_LR_7[0]/LWL<8>
+ RM_IHPSG13_1P_BITKIT_16x2_EDGE_LR_4[3]/LWL<2> RM_IHPSG13_1P_COLUMN_256_0[5]/RM_IHPSG13_1P_BITKIT_16x2_SRAM_0[0]/A_BLC_BOT<1>
+ RM_IHPSG13_1P_BITKIT_16x2_EDGE_LR_7[1]/LWL<13> RM_IHPSG13_1P_BITKIT_16x2_EDGE_LR_4[0]/LWL<11>
+ RM_IHPSG13_1P_BITKIT_16x2_EDGE_LR_5[2]/LWL<11> RM_IHPSG13_1P_COLUMN_256_0[0]/RM_IHPSG13_1P_BITKIT_16x2_SRAM_0[0]/A_BLT_BOT<0>
+ RM_IHPSG13_1P_BITKIT_16x2_EDGE_LR_4[3]/LWL<15> RM_IHPSG13_1P_BITKIT_16x2_EDGE_LR_5[2]/LWL<6>
+ RM_IHPSG13_1P_BITKIT_16x2_EDGE_LR_5[3]/LWL<12> RM_IHPSG13_1P_BITKIT_16x2_EDGE_LR_6[2]/LWL<6>
+ RM_IHPSG13_1P_BITKIT_16x2_EDGE_LR_4[0]/LWL<12> RM_IHPSG13_1P_BITKIT_16x2_EDGE_LR_4[0]/LWL<6>
+ RM_IHPSG13_1P_BITKIT_16x2_EDGE_LR_6[2]/LWL<5> RM_IHPSG13_1P_COLUMN_256_0[0]/RM_IHPSG13_1P_BITKIT_16x2_SRAM_0[0]/A_BLT_BOT<1>
+ RM_IHPSG13_1P_BITKIT_16x2_EDGE_LR_6[1]/LWL<0> RM_IHPSG13_1P_COLUMN_256_0[0]/RM_IHPSG13_1P_BITKIT_16x2_SRAM_0[0]/A_BLC_BOT<0>
+ RM_IHPSG13_1P_BITKIT_16x2_EDGE_LR_7[1]/LWL<7> RM_IHPSG13_1P_BITKIT_16x2_EDGE_LR_5[3]/LWL<13>
+ RM_IHPSG13_1P_BITKIT_16x2_EDGE_LR_6[2]/LWL<15> RM_IHPSG13_1P_BITKIT_16x2_EDGE_LR_5[3]/LWL<11>
+ RM_IHPSG13_1P_BITKIT_16x2_EDGE_LR_4[0]/LWL<5> RM_IHPSG13_1P_BITKIT_16x2_EDGE_LR_6[2]/LWL<7>
+ RM_IHPSG13_1P_BITKIT_16x2_EDGE_LR_4[0]/LWL<7> RM_IHPSG13_1P_BITKIT_16x2_EDGE_LR_4[2]/LWL<11>
+ RM_IHPSG13_1P_BITKIT_16x2_EDGE_LR_5[0]/LWL<10> RM_IHPSG13_1P_BITKIT_16x2_EDGE_LR_6[3]/LWL<10>
+ RM_IHPSG13_1P_BITKIT_16x2_EDGE_LR_5[3]/LWL<7> RM_IHPSG13_1P_BITKIT_16x2_EDGE_LR_4[3]/LWL<8>
+ RM_IHPSG13_1P_COLUMN_256_0[0]/RM_IHPSG13_1P_BITKIT_16x2_SRAM_0[0]/A_BLC_BOT<1> RM_IHPSG13_1P_BITKIT_16x2_EDGE_LR_7[1]/LWL<2>
+ RM_IHPSG13_1P_BITKIT_16x2_EDGE_LR_6[3]/LWL<11> RM_IHPSG13_1P_BITKIT_16x2_EDGE_LR_4[0]/LWL<14>
+ RM_IHPSG13_1P_BITKIT_16x2_EDGE_LR_4[0]/LWL<8> RM_IHPSG13_1P_BITKIT_16x2_EDGE_LR_5[2]/LWL<5>
+ RM_IHPSG13_1P_BITKIT_16x2_EDGE_LR_5[0]/LWL<11> RM_IHPSG13_1P_BITKIT_16x2_EDGE_LR_5[2]/LWL<10>
+ RM_IHPSG13_1P_BITKIT_16x2_EDGE_LR_5[3]/LWL<8> RM_IHPSG13_1P_BITKIT_16x2_EDGE_LR_5[3]/LWL<14>
+ RM_IHPSG13_1P_BITKIT_16x2_EDGE_LR_7[2]/LWL<0> RM_IHPSG13_1P_BITKIT_16x2_EDGE_LR_5[0]/LWL<0>
+ RM_IHPSG13_1P_BITKIT_16x2_EDGE_LR_6[3]/LWL<12> RM_IHPSG13_1P_BITKIT_16x2_EDGE_LR_4[3]/LWL<11>
+ RM_IHPSG13_1P_BITKIT_16x2_EDGE_LR_4[0]/LWL<15> RM_IHPSG13_1P_BITKIT_16x2_EDGE_LR_5[3]/LWL<9>
+ RM_IHPSG13_1P_BITKIT_16x2_EDGE_LR_6[2]/LWL<4> RM_IHPSG13_1P_BITKIT_16x2_EDGE_LR_4[2]/LWL<14>
+ RM_IHPSG13_1P_BITKIT_16x2_EDGE_LR_7[2]/LWL<1> RM_IHPSG13_1P_BITKIT_16x2_EDGE_LR_5[3]/LWL<5>
+ RM_IHPSG13_1P_BITKIT_16x2_EDGE_LR_5[0]/LWL<1> RM_IHPSG13_1P_BITKIT_16x2_EDGE_LR_6[3]/LWL<13>
+ RM_IHPSG13_1P_BITKIT_16x2_EDGE_LR_7[3]/LWL<10> RM_IHPSG13_1P_BITKIT_16x2_EDGE_LR_6[3]/LWL<1>
+ RM_IHPSG13_1P_BITKIT_16x2_EDGE_LR_4[1]/LWL<1> RM_IHPSG13_1P_BITKIT_16x2_EDGE_LR_4[3]/LWL<12>
+ RM_IHPSG13_1P_BITKIT_16x2_EDGE_LR_7[1]/LWL<8> RM_IHPSG13_1P_BITKIT_16x2_EDGE_LR_6[0]/LWL<10>
+ RM_IHPSG13_1P_BITKIT_16x2_EDGE_LR_7[2]/LWL<13> RM_IHPSG13_1P_COLUMN_256_0[3]/RM_IHPSG13_1P_BITKIT_16x2_SRAM_0[0]/A_BLT_BOT<0>
+ RM_IHPSG13_1P_BITKIT_16x2_EDGE_LR_6[3]/LWL<14> RM_IHPSG13_1P_BITKIT_16x2_EDGE_LR_7[3]/LWL<11>
+ RM_IHPSG13_1P_BITKIT_16x2_EDGE_LR_6[3]/LWL<2> RM_IHPSG13_1P_BITKIT_16x2_EDGE_LR_4[1]/LWL<2>
+ RM_IHPSG13_1P_BITKIT_16x2_EDGE_LR_5[0]/LWL<14> RM_IHPSG13_1P_BITKIT_16x2_EDGE_LR_5[3]/LWL<6>
+ RM_IHPSG13_1P_BITKIT_16x2_EDGE_LR_6[0]/LWL<11> RM_IHPSG13_1P_BITKIT_16x2_EDGE_LR_6[0]/LWL<8>
+ RM_IHPSG13_1P_BITKIT_16x2_EDGE_LR_4[0]/LWL<4> RM_IHPSG13_1P_BITKIT_16x2_EDGE_LR_4[3]/LWL<5>
+ RM_IHPSG13_1P_BITKIT_16x2_EDGE_LR_6[1]/LWL<13> RM_IHPSG13_1P_COLUMN_256_0[3]/RM_IHPSG13_1P_BITKIT_16x2_SRAM_0[0]/A_BLT_BOT<1>
+ RM_IHPSG13_1P_BITKIT_16x2_EDGE_LR_7[0]/LWL<3> RM_IHPSG13_1P_COLUMN_256_0[3]/RM_IHPSG13_1P_BITKIT_16x2_SRAM_0[0]/A_BLC_BOT<0>
+ RM_IHPSG13_1P_BITKIT_16x2_EDGE_LR_7[3]/LWL<12> RM_IHPSG13_1P_BITKIT_16x2_EDGE_LR_5[0]/LWL<15>
+ RM_IHPSG13_1P_BITKIT_16x2_EDGE_LR_6[2]/LWL<0> RM_IHPSG13_1P_BITKIT_16x2_EDGE_LR_4[2]/LWL<6>
+ RM_IHPSG13_1P_BITKIT_16x2_EDGE_LR_6[3]/LWL<15> RM_IHPSG13_1P_BITKIT_16x2_EDGE_LR_7[2]/LWL<4>
+ RM_IHPSG13_1P_BITKIT_16x2_EDGE_LR_5[0]/LWL<4> RM_IHPSG13_1P_BITKIT_16x2_EDGE_LR_5[0]/LWL<13>
+ RM_IHPSG13_1P_COLUMN_256_0[3]/RM_IHPSG13_1P_BITKIT_16x2_SRAM_0[0]/A_BLC_BOT<1> RM_IHPSG13_1P_BITKIT_16x2_EDGE_LR_7[1]/LWL<12>
+ RM_IHPSG13_1P_BITKIT_16x2_EDGE_LR_7[1]/LWL<3> RM_IHPSG13_1P_BITKIT_16x2_EDGE_LR_6[0]/LWL<13>
+ RM_IHPSG13_1P_BITKIT_16x2_EDGE_LR_7[2]/LWL<2> RM_IHPSG13_1P_BITKIT_16x2_EDGE_LR_7[2]/LWL<5>
+ RM_IHPSG13_1P_BITKIT_16x2_EDGE_LR_5[2]/LWL<15> RM_IHPSG13_1P_BITKIT_16x2_EDGE_LR_5[0]/LWL<5>
+ RM_IHPSG13_1P_BITKIT_16x2_EDGE_LR_7[3]/LWL<14> RM_IHPSG13_1P_BITKIT_16x2_EDGE_LR_6[3]/LWL<5>
+ RM_IHPSG13_1P_BITKIT_16x2_EDGE_LR_4[1]/LWL<5> RM_IHPSG13_1P_BITKIT_16x2_EDGE_LR_5[3]/LWL<10>
+ RM_IHPSG13_1P_BITKIT_16x2_EDGE_LR_6[0]/LWL<12> RM_IHPSG13_1P_BITKIT_16x2_EDGE_LR_4[0]/LWL<0>
+ RM_IHPSG13_1P_BITKIT_16x2_EDGE_LR_6[1]/LWL<2> RM_IHPSG13_1P_BITKIT_16x2_EDGE_LR_7[2]/LWL<6>
+ RM_IHPSG13_1P_BITKIT_16x2_EDGE_LR_7[0]/LWL<9> RM_IHPSG13_1P_BITKIT_16x2_EDGE_LR_4[1]/LWL<10>
+ RM_IHPSG13_1P_BITKIT_16x2_EDGE_LR_5[0]/LWL<6> RM_IHPSG13_1P_BITKIT_16x2_EDGE_LR_7[0]/LWL<11>
+ RM_IHPSG13_1P_BITKIT_16x2_EDGE_LR_7[2]/LWL<3> RM_IHPSG13_1P_BITKIT_16x2_EDGE_LR_7[3]/LWL<15>
+ RM_IHPSG13_1P_BITKIT_16x2_EDGE_LR_6[3]/LWL<6> RM_IHPSG13_1P_BITKIT_16x2_EDGE_LR_4[1]/LWL<6>
+ RM_IHPSG13_1P_BITKIT_16x2_EDGE_LR_4[2]/LWL<10> RM_IHPSG13_1P_BITKIT_16x2_EDGE_LR_6[1]/LWL<3>
+ RM_IHPSG13_1P_BITKIT_16x2_EDGE_LR_6[0]/LWL<15> RM_IHPSG13_1P_BITKIT_16x2_EDGE_LR_6[3]/LWL<4>
+ RM_IHPSG13_1P_BITKIT_16x2_EDGE_LR_7[0]/LWL<6> RM_IHPSG13_1P_BITKIT_16x2_EDGE_LR_4[3]/LWL<14>
+ RM_IHPSG13_1P_BITKIT_16x2_EDGE_LR_7[2]/LWL<7> RM_IHPSG13_1P_BITKIT_16x2_EDGE_LR_5[0]/LWL<2>
+ RM_IHPSG13_1P_BITKIT_16x2_EDGE_LR_5[0]/LWL<7> RM_IHPSG13_1P_BITKIT_16x2_EDGE_LR_4[1]/LWL<11>
+ RM_IHPSG13_1P_BITKIT_16x2_EDGE_LR_7[0]/LWL<12> RM_IHPSG13_1P_BITKIT_16x2_EDGE_LR_5[0]/LWL<3>
+ RM_IHPSG13_1P_BITKIT_16x2_EDGE_LR_6[3]/LWL<7> RM_IHPSG13_1P_BITKIT_16x2_EDGE_LR_4[1]/LWL<7>
+ RM_IHPSG13_1P_BITKIT_16x2_EDGE_LR_7[1]/LWL<9> RM_IHPSG13_1P_COLUMN_256_0[6]/RM_IHPSG13_1P_BITKIT_16x2_SRAM_0[0]/A_BLT_BOT<0>
+ RM_IHPSG13_1P_BITKIT_16x2_EDGE_LR_5[2]/LWL<4> RM_IHPSG13_1P_BITKIT_16x2_EDGE_LR_7[2]/LWL<8>
+ RM_IHPSG13_1P_BITKIT_16x2_EDGE_LR_7[3]/LWL<13> RM_IHPSG13_1P_BITKIT_16x2_EDGE_LR_6[0]/LWL<9>
+ RM_IHPSG13_1P_BITKIT_16x2_EDGE_LR_4[1]/LWL<12> RM_IHPSG13_1P_BITKIT_16x2_EDGE_LR_7[0]/LWL<13>
+ RM_IHPSG13_1P_BITKIT_16x2_EDGE_LR_6[2]/LWL<3> RM_IHPSG13_1P_BITKIT_16x2_EDGE_LR_6[3]/LWL<8>
+ RM_IHPSG13_1P_BITKIT_16x2_EDGE_LR_4[1]/LWL<8> RM_IHPSG13_1P_COLUMN_256_0[6]/RM_IHPSG13_1P_BITKIT_16x2_SRAM_0[0]/A_BLT_BOT<1>
+ RM_IHPSG13_1P_BITKIT_16x2_EDGE_LR_6[1]/LWL<8> RM_IHPSG13_1P_BITKIT_16x2_EDGE_LR_6[0]/LWL<0>
+ RM_IHPSG13_1P_COLUMN_256_0[6]/RM_IHPSG13_1P_BITKIT_16x2_SRAM_0[0]/A_BLC_BOT<0> RM_IHPSG13_1P_BITKIT_16x2_EDGE_LR_4[1]/LWL<4>
+ RM_IHPSG13_1P_BITKIT_16x2_EDGE_LR_6[2]/LWL<13> RM_IHPSG13_1P_BITKIT_16x2_EDGE_LR_4[1]/LWL<13>
+ RM_IHPSG13_1P_BITKIT_16x2_EDGE_LR_7[0]/LWL<14> RM_IHPSG13_1P_BITKIT_16x2_EDGE_LR_7[3]/LWL<0>
+ RM_IHPSG13_1P_BITKIT_16x2_EDGE_LR_4[0]/LWL<3> RM_IHPSG13_1P_BITKIT_16x2_EDGE_LR_7[2]/LWL<9>
+ RM_IHPSG13_1P_BITKIT_16x2_EDGE_LR_5[1]/LWL<0> RM_IHPSG13_1P_BITKIT_16x2_EDGE_LR_5[1]/LWL<10>
+ RM_IHPSG13_1P_BITKIT_16x2_EDGE_LR_6[1]/LWL<9> RM_IHPSG13_1P_BITKIT_16x2_EDGE_LR_6[3]/LWL<0>
+ RM_IHPSG13_1P_BITKIT_16x2_EDGE_LR_7[0]/LWL<10> RM_IHPSG13_1P_BITKIT_16x2_EDGE_LR_4[2]/LWL<0>
+ RM_IHPSG13_1P_BITKIT_16x2_EDGE_LR_4[3]/LWL<6> RM_IHPSG13_1P_BITKIT_16x2_EDGE_LR_5[0]/LWL<8>
+ RM_IHPSG13_1P_BITKIT_16x2_EDGE_LR_6[0]/LWL<1> RM_IHPSG13_1P_COLUMN_256_0[6]/RM_IHPSG13_1P_BITKIT_16x2_SRAM_0[0]/A_BLC_BOT<1>
+ RM_IHPSG13_1P_BITKIT_16x2_EDGE_LR_7[1]/LWL<14> RM_IHPSG13_1P_BITKIT_16x2_EDGE_LR_6[3]/LWL<3>
+ RM_IHPSG13_1P_BITKIT_16x2_EDGE_LR_4[1]/LWL<14> RM_IHPSG13_1P_BITKIT_16x2_EDGE_LR_5[0]/LWL<9>
+ RM_IHPSG13_1P_BITKIT_16x2_EDGE_LR_7[0]/LWL<15> RM_IHPSG13_1P_BITKIT_16x2_EDGE_LR_7[3]/LWL<1>
+ RM_IHPSG13_1P_BITKIT_16x2_EDGE_LR_5[1]/LWL<1> RM_IHPSG13_1P_BITKIT_16x2_EDGE_LR_5[1]/LWL<11>
+ RM_IHPSG13_1P_BITKIT_16x2_EDGE_LR_5[2]/LWL<3> RM_IHPSG13_1P_COLUMN_256_0[1]/RM_IHPSG13_1P_BITKIT_16x2_SRAM_0[0]/A_BLT_BOT<0>
+ RM_IHPSG13_1P_BITKIT_16x2_EDGE_LR_7[2]/LWL<12> RM_IHPSG13_1P_BITKIT_16x2_EDGE_LR_5[2]/LWL<0>
+ RM_IHPSG13_1P_BITKIT_16x2_EDGE_LR_4[2]/LWL<1> RM_IHPSG13_1P_BITKIT_16x2_EDGE_LR_6[0]/LWL<2>
+ RM_IHPSG13_1P_BITKIT_16x2_EDGE_LR_4[1]/LWL<3> RM_IHPSG13_1P_BITKIT_16x2_EDGE_LR_7[3]/LWL<9>
+ RM_IHPSG13_1P_BITKIT_16x2_EDGE_LR_5[3]/LWL<15> RM_IHPSG13_1P_BITKIT_16x2_EDGE_LR_6[0]/LWL<14>
+ RM_IHPSG13_1P_BITKIT_16x2_EDGE_LR_4[1]/LWL<15> RM_IHPSG13_1P_BITKIT_16x2_EDGE_LR_4[0]/LWL<13>
+ RM_IHPSG13_1P_BITKIT_16x2_EDGE_LR_7[3]/LWL<2> RM_IHPSG13_1P_BITKIT_16x2_EDGE_LR_6[2]/LWL<9>
+ RM_IHPSG13_1P_BITKIT_16x2_EDGE_LR_5[1]/LWL<12> RM_IHPSG13_1P_COLUMN_256_0[1]/RM_IHPSG13_1P_BITKIT_16x2_SRAM_0[0]/A_BLT_BOT<1>
+ RM_IHPSG13_1P_COLUMN_256_0[1]/RM_IHPSG13_1P_BITKIT_16x2_SRAM_0[0]/A_BLC_BOT<0> RM_IHPSG13_1P_BITKIT_16x2_EDGE_LR_5[1]/LWL<9>
+ RM_IHPSG13_1P_BITKIT_16x2_EDGE_LR_4[2]/LWL<2> RM_IHPSG13_1P_BITKIT_16x2_EDGE_LR_4[1]/LWL<0>
+ RM_IHPSG13_1P_BITKIT_16x2_EDGE_LR_6[0]/LWL<3> RM_IHPSG13_1P_BITKIT_16x2_EDGE_LR_6[2]/LWL<2>
+ RM_IHPSG13_1P_BITKIT_16x2_EDGE_LR_4[2]/LWL<15> RM_IHPSG13_1P_BITKIT_16x2_EDGE_LR_5[3]/LWL<3>
+ RM_IHPSG13_1P_BITKIT_16x2_EDGE_LR_4[0]/LWL<9> RM_IHPSG13_1P_BITKIT_16x2_EDGE_LR_7[3]/LWL<3>
+ RM_IHPSG13_1P_BITKIT_16x2_EDGE_LR_5[1]/LWL<3> RM_IHPSG13_1P_BITKIT_16x2_EDGE_LR_5[1]/LWL<13>
+ RM_IHPSG13_1P_BITKIT_16x2_EDGE_LR_6[1]/LWL<10> RM_IHPSG13_1P_COLUMN_256_0[1]/RM_IHPSG13_1P_BITKIT_16x2_SRAM_0[0]/A_BLC_BOT<1>
+ RM_IHPSG13_1P_BITKIT_16x2_EDGE_LR_4[3]/LWL<10> RM_IHPSG13_1P_BITKIT_16x2_EDGE_LR_5[0]/LWL<12>
+ RM_IHPSG13_1P_BITKIT_16x2_EDGE_LR_4[2]/LWL<3> RM_IHPSG13_1P_BITKIT_16x2_EDGE_LR_6[0]/LWL<4>
+ RM_IHPSG13_1P_BITKIT_16x2_EDGE_LR_7[1]/LWL<6> RM_IHPSG13_1P_BITKIT_16x2_EDGE_LR_6[3]/LWL<9>
+ RM_IHPSG13_1P_BITKIT_16x2_EDGE_LR_5[1]/LWL<2> RM_IHPSG13_1P_BITKIT_16x2_EDGE_LR_7[3]/LWL<4>
+ RM_IHPSG13_1P_BITKIT_16x2_EDGE_LR_5[1]/LWL<4> RM_IHPSG13_1P_BITKIT_16x2_EDGE_LR_5[2]/LWL<9>
+ RM_IHPSG13_1P_BITKIT_16x2_EDGE_LR_5[1]/LWL<14> RM_IHPSG13_1P_BITKIT_16x2_EDGE_LR_6[1]/LWL<11>
+ RM_IHPSG13_1P_BITKIT_16x2_EDGE_LR_4[1]/LWL<9> RM_IHPSG13_1P_BITKIT_16x2_EDGE_LR_7[3]/LWL<8>
+ RM_IHPSG13_1P_BITKIT_16x2_EDGE_LR_6[0]/LWL<5> RM_IHPSG13_1P_BITKIT_16x2_EDGE_LR_5[3]/LWL<4>
+ RM_IHPSG13_1P_BITKIT_16x2_EDGE_LR_4[0]/LWL<2> RM_IHPSG13_1P_BITKIT_16x2_EDGE_LR_4[3]/LWL<3>
+ RM_IHPSG13_1P_BITKIT_16x2_EDGE_LR_7[3]/LWL<5> RM_IHPSG13_1P_BITKIT_16x2_EDGE_LR_7[0]/LWL<1>
+ RM_IHPSG13_1P_BITKIT_16x2_EDGE_LR_5[1]/LWL<5> RM_IHPSG13_1P_BITKIT_16x2_EDGE_LR_5[1]/LWL<15>
+ RM_IHPSG13_1P_BITKIT_16x2_EDGE_LR_6[1]/LWL<12> RM_IHPSG13_1P_BITKIT_16x2_EDGE_LR_4[2]/LWL<5>
+ RM_IHPSG13_1P_BITKIT_16x2_EDGE_LR_6[2]/LWL<8> RM_IHPSG13_1P_BITKIT_16x2_EDGE_LR_6[0]/LWL<6>
+ RM_IHPSG13_1P_COLUMN_256_0[7]/RM_IHPSG13_1P_BITKIT_16x2_SRAM_3[3]/VSS RM_IHPSG13_1P_COLUMN_256_0[7]/RM_IHPSG13_1P_BITKIT_16x2_SRAM_3[3]/VDD
+ RM_IHPSG13_1P_BITKIT_16x2_EDGE_LR_4[2]/LWL<4>
XRM_IHPSG13_1P_BITKIT_16x2_EDGE_LR_0[0] RM_IHPSG13_1P_BITKIT_16x2_EDGE_LR_0[0]/LWL<15>
+ RM_IHPSG13_1P_BITKIT_16x2_EDGE_LR_0[0]/LWL<14> RM_IHPSG13_1P_BITKIT_16x2_EDGE_LR_0[0]/LWL<12>
+ RM_IHPSG13_1P_BITKIT_16x2_EDGE_LR_0[0]/LWL<10> RM_IHPSG13_1P_BITKIT_16x2_EDGE_LR_0[0]/LWL<9>
+ RM_IHPSG13_1P_BITKIT_16x2_EDGE_LR_0[0]/LWL<8> RM_IHPSG13_1P_BITKIT_16x2_EDGE_LR_0[0]/LWL<7>
+ RM_IHPSG13_1P_BITKIT_16x2_EDGE_LR_0[0]/LWL<6> RM_IHPSG13_1P_BITKIT_16x2_EDGE_LR_0[0]/LWL<4>
+ RM_IHPSG13_1P_BITKIT_16x2_EDGE_LR_0[0]/LWL<3> RM_IHPSG13_1P_BITKIT_16x2_EDGE_LR_0[0]/LWL<1>
+ RM_IHPSG13_1P_BITKIT_16x2_EDGE_LR_0[0]/LWL<0> RM_IHPSG13_1P_BITKIT_16x2_EDGE_LR_0[0]/LWL<11>
+ RM_IHPSG13_1P_BITKIT_16x2_EDGE_LR_0[0]/LWL<13> RM_IHPSG13_1P_COLUMN_256_0[7]/RM_IHPSG13_1P_BITKIT_16x2_SRAM_3[3]/VSS
+ RM_IHPSG13_1P_BITKIT_16x2_EDGE_LR_0[0]/LWL<5> RM_IHPSG13_1P_BITKIT_16x2_EDGE_LR_0[0]/LWL<2>
+ RM_IHPSG13_1P_COLUMN_256_0[7]/RM_IHPSG13_1P_BITKIT_16x2_SRAM_3[3]/VDD RM_IHPSG13_1P_BITKIT_16x2_EDGE_LR
XRM_IHPSG13_1P_BITKIT_16x2_EDGE_LR_0[1] RM_IHPSG13_1P_BITKIT_16x2_EDGE_LR_0[1]/LWL<15>
+ RM_IHPSG13_1P_BITKIT_16x2_EDGE_LR_0[1]/LWL<14> RM_IHPSG13_1P_BITKIT_16x2_EDGE_LR_0[1]/LWL<12>
+ RM_IHPSG13_1P_BITKIT_16x2_EDGE_LR_0[1]/LWL<10> RM_IHPSG13_1P_BITKIT_16x2_EDGE_LR_0[1]/LWL<9>
+ RM_IHPSG13_1P_BITKIT_16x2_EDGE_LR_0[1]/LWL<8> RM_IHPSG13_1P_BITKIT_16x2_EDGE_LR_0[1]/LWL<7>
+ RM_IHPSG13_1P_BITKIT_16x2_EDGE_LR_0[1]/LWL<6> RM_IHPSG13_1P_BITKIT_16x2_EDGE_LR_0[1]/LWL<4>
+ RM_IHPSG13_1P_BITKIT_16x2_EDGE_LR_0[1]/LWL<3> RM_IHPSG13_1P_BITKIT_16x2_EDGE_LR_0[1]/LWL<1>
+ RM_IHPSG13_1P_BITKIT_16x2_EDGE_LR_0[1]/LWL<0> RM_IHPSG13_1P_BITKIT_16x2_EDGE_LR_0[1]/LWL<11>
+ RM_IHPSG13_1P_BITKIT_16x2_EDGE_LR_0[1]/LWL<13> RM_IHPSG13_1P_COLUMN_256_0[7]/RM_IHPSG13_1P_BITKIT_16x2_SRAM_3[3]/VSS
+ RM_IHPSG13_1P_BITKIT_16x2_EDGE_LR_0[1]/LWL<5> RM_IHPSG13_1P_BITKIT_16x2_EDGE_LR_0[1]/LWL<2>
+ RM_IHPSG13_1P_COLUMN_256_0[7]/RM_IHPSG13_1P_BITKIT_16x2_SRAM_3[3]/VDD RM_IHPSG13_1P_BITKIT_16x2_EDGE_LR
XRM_IHPSG13_1P_BITKIT_16x2_EDGE_LR_0[2] RM_IHPSG13_1P_BITKIT_16x2_EDGE_LR_0[2]/LWL<15>
+ RM_IHPSG13_1P_BITKIT_16x2_EDGE_LR_0[2]/LWL<14> RM_IHPSG13_1P_BITKIT_16x2_EDGE_LR_0[2]/LWL<12>
+ RM_IHPSG13_1P_BITKIT_16x2_EDGE_LR_0[2]/LWL<10> RM_IHPSG13_1P_BITKIT_16x2_EDGE_LR_0[2]/LWL<9>
+ RM_IHPSG13_1P_BITKIT_16x2_EDGE_LR_0[2]/LWL<8> RM_IHPSG13_1P_BITKIT_16x2_EDGE_LR_0[2]/LWL<7>
+ RM_IHPSG13_1P_BITKIT_16x2_EDGE_LR_0[2]/LWL<6> RM_IHPSG13_1P_BITKIT_16x2_EDGE_LR_0[2]/LWL<4>
+ RM_IHPSG13_1P_BITKIT_16x2_EDGE_LR_0[2]/LWL<3> RM_IHPSG13_1P_BITKIT_16x2_EDGE_LR_0[2]/LWL<1>
+ RM_IHPSG13_1P_BITKIT_16x2_EDGE_LR_0[2]/LWL<0> RM_IHPSG13_1P_BITKIT_16x2_EDGE_LR_0[2]/LWL<11>
+ RM_IHPSG13_1P_BITKIT_16x2_EDGE_LR_0[2]/LWL<13> RM_IHPSG13_1P_COLUMN_256_0[7]/RM_IHPSG13_1P_BITKIT_16x2_SRAM_3[3]/VSS
+ RM_IHPSG13_1P_BITKIT_16x2_EDGE_LR_0[2]/LWL<5> RM_IHPSG13_1P_BITKIT_16x2_EDGE_LR_0[2]/LWL<2>
+ RM_IHPSG13_1P_COLUMN_256_0[7]/RM_IHPSG13_1P_BITKIT_16x2_SRAM_3[3]/VDD RM_IHPSG13_1P_BITKIT_16x2_EDGE_LR
XRM_IHPSG13_1P_BITKIT_16x2_EDGE_LR_0[3] RM_IHPSG13_1P_BITKIT_16x2_EDGE_LR_0[3]/LWL<15>
+ RM_IHPSG13_1P_BITKIT_16x2_EDGE_LR_0[3]/LWL<14> RM_IHPSG13_1P_BITKIT_16x2_EDGE_LR_0[3]/LWL<12>
+ RM_IHPSG13_1P_BITKIT_16x2_EDGE_LR_0[3]/LWL<10> RM_IHPSG13_1P_BITKIT_16x2_EDGE_LR_0[3]/LWL<9>
+ RM_IHPSG13_1P_BITKIT_16x2_EDGE_LR_0[3]/LWL<8> RM_IHPSG13_1P_BITKIT_16x2_EDGE_LR_0[3]/LWL<7>
+ RM_IHPSG13_1P_BITKIT_16x2_EDGE_LR_0[3]/LWL<6> RM_IHPSG13_1P_BITKIT_16x2_EDGE_LR_0[3]/LWL<4>
+ RM_IHPSG13_1P_BITKIT_16x2_EDGE_LR_0[3]/LWL<3> RM_IHPSG13_1P_BITKIT_16x2_EDGE_LR_0[3]/LWL<1>
+ RM_IHPSG13_1P_BITKIT_16x2_EDGE_LR_0[3]/LWL<0> RM_IHPSG13_1P_BITKIT_16x2_EDGE_LR_0[3]/LWL<11>
+ RM_IHPSG13_1P_BITKIT_16x2_EDGE_LR_0[3]/LWL<13> RM_IHPSG13_1P_COLUMN_256_0[7]/RM_IHPSG13_1P_BITKIT_16x2_SRAM_3[3]/VSS
+ RM_IHPSG13_1P_BITKIT_16x2_EDGE_LR_0[3]/LWL<5> RM_IHPSG13_1P_BITKIT_16x2_EDGE_LR_0[3]/LWL<2>
+ RM_IHPSG13_1P_COLUMN_256_0[7]/RM_IHPSG13_1P_BITKIT_16x2_SRAM_3[3]/VDD RM_IHPSG13_1P_BITKIT_16x2_EDGE_LR
XRM_IHPSG13_1P_BITKIT_16x2_EDGE_LR_1[0] RM_IHPSG13_1P_BITKIT_16x2_EDGE_LR_1[0]/LWL<15>
+ RM_IHPSG13_1P_BITKIT_16x2_EDGE_LR_1[0]/LWL<14> RM_IHPSG13_1P_BITKIT_16x2_EDGE_LR_1[0]/LWL<12>
+ RM_IHPSG13_1P_BITKIT_16x2_EDGE_LR_1[0]/LWL<10> RM_IHPSG13_1P_BITKIT_16x2_EDGE_LR_1[0]/LWL<9>
+ RM_IHPSG13_1P_BITKIT_16x2_EDGE_LR_1[0]/LWL<8> RM_IHPSG13_1P_BITKIT_16x2_EDGE_LR_1[0]/LWL<7>
+ RM_IHPSG13_1P_BITKIT_16x2_EDGE_LR_1[0]/LWL<6> RM_IHPSG13_1P_BITKIT_16x2_EDGE_LR_1[0]/LWL<4>
+ RM_IHPSG13_1P_BITKIT_16x2_EDGE_LR_1[0]/LWL<3> RM_IHPSG13_1P_BITKIT_16x2_EDGE_LR_1[0]/LWL<1>
+ RM_IHPSG13_1P_BITKIT_16x2_EDGE_LR_1[0]/LWL<0> RM_IHPSG13_1P_BITKIT_16x2_EDGE_LR_1[0]/LWL<11>
+ RM_IHPSG13_1P_BITKIT_16x2_EDGE_LR_1[0]/LWL<13> RM_IHPSG13_1P_COLUMN_256_0[7]/RM_IHPSG13_1P_BITKIT_16x2_SRAM_3[3]/VSS
+ RM_IHPSG13_1P_BITKIT_16x2_EDGE_LR_1[0]/LWL<5> RM_IHPSG13_1P_BITKIT_16x2_EDGE_LR_1[0]/LWL<2>
+ RM_IHPSG13_1P_COLUMN_256_0[7]/RM_IHPSG13_1P_BITKIT_16x2_SRAM_3[3]/VDD RM_IHPSG13_1P_BITKIT_16x2_EDGE_LR
XRM_IHPSG13_1P_BITKIT_16x2_EDGE_LR_1[1] RM_IHPSG13_1P_BITKIT_16x2_EDGE_LR_1[1]/LWL<15>
+ RM_IHPSG13_1P_BITKIT_16x2_EDGE_LR_1[1]/LWL<14> RM_IHPSG13_1P_BITKIT_16x2_EDGE_LR_1[1]/LWL<12>
+ RM_IHPSG13_1P_BITKIT_16x2_EDGE_LR_1[1]/LWL<10> RM_IHPSG13_1P_BITKIT_16x2_EDGE_LR_1[1]/LWL<9>
+ RM_IHPSG13_1P_BITKIT_16x2_EDGE_LR_1[1]/LWL<8> RM_IHPSG13_1P_BITKIT_16x2_EDGE_LR_1[1]/LWL<7>
+ RM_IHPSG13_1P_BITKIT_16x2_EDGE_LR_1[1]/LWL<6> RM_IHPSG13_1P_BITKIT_16x2_EDGE_LR_1[1]/LWL<4>
+ RM_IHPSG13_1P_BITKIT_16x2_EDGE_LR_1[1]/LWL<3> RM_IHPSG13_1P_BITKIT_16x2_EDGE_LR_1[1]/LWL<1>
+ RM_IHPSG13_1P_BITKIT_16x2_EDGE_LR_1[1]/LWL<0> RM_IHPSG13_1P_BITKIT_16x2_EDGE_LR_1[1]/LWL<11>
+ RM_IHPSG13_1P_BITKIT_16x2_EDGE_LR_1[1]/LWL<13> RM_IHPSG13_1P_COLUMN_256_0[7]/RM_IHPSG13_1P_BITKIT_16x2_SRAM_3[3]/VSS
+ RM_IHPSG13_1P_BITKIT_16x2_EDGE_LR_1[1]/LWL<5> RM_IHPSG13_1P_BITKIT_16x2_EDGE_LR_1[1]/LWL<2>
+ RM_IHPSG13_1P_COLUMN_256_0[7]/RM_IHPSG13_1P_BITKIT_16x2_SRAM_3[3]/VDD RM_IHPSG13_1P_BITKIT_16x2_EDGE_LR
XRM_IHPSG13_1P_BITKIT_16x2_EDGE_LR_1[2] RM_IHPSG13_1P_BITKIT_16x2_EDGE_LR_1[2]/LWL<15>
+ RM_IHPSG13_1P_BITKIT_16x2_EDGE_LR_1[2]/LWL<14> RM_IHPSG13_1P_BITKIT_16x2_EDGE_LR_1[2]/LWL<12>
+ RM_IHPSG13_1P_BITKIT_16x2_EDGE_LR_1[2]/LWL<10> RM_IHPSG13_1P_BITKIT_16x2_EDGE_LR_1[2]/LWL<9>
+ RM_IHPSG13_1P_BITKIT_16x2_EDGE_LR_1[2]/LWL<8> RM_IHPSG13_1P_BITKIT_16x2_EDGE_LR_1[2]/LWL<7>
+ RM_IHPSG13_1P_BITKIT_16x2_EDGE_LR_1[2]/LWL<6> RM_IHPSG13_1P_BITKIT_16x2_EDGE_LR_1[2]/LWL<4>
+ RM_IHPSG13_1P_BITKIT_16x2_EDGE_LR_1[2]/LWL<3> RM_IHPSG13_1P_BITKIT_16x2_EDGE_LR_1[2]/LWL<1>
+ RM_IHPSG13_1P_BITKIT_16x2_EDGE_LR_1[2]/LWL<0> RM_IHPSG13_1P_BITKIT_16x2_EDGE_LR_1[2]/LWL<11>
+ RM_IHPSG13_1P_BITKIT_16x2_EDGE_LR_1[2]/LWL<13> RM_IHPSG13_1P_COLUMN_256_0[7]/RM_IHPSG13_1P_BITKIT_16x2_SRAM_3[3]/VSS
+ RM_IHPSG13_1P_BITKIT_16x2_EDGE_LR_1[2]/LWL<5> RM_IHPSG13_1P_BITKIT_16x2_EDGE_LR_1[2]/LWL<2>
+ RM_IHPSG13_1P_COLUMN_256_0[7]/RM_IHPSG13_1P_BITKIT_16x2_SRAM_3[3]/VDD RM_IHPSG13_1P_BITKIT_16x2_EDGE_LR
XRM_IHPSG13_1P_BITKIT_16x2_EDGE_LR_1[3] RM_IHPSG13_1P_BITKIT_16x2_EDGE_LR_1[3]/LWL<15>
+ RM_IHPSG13_1P_BITKIT_16x2_EDGE_LR_1[3]/LWL<14> RM_IHPSG13_1P_BITKIT_16x2_EDGE_LR_1[3]/LWL<12>
+ RM_IHPSG13_1P_BITKIT_16x2_EDGE_LR_1[3]/LWL<10> RM_IHPSG13_1P_BITKIT_16x2_EDGE_LR_1[3]/LWL<9>
+ RM_IHPSG13_1P_BITKIT_16x2_EDGE_LR_1[3]/LWL<8> RM_IHPSG13_1P_BITKIT_16x2_EDGE_LR_1[3]/LWL<7>
+ RM_IHPSG13_1P_BITKIT_16x2_EDGE_LR_1[3]/LWL<6> RM_IHPSG13_1P_BITKIT_16x2_EDGE_LR_1[3]/LWL<4>
+ RM_IHPSG13_1P_BITKIT_16x2_EDGE_LR_1[3]/LWL<3> RM_IHPSG13_1P_BITKIT_16x2_EDGE_LR_1[3]/LWL<1>
+ RM_IHPSG13_1P_BITKIT_16x2_EDGE_LR_1[3]/LWL<0> RM_IHPSG13_1P_BITKIT_16x2_EDGE_LR_1[3]/LWL<11>
+ RM_IHPSG13_1P_BITKIT_16x2_EDGE_LR_1[3]/LWL<13> RM_IHPSG13_1P_COLUMN_256_0[7]/RM_IHPSG13_1P_BITKIT_16x2_SRAM_3[3]/VSS
+ RM_IHPSG13_1P_BITKIT_16x2_EDGE_LR_1[3]/LWL<5> RM_IHPSG13_1P_BITKIT_16x2_EDGE_LR_1[3]/LWL<2>
+ RM_IHPSG13_1P_COLUMN_256_0[7]/RM_IHPSG13_1P_BITKIT_16x2_SRAM_3[3]/VDD RM_IHPSG13_1P_BITKIT_16x2_EDGE_LR
XRM_IHPSG13_1P_BITKIT_16x2_EDGE_LR_2[0] RM_IHPSG13_1P_BITKIT_16x2_EDGE_LR_2[0]/LWL<15>
+ RM_IHPSG13_1P_BITKIT_16x2_EDGE_LR_2[0]/LWL<14> RM_IHPSG13_1P_BITKIT_16x2_EDGE_LR_2[0]/LWL<12>
+ RM_IHPSG13_1P_BITKIT_16x2_EDGE_LR_2[0]/LWL<10> RM_IHPSG13_1P_BITKIT_16x2_EDGE_LR_2[0]/LWL<9>
+ RM_IHPSG13_1P_BITKIT_16x2_EDGE_LR_2[0]/LWL<8> RM_IHPSG13_1P_BITKIT_16x2_EDGE_LR_2[0]/LWL<7>
+ RM_IHPSG13_1P_BITKIT_16x2_EDGE_LR_2[0]/LWL<6> RM_IHPSG13_1P_BITKIT_16x2_EDGE_LR_2[0]/LWL<4>
+ RM_IHPSG13_1P_BITKIT_16x2_EDGE_LR_2[0]/LWL<3> RM_IHPSG13_1P_BITKIT_16x2_EDGE_LR_2[0]/LWL<1>
+ RM_IHPSG13_1P_BITKIT_16x2_EDGE_LR_2[0]/LWL<0> RM_IHPSG13_1P_BITKIT_16x2_EDGE_LR_2[0]/LWL<11>
+ RM_IHPSG13_1P_BITKIT_16x2_EDGE_LR_2[0]/LWL<13> RM_IHPSG13_1P_COLUMN_256_0[7]/RM_IHPSG13_1P_BITKIT_16x2_SRAM_3[3]/VSS
+ RM_IHPSG13_1P_BITKIT_16x2_EDGE_LR_2[0]/LWL<5> RM_IHPSG13_1P_BITKIT_16x2_EDGE_LR_2[0]/LWL<2>
+ RM_IHPSG13_1P_COLUMN_256_0[7]/RM_IHPSG13_1P_BITKIT_16x2_SRAM_3[3]/VDD RM_IHPSG13_1P_BITKIT_16x2_EDGE_LR
XRM_IHPSG13_1P_BITKIT_16x2_EDGE_LR_2[1] RM_IHPSG13_1P_BITKIT_16x2_EDGE_LR_2[1]/LWL<15>
+ RM_IHPSG13_1P_BITKIT_16x2_EDGE_LR_2[1]/LWL<14> RM_IHPSG13_1P_BITKIT_16x2_EDGE_LR_2[1]/LWL<12>
+ RM_IHPSG13_1P_BITKIT_16x2_EDGE_LR_2[1]/LWL<10> RM_IHPSG13_1P_BITKIT_16x2_EDGE_LR_2[1]/LWL<9>
+ RM_IHPSG13_1P_BITKIT_16x2_EDGE_LR_2[1]/LWL<8> RM_IHPSG13_1P_BITKIT_16x2_EDGE_LR_2[1]/LWL<7>
+ RM_IHPSG13_1P_BITKIT_16x2_EDGE_LR_2[1]/LWL<6> RM_IHPSG13_1P_BITKIT_16x2_EDGE_LR_2[1]/LWL<4>
+ RM_IHPSG13_1P_BITKIT_16x2_EDGE_LR_2[1]/LWL<3> RM_IHPSG13_1P_BITKIT_16x2_EDGE_LR_2[1]/LWL<1>
+ RM_IHPSG13_1P_BITKIT_16x2_EDGE_LR_2[1]/LWL<0> RM_IHPSG13_1P_BITKIT_16x2_EDGE_LR_2[1]/LWL<11>
+ RM_IHPSG13_1P_BITKIT_16x2_EDGE_LR_2[1]/LWL<13> RM_IHPSG13_1P_COLUMN_256_0[7]/RM_IHPSG13_1P_BITKIT_16x2_SRAM_3[3]/VSS
+ RM_IHPSG13_1P_BITKIT_16x2_EDGE_LR_2[1]/LWL<5> RM_IHPSG13_1P_BITKIT_16x2_EDGE_LR_2[1]/LWL<2>
+ RM_IHPSG13_1P_COLUMN_256_0[7]/RM_IHPSG13_1P_BITKIT_16x2_SRAM_3[3]/VDD RM_IHPSG13_1P_BITKIT_16x2_EDGE_LR
XRM_IHPSG13_1P_BITKIT_16x2_EDGE_LR_2[2] RM_IHPSG13_1P_BITKIT_16x2_EDGE_LR_2[2]/LWL<15>
+ RM_IHPSG13_1P_BITKIT_16x2_EDGE_LR_2[2]/LWL<14> RM_IHPSG13_1P_BITKIT_16x2_EDGE_LR_2[2]/LWL<12>
+ RM_IHPSG13_1P_BITKIT_16x2_EDGE_LR_2[2]/LWL<10> RM_IHPSG13_1P_BITKIT_16x2_EDGE_LR_2[2]/LWL<9>
+ RM_IHPSG13_1P_BITKIT_16x2_EDGE_LR_2[2]/LWL<8> RM_IHPSG13_1P_BITKIT_16x2_EDGE_LR_2[2]/LWL<7>
+ RM_IHPSG13_1P_BITKIT_16x2_EDGE_LR_2[2]/LWL<6> RM_IHPSG13_1P_BITKIT_16x2_EDGE_LR_2[2]/LWL<4>
+ RM_IHPSG13_1P_BITKIT_16x2_EDGE_LR_2[2]/LWL<3> RM_IHPSG13_1P_BITKIT_16x2_EDGE_LR_2[2]/LWL<1>
+ RM_IHPSG13_1P_BITKIT_16x2_EDGE_LR_2[2]/LWL<0> RM_IHPSG13_1P_BITKIT_16x2_EDGE_LR_2[2]/LWL<11>
+ RM_IHPSG13_1P_BITKIT_16x2_EDGE_LR_2[2]/LWL<13> RM_IHPSG13_1P_COLUMN_256_0[7]/RM_IHPSG13_1P_BITKIT_16x2_SRAM_3[3]/VSS
+ RM_IHPSG13_1P_BITKIT_16x2_EDGE_LR_2[2]/LWL<5> RM_IHPSG13_1P_BITKIT_16x2_EDGE_LR_2[2]/LWL<2>
+ RM_IHPSG13_1P_COLUMN_256_0[7]/RM_IHPSG13_1P_BITKIT_16x2_SRAM_3[3]/VDD RM_IHPSG13_1P_BITKIT_16x2_EDGE_LR
XRM_IHPSG13_1P_BITKIT_16x2_EDGE_LR_2[3] RM_IHPSG13_1P_BITKIT_16x2_EDGE_LR_2[3]/LWL<15>
+ RM_IHPSG13_1P_BITKIT_16x2_EDGE_LR_2[3]/LWL<14> RM_IHPSG13_1P_BITKIT_16x2_EDGE_LR_2[3]/LWL<12>
+ RM_IHPSG13_1P_BITKIT_16x2_EDGE_LR_2[3]/LWL<10> RM_IHPSG13_1P_BITKIT_16x2_EDGE_LR_2[3]/LWL<9>
+ RM_IHPSG13_1P_BITKIT_16x2_EDGE_LR_2[3]/LWL<8> RM_IHPSG13_1P_BITKIT_16x2_EDGE_LR_2[3]/LWL<7>
+ RM_IHPSG13_1P_BITKIT_16x2_EDGE_LR_2[3]/LWL<6> RM_IHPSG13_1P_BITKIT_16x2_EDGE_LR_2[3]/LWL<4>
+ RM_IHPSG13_1P_BITKIT_16x2_EDGE_LR_2[3]/LWL<3> RM_IHPSG13_1P_BITKIT_16x2_EDGE_LR_2[3]/LWL<1>
+ RM_IHPSG13_1P_BITKIT_16x2_EDGE_LR_2[3]/LWL<0> RM_IHPSG13_1P_BITKIT_16x2_EDGE_LR_2[3]/LWL<11>
+ RM_IHPSG13_1P_BITKIT_16x2_EDGE_LR_2[3]/LWL<13> RM_IHPSG13_1P_COLUMN_256_0[7]/RM_IHPSG13_1P_BITKIT_16x2_SRAM_3[3]/VSS
+ RM_IHPSG13_1P_BITKIT_16x2_EDGE_LR_2[3]/LWL<5> RM_IHPSG13_1P_BITKIT_16x2_EDGE_LR_2[3]/LWL<2>
+ RM_IHPSG13_1P_COLUMN_256_0[7]/RM_IHPSG13_1P_BITKIT_16x2_SRAM_3[3]/VDD RM_IHPSG13_1P_BITKIT_16x2_EDGE_LR
XRM_IHPSG13_1P_BITKIT_16x2_EDGE_LR_3[0] RM_IHPSG13_1P_BITKIT_16x2_EDGE_LR_3[0]/LWL<15>
+ RM_IHPSG13_1P_BITKIT_16x2_EDGE_LR_3[0]/LWL<14> RM_IHPSG13_1P_BITKIT_16x2_EDGE_LR_3[0]/LWL<12>
+ RM_IHPSG13_1P_BITKIT_16x2_EDGE_LR_3[0]/LWL<10> RM_IHPSG13_1P_BITKIT_16x2_EDGE_LR_3[0]/LWL<9>
+ RM_IHPSG13_1P_BITKIT_16x2_EDGE_LR_3[0]/LWL<8> RM_IHPSG13_1P_BITKIT_16x2_EDGE_LR_3[0]/LWL<7>
+ RM_IHPSG13_1P_BITKIT_16x2_EDGE_LR_3[0]/LWL<6> RM_IHPSG13_1P_BITKIT_16x2_EDGE_LR_3[0]/LWL<4>
+ RM_IHPSG13_1P_BITKIT_16x2_EDGE_LR_3[0]/LWL<3> RM_IHPSG13_1P_BITKIT_16x2_EDGE_LR_3[0]/LWL<1>
+ RM_IHPSG13_1P_BITKIT_16x2_EDGE_LR_3[0]/LWL<0> RM_IHPSG13_1P_BITKIT_16x2_EDGE_LR_3[0]/LWL<11>
+ RM_IHPSG13_1P_BITKIT_16x2_EDGE_LR_3[0]/LWL<13> RM_IHPSG13_1P_COLUMN_256_0[7]/RM_IHPSG13_1P_BITKIT_16x2_SRAM_3[3]/VSS
+ RM_IHPSG13_1P_BITKIT_16x2_EDGE_LR_3[0]/LWL<5> RM_IHPSG13_1P_BITKIT_16x2_EDGE_LR_3[0]/LWL<2>
+ RM_IHPSG13_1P_COLUMN_256_0[7]/RM_IHPSG13_1P_BITKIT_16x2_SRAM_3[3]/VDD RM_IHPSG13_1P_BITKIT_16x2_EDGE_LR
XRM_IHPSG13_1P_BITKIT_16x2_EDGE_LR_3[1] RM_IHPSG13_1P_BITKIT_16x2_EDGE_LR_3[1]/LWL<15>
+ RM_IHPSG13_1P_BITKIT_16x2_EDGE_LR_3[1]/LWL<14> RM_IHPSG13_1P_BITKIT_16x2_EDGE_LR_3[1]/LWL<12>
+ RM_IHPSG13_1P_BITKIT_16x2_EDGE_LR_3[1]/LWL<10> RM_IHPSG13_1P_BITKIT_16x2_EDGE_LR_3[1]/LWL<9>
+ RM_IHPSG13_1P_BITKIT_16x2_EDGE_LR_3[1]/LWL<8> RM_IHPSG13_1P_BITKIT_16x2_EDGE_LR_3[1]/LWL<7>
+ RM_IHPSG13_1P_BITKIT_16x2_EDGE_LR_3[1]/LWL<6> RM_IHPSG13_1P_BITKIT_16x2_EDGE_LR_3[1]/LWL<4>
+ RM_IHPSG13_1P_BITKIT_16x2_EDGE_LR_3[1]/LWL<3> RM_IHPSG13_1P_BITKIT_16x2_EDGE_LR_3[1]/LWL<1>
+ RM_IHPSG13_1P_BITKIT_16x2_EDGE_LR_3[1]/LWL<0> RM_IHPSG13_1P_BITKIT_16x2_EDGE_LR_3[1]/LWL<11>
+ RM_IHPSG13_1P_BITKIT_16x2_EDGE_LR_3[1]/LWL<13> RM_IHPSG13_1P_COLUMN_256_0[7]/RM_IHPSG13_1P_BITKIT_16x2_SRAM_3[3]/VSS
+ RM_IHPSG13_1P_BITKIT_16x2_EDGE_LR_3[1]/LWL<5> RM_IHPSG13_1P_BITKIT_16x2_EDGE_LR_3[1]/LWL<2>
+ RM_IHPSG13_1P_COLUMN_256_0[7]/RM_IHPSG13_1P_BITKIT_16x2_SRAM_3[3]/VDD RM_IHPSG13_1P_BITKIT_16x2_EDGE_LR
XRM_IHPSG13_1P_BITKIT_16x2_EDGE_LR_3[2] RM_IHPSG13_1P_BITKIT_16x2_EDGE_LR_3[2]/LWL<15>
+ RM_IHPSG13_1P_BITKIT_16x2_EDGE_LR_3[2]/LWL<14> RM_IHPSG13_1P_BITKIT_16x2_EDGE_LR_3[2]/LWL<12>
+ RM_IHPSG13_1P_BITKIT_16x2_EDGE_LR_3[2]/LWL<10> RM_IHPSG13_1P_BITKIT_16x2_EDGE_LR_3[2]/LWL<9>
+ RM_IHPSG13_1P_BITKIT_16x2_EDGE_LR_3[2]/LWL<8> RM_IHPSG13_1P_BITKIT_16x2_EDGE_LR_3[2]/LWL<7>
+ RM_IHPSG13_1P_BITKIT_16x2_EDGE_LR_3[2]/LWL<6> RM_IHPSG13_1P_BITKIT_16x2_EDGE_LR_3[2]/LWL<4>
+ RM_IHPSG13_1P_BITKIT_16x2_EDGE_LR_3[2]/LWL<3> RM_IHPSG13_1P_BITKIT_16x2_EDGE_LR_3[2]/LWL<1>
+ RM_IHPSG13_1P_BITKIT_16x2_EDGE_LR_3[2]/LWL<0> RM_IHPSG13_1P_BITKIT_16x2_EDGE_LR_3[2]/LWL<11>
+ RM_IHPSG13_1P_BITKIT_16x2_EDGE_LR_3[2]/LWL<13> RM_IHPSG13_1P_COLUMN_256_0[7]/RM_IHPSG13_1P_BITKIT_16x2_SRAM_3[3]/VSS
+ RM_IHPSG13_1P_BITKIT_16x2_EDGE_LR_3[2]/LWL<5> RM_IHPSG13_1P_BITKIT_16x2_EDGE_LR_3[2]/LWL<2>
+ RM_IHPSG13_1P_COLUMN_256_0[7]/RM_IHPSG13_1P_BITKIT_16x2_SRAM_3[3]/VDD RM_IHPSG13_1P_BITKIT_16x2_EDGE_LR
XRM_IHPSG13_1P_BITKIT_16x2_EDGE_LR_3[3] RM_IHPSG13_1P_BITKIT_16x2_EDGE_LR_3[3]/LWL<15>
+ RM_IHPSG13_1P_BITKIT_16x2_EDGE_LR_3[3]/LWL<14> RM_IHPSG13_1P_BITKIT_16x2_EDGE_LR_3[3]/LWL<12>
+ RM_IHPSG13_1P_BITKIT_16x2_EDGE_LR_3[3]/LWL<10> RM_IHPSG13_1P_BITKIT_16x2_EDGE_LR_3[3]/LWL<9>
+ RM_IHPSG13_1P_BITKIT_16x2_EDGE_LR_3[3]/LWL<8> RM_IHPSG13_1P_BITKIT_16x2_EDGE_LR_3[3]/LWL<7>
+ RM_IHPSG13_1P_BITKIT_16x2_EDGE_LR_3[3]/LWL<6> RM_IHPSG13_1P_BITKIT_16x2_EDGE_LR_3[3]/LWL<4>
+ RM_IHPSG13_1P_BITKIT_16x2_EDGE_LR_3[3]/LWL<3> RM_IHPSG13_1P_BITKIT_16x2_EDGE_LR_3[3]/LWL<1>
+ RM_IHPSG13_1P_BITKIT_16x2_EDGE_LR_3[3]/LWL<0> RM_IHPSG13_1P_BITKIT_16x2_EDGE_LR_3[3]/LWL<11>
+ RM_IHPSG13_1P_BITKIT_16x2_EDGE_LR_3[3]/LWL<13> RM_IHPSG13_1P_COLUMN_256_0[7]/RM_IHPSG13_1P_BITKIT_16x2_SRAM_3[3]/VSS
+ RM_IHPSG13_1P_BITKIT_16x2_EDGE_LR_3[3]/LWL<5> RM_IHPSG13_1P_BITKIT_16x2_EDGE_LR_3[3]/LWL<2>
+ RM_IHPSG13_1P_COLUMN_256_0[7]/RM_IHPSG13_1P_BITKIT_16x2_SRAM_3[3]/VDD RM_IHPSG13_1P_BITKIT_16x2_EDGE_LR
XRM_IHPSG13_1P_BITKIT_16x2_EDGE_LR_4[0] RM_IHPSG13_1P_BITKIT_16x2_EDGE_LR_4[0]/LWL<15>
+ RM_IHPSG13_1P_BITKIT_16x2_EDGE_LR_4[0]/LWL<14> RM_IHPSG13_1P_BITKIT_16x2_EDGE_LR_4[0]/LWL<12>
+ RM_IHPSG13_1P_BITKIT_16x2_EDGE_LR_4[0]/LWL<10> RM_IHPSG13_1P_BITKIT_16x2_EDGE_LR_4[0]/LWL<9>
+ RM_IHPSG13_1P_BITKIT_16x2_EDGE_LR_4[0]/LWL<8> RM_IHPSG13_1P_BITKIT_16x2_EDGE_LR_4[0]/LWL<7>
+ RM_IHPSG13_1P_BITKIT_16x2_EDGE_LR_4[0]/LWL<6> RM_IHPSG13_1P_BITKIT_16x2_EDGE_LR_4[0]/LWL<4>
+ RM_IHPSG13_1P_BITKIT_16x2_EDGE_LR_4[0]/LWL<3> RM_IHPSG13_1P_BITKIT_16x2_EDGE_LR_4[0]/LWL<1>
+ RM_IHPSG13_1P_BITKIT_16x2_EDGE_LR_4[0]/LWL<0> RM_IHPSG13_1P_BITKIT_16x2_EDGE_LR_4[0]/LWL<11>
+ RM_IHPSG13_1P_BITKIT_16x2_EDGE_LR_4[0]/LWL<13> RM_IHPSG13_1P_COLUMN_256_0[7]/RM_IHPSG13_1P_BITKIT_16x2_SRAM_3[3]/VSS
+ RM_IHPSG13_1P_BITKIT_16x2_EDGE_LR_4[0]/LWL<5> RM_IHPSG13_1P_BITKIT_16x2_EDGE_LR_4[0]/LWL<2>
+ RM_IHPSG13_1P_COLUMN_256_0[7]/RM_IHPSG13_1P_BITKIT_16x2_SRAM_3[3]/VDD RM_IHPSG13_1P_BITKIT_16x2_EDGE_LR
XRM_IHPSG13_1P_BITKIT_16x2_EDGE_LR_4[1] RM_IHPSG13_1P_BITKIT_16x2_EDGE_LR_4[1]/LWL<15>
+ RM_IHPSG13_1P_BITKIT_16x2_EDGE_LR_4[1]/LWL<14> RM_IHPSG13_1P_BITKIT_16x2_EDGE_LR_4[1]/LWL<12>
+ RM_IHPSG13_1P_BITKIT_16x2_EDGE_LR_4[1]/LWL<10> RM_IHPSG13_1P_BITKIT_16x2_EDGE_LR_4[1]/LWL<9>
+ RM_IHPSG13_1P_BITKIT_16x2_EDGE_LR_4[1]/LWL<8> RM_IHPSG13_1P_BITKIT_16x2_EDGE_LR_4[1]/LWL<7>
+ RM_IHPSG13_1P_BITKIT_16x2_EDGE_LR_4[1]/LWL<6> RM_IHPSG13_1P_BITKIT_16x2_EDGE_LR_4[1]/LWL<4>
+ RM_IHPSG13_1P_BITKIT_16x2_EDGE_LR_4[1]/LWL<3> RM_IHPSG13_1P_BITKIT_16x2_EDGE_LR_4[1]/LWL<1>
+ RM_IHPSG13_1P_BITKIT_16x2_EDGE_LR_4[1]/LWL<0> RM_IHPSG13_1P_BITKIT_16x2_EDGE_LR_4[1]/LWL<11>
+ RM_IHPSG13_1P_BITKIT_16x2_EDGE_LR_4[1]/LWL<13> RM_IHPSG13_1P_COLUMN_256_0[7]/RM_IHPSG13_1P_BITKIT_16x2_SRAM_3[3]/VSS
+ RM_IHPSG13_1P_BITKIT_16x2_EDGE_LR_4[1]/LWL<5> RM_IHPSG13_1P_BITKIT_16x2_EDGE_LR_4[1]/LWL<2>
+ RM_IHPSG13_1P_COLUMN_256_0[7]/RM_IHPSG13_1P_BITKIT_16x2_SRAM_3[3]/VDD RM_IHPSG13_1P_BITKIT_16x2_EDGE_LR
XRM_IHPSG13_1P_BITKIT_16x2_EDGE_LR_4[2] RM_IHPSG13_1P_BITKIT_16x2_EDGE_LR_4[2]/LWL<15>
+ RM_IHPSG13_1P_BITKIT_16x2_EDGE_LR_4[2]/LWL<14> RM_IHPSG13_1P_BITKIT_16x2_EDGE_LR_4[2]/LWL<12>
+ RM_IHPSG13_1P_BITKIT_16x2_EDGE_LR_4[2]/LWL<10> RM_IHPSG13_1P_BITKIT_16x2_EDGE_LR_4[2]/LWL<9>
+ RM_IHPSG13_1P_BITKIT_16x2_EDGE_LR_4[2]/LWL<8> RM_IHPSG13_1P_BITKIT_16x2_EDGE_LR_4[2]/LWL<7>
+ RM_IHPSG13_1P_BITKIT_16x2_EDGE_LR_4[2]/LWL<6> RM_IHPSG13_1P_BITKIT_16x2_EDGE_LR_4[2]/LWL<4>
+ RM_IHPSG13_1P_BITKIT_16x2_EDGE_LR_4[2]/LWL<3> RM_IHPSG13_1P_BITKIT_16x2_EDGE_LR_4[2]/LWL<1>
+ RM_IHPSG13_1P_BITKIT_16x2_EDGE_LR_4[2]/LWL<0> RM_IHPSG13_1P_BITKIT_16x2_EDGE_LR_4[2]/LWL<11>
+ RM_IHPSG13_1P_BITKIT_16x2_EDGE_LR_4[2]/LWL<13> RM_IHPSG13_1P_COLUMN_256_0[7]/RM_IHPSG13_1P_BITKIT_16x2_SRAM_3[3]/VSS
+ RM_IHPSG13_1P_BITKIT_16x2_EDGE_LR_4[2]/LWL<5> RM_IHPSG13_1P_BITKIT_16x2_EDGE_LR_4[2]/LWL<2>
+ RM_IHPSG13_1P_COLUMN_256_0[7]/RM_IHPSG13_1P_BITKIT_16x2_SRAM_3[3]/VDD RM_IHPSG13_1P_BITKIT_16x2_EDGE_LR
XRM_IHPSG13_1P_BITKIT_16x2_EDGE_LR_4[3] RM_IHPSG13_1P_BITKIT_16x2_EDGE_LR_4[3]/LWL<15>
+ RM_IHPSG13_1P_BITKIT_16x2_EDGE_LR_4[3]/LWL<14> RM_IHPSG13_1P_BITKIT_16x2_EDGE_LR_4[3]/LWL<12>
+ RM_IHPSG13_1P_BITKIT_16x2_EDGE_LR_4[3]/LWL<10> RM_IHPSG13_1P_BITKIT_16x2_EDGE_LR_4[3]/LWL<9>
+ RM_IHPSG13_1P_BITKIT_16x2_EDGE_LR_4[3]/LWL<8> RM_IHPSG13_1P_BITKIT_16x2_EDGE_LR_4[3]/LWL<7>
+ RM_IHPSG13_1P_BITKIT_16x2_EDGE_LR_4[3]/LWL<6> RM_IHPSG13_1P_BITKIT_16x2_EDGE_LR_4[3]/LWL<4>
+ RM_IHPSG13_1P_BITKIT_16x2_EDGE_LR_4[3]/LWL<3> RM_IHPSG13_1P_BITKIT_16x2_EDGE_LR_4[3]/LWL<1>
+ RM_IHPSG13_1P_BITKIT_16x2_EDGE_LR_4[3]/LWL<0> RM_IHPSG13_1P_BITKIT_16x2_EDGE_LR_4[3]/LWL<11>
+ RM_IHPSG13_1P_BITKIT_16x2_EDGE_LR_4[3]/LWL<13> RM_IHPSG13_1P_COLUMN_256_0[7]/RM_IHPSG13_1P_BITKIT_16x2_SRAM_3[3]/VSS
+ RM_IHPSG13_1P_BITKIT_16x2_EDGE_LR_4[3]/LWL<5> RM_IHPSG13_1P_BITKIT_16x2_EDGE_LR_4[3]/LWL<2>
+ RM_IHPSG13_1P_COLUMN_256_0[7]/RM_IHPSG13_1P_BITKIT_16x2_SRAM_3[3]/VDD RM_IHPSG13_1P_BITKIT_16x2_EDGE_LR
XRM_IHPSG13_1P_BITKIT_16x2_EDGE_LR_5[0] RM_IHPSG13_1P_BITKIT_16x2_EDGE_LR_5[0]/LWL<15>
+ RM_IHPSG13_1P_BITKIT_16x2_EDGE_LR_5[0]/LWL<14> RM_IHPSG13_1P_BITKIT_16x2_EDGE_LR_5[0]/LWL<12>
+ RM_IHPSG13_1P_BITKIT_16x2_EDGE_LR_5[0]/LWL<10> RM_IHPSG13_1P_BITKIT_16x2_EDGE_LR_5[0]/LWL<9>
+ RM_IHPSG13_1P_BITKIT_16x2_EDGE_LR_5[0]/LWL<8> RM_IHPSG13_1P_BITKIT_16x2_EDGE_LR_5[0]/LWL<7>
+ RM_IHPSG13_1P_BITKIT_16x2_EDGE_LR_5[0]/LWL<6> RM_IHPSG13_1P_BITKIT_16x2_EDGE_LR_5[0]/LWL<4>
+ RM_IHPSG13_1P_BITKIT_16x2_EDGE_LR_5[0]/LWL<3> RM_IHPSG13_1P_BITKIT_16x2_EDGE_LR_5[0]/LWL<1>
+ RM_IHPSG13_1P_BITKIT_16x2_EDGE_LR_5[0]/LWL<0> RM_IHPSG13_1P_BITKIT_16x2_EDGE_LR_5[0]/LWL<11>
+ RM_IHPSG13_1P_BITKIT_16x2_EDGE_LR_5[0]/LWL<13> RM_IHPSG13_1P_COLUMN_256_0[7]/RM_IHPSG13_1P_BITKIT_16x2_SRAM_3[3]/VSS
+ RM_IHPSG13_1P_BITKIT_16x2_EDGE_LR_5[0]/LWL<5> RM_IHPSG13_1P_BITKIT_16x2_EDGE_LR_5[0]/LWL<2>
+ RM_IHPSG13_1P_COLUMN_256_0[7]/RM_IHPSG13_1P_BITKIT_16x2_SRAM_3[3]/VDD RM_IHPSG13_1P_BITKIT_16x2_EDGE_LR
XRM_IHPSG13_1P_BITKIT_16x2_EDGE_LR_5[1] RM_IHPSG13_1P_BITKIT_16x2_EDGE_LR_5[1]/LWL<15>
+ RM_IHPSG13_1P_BITKIT_16x2_EDGE_LR_5[1]/LWL<14> RM_IHPSG13_1P_BITKIT_16x2_EDGE_LR_5[1]/LWL<12>
+ RM_IHPSG13_1P_BITKIT_16x2_EDGE_LR_5[1]/LWL<10> RM_IHPSG13_1P_BITKIT_16x2_EDGE_LR_5[1]/LWL<9>
+ RM_IHPSG13_1P_BITKIT_16x2_EDGE_LR_5[1]/LWL<8> RM_IHPSG13_1P_BITKIT_16x2_EDGE_LR_5[1]/LWL<7>
+ RM_IHPSG13_1P_BITKIT_16x2_EDGE_LR_5[1]/LWL<6> RM_IHPSG13_1P_BITKIT_16x2_EDGE_LR_5[1]/LWL<4>
+ RM_IHPSG13_1P_BITKIT_16x2_EDGE_LR_5[1]/LWL<3> RM_IHPSG13_1P_BITKIT_16x2_EDGE_LR_5[1]/LWL<1>
+ RM_IHPSG13_1P_BITKIT_16x2_EDGE_LR_5[1]/LWL<0> RM_IHPSG13_1P_BITKIT_16x2_EDGE_LR_5[1]/LWL<11>
+ RM_IHPSG13_1P_BITKIT_16x2_EDGE_LR_5[1]/LWL<13> RM_IHPSG13_1P_COLUMN_256_0[7]/RM_IHPSG13_1P_BITKIT_16x2_SRAM_3[3]/VSS
+ RM_IHPSG13_1P_BITKIT_16x2_EDGE_LR_5[1]/LWL<5> RM_IHPSG13_1P_BITKIT_16x2_EDGE_LR_5[1]/LWL<2>
+ RM_IHPSG13_1P_COLUMN_256_0[7]/RM_IHPSG13_1P_BITKIT_16x2_SRAM_3[3]/VDD RM_IHPSG13_1P_BITKIT_16x2_EDGE_LR
XRM_IHPSG13_1P_BITKIT_16x2_EDGE_LR_5[2] RM_IHPSG13_1P_BITKIT_16x2_EDGE_LR_5[2]/LWL<15>
+ RM_IHPSG13_1P_BITKIT_16x2_EDGE_LR_5[2]/LWL<14> RM_IHPSG13_1P_BITKIT_16x2_EDGE_LR_5[2]/LWL<12>
+ RM_IHPSG13_1P_BITKIT_16x2_EDGE_LR_5[2]/LWL<10> RM_IHPSG13_1P_BITKIT_16x2_EDGE_LR_5[2]/LWL<9>
+ RM_IHPSG13_1P_BITKIT_16x2_EDGE_LR_5[2]/LWL<8> RM_IHPSG13_1P_BITKIT_16x2_EDGE_LR_5[2]/LWL<7>
+ RM_IHPSG13_1P_BITKIT_16x2_EDGE_LR_5[2]/LWL<6> RM_IHPSG13_1P_BITKIT_16x2_EDGE_LR_5[2]/LWL<4>
+ RM_IHPSG13_1P_BITKIT_16x2_EDGE_LR_5[2]/LWL<3> RM_IHPSG13_1P_BITKIT_16x2_EDGE_LR_5[2]/LWL<1>
+ RM_IHPSG13_1P_BITKIT_16x2_EDGE_LR_5[2]/LWL<0> RM_IHPSG13_1P_BITKIT_16x2_EDGE_LR_5[2]/LWL<11>
+ RM_IHPSG13_1P_BITKIT_16x2_EDGE_LR_5[2]/LWL<13> RM_IHPSG13_1P_COLUMN_256_0[7]/RM_IHPSG13_1P_BITKIT_16x2_SRAM_3[3]/VSS
+ RM_IHPSG13_1P_BITKIT_16x2_EDGE_LR_5[2]/LWL<5> RM_IHPSG13_1P_BITKIT_16x2_EDGE_LR_5[2]/LWL<2>
+ RM_IHPSG13_1P_COLUMN_256_0[7]/RM_IHPSG13_1P_BITKIT_16x2_SRAM_3[3]/VDD RM_IHPSG13_1P_BITKIT_16x2_EDGE_LR
XRM_IHPSG13_1P_BITKIT_16x2_EDGE_LR_5[3] RM_IHPSG13_1P_BITKIT_16x2_EDGE_LR_5[3]/LWL<15>
+ RM_IHPSG13_1P_BITKIT_16x2_EDGE_LR_5[3]/LWL<14> RM_IHPSG13_1P_BITKIT_16x2_EDGE_LR_5[3]/LWL<12>
+ RM_IHPSG13_1P_BITKIT_16x2_EDGE_LR_5[3]/LWL<10> RM_IHPSG13_1P_BITKIT_16x2_EDGE_LR_5[3]/LWL<9>
+ RM_IHPSG13_1P_BITKIT_16x2_EDGE_LR_5[3]/LWL<8> RM_IHPSG13_1P_BITKIT_16x2_EDGE_LR_5[3]/LWL<7>
+ RM_IHPSG13_1P_BITKIT_16x2_EDGE_LR_5[3]/LWL<6> RM_IHPSG13_1P_BITKIT_16x2_EDGE_LR_5[3]/LWL<4>
+ RM_IHPSG13_1P_BITKIT_16x2_EDGE_LR_5[3]/LWL<3> RM_IHPSG13_1P_BITKIT_16x2_EDGE_LR_5[3]/LWL<1>
+ RM_IHPSG13_1P_BITKIT_16x2_EDGE_LR_5[3]/LWL<0> RM_IHPSG13_1P_BITKIT_16x2_EDGE_LR_5[3]/LWL<11>
+ RM_IHPSG13_1P_BITKIT_16x2_EDGE_LR_5[3]/LWL<13> RM_IHPSG13_1P_COLUMN_256_0[7]/RM_IHPSG13_1P_BITKIT_16x2_SRAM_3[3]/VSS
+ RM_IHPSG13_1P_BITKIT_16x2_EDGE_LR_5[3]/LWL<5> RM_IHPSG13_1P_BITKIT_16x2_EDGE_LR_5[3]/LWL<2>
+ RM_IHPSG13_1P_COLUMN_256_0[7]/RM_IHPSG13_1P_BITKIT_16x2_SRAM_3[3]/VDD RM_IHPSG13_1P_BITKIT_16x2_EDGE_LR
XRM_IHPSG13_1P_COLUMN_256_0[0] RM_IHPSG13_1P_COLUMN_256_0[0]/RM_IHPSG13_1P_BITKIT_16x2_SRAM_0[0]/A_BLT_BOT<0>
+ RM_IHPSG13_1P_BITKIT_16x2_EDGE_LR_5[1]/LWL<10> RM_IHPSG13_1P_BITKIT_16x2_EDGE_LR_5[0]/LWL<13>
+ RM_IHPSG13_1P_COLUMN_256_0[0]/RM_IHPSG13_1P_BITKIT_16x2_SRAM_0[0]/A_BLT_BOT<1> RM_IHPSG13_1P_BITKIT_16x2_EDGE_LR_6[2]/LWL<9>
+ RM_IHPSG13_1P_COLUMN_256_0[0]/RM_IHPSG13_1P_BITKIT_16x2_SRAM_0[0]/A_BLC_BOT<0> RM_IHPSG13_1P_BITKIT_16x2_EDGE_LR_5[2]/LWL<8>
+ RM_IHPSG13_1P_COLUMN_256_0[0]/RM_IHPSG13_1P_BITKIT_16x2_SRAM_0[3]/A_RWL<11> RM_IHPSG13_1P_COLUMN_256_0[0]/RM_IHPSG13_1P_BITKIT_16x2_SRAM_2[3]/A_RWL<5>
+ RM_IHPSG13_1P_COLUMN_256_0[0]/RM_IHPSG13_1P_BITKIT_16x2_SRAM_0[0]/A_BLC_BOT<1> RM_IHPSG13_1P_BITKIT_16x2_EDGE_LR_6[3]/LWL<0>
+ RM_IHPSG13_1P_BITKIT_16x2_EDGE_LR_5[1]/LWL<13> RM_IHPSG13_1P_BITKIT_16x2_EDGE_LR_6[3]/LWL<3>
+ RM_IHPSG13_1P_COLUMN_256_0[0]/RM_IHPSG13_1P_BITKIT_16x2_SRAM_1[3]/A_RWL<9> RM_IHPSG13_1P_BITKIT_16x2_EDGE_LR_4[3]/LWL<1>
+ RM_IHPSG13_1P_COLUMN_256_0[0]/RM_IHPSG13_1P_BITKIT_16x2_SRAM_0[0]/A_RWL<1> RM_IHPSG13_1P_BITKIT_16x2_EDGE_LR_7[3]/LWL<6>
+ RM_IHPSG13_1P_COLUMN_256_0[0]/RM_IHPSG13_1P_BITKIT_16x2_SRAM_2[3]/A_RWL<7> RM_IHPSG13_1P_BITKIT_16x2_EDGE_LR_5[2]/LWL<13>
+ RM_IHPSG13_1P_BITKIT_16x2_EDGE_LR_4[3]/LWL<2> RM_IHPSG13_1P_BITKIT_16x2_EDGE_LR_5[3]/LWL<5>
+ RM_IHPSG13_1P_COLUMN_256_0[0]/RM_IHPSG13_1P_BITKIT_16x2_SRAM_0[2]/A_RWL<14> RM_IHPSG13_1P_BITKIT_16x2_EDGE_LR_7[3]/LWL<8>
+ RM_IHPSG13_1P_BITKIT_16x2_EDGE_LR_5[3]/LWL<11> RM_IHPSG13_1P_COLUMN_256_0[0]/RM_IHPSG13_1P_BITKIT_16x2_SRAM_3[0]/A_RWL<12>
+ RM_IHPSG13_1P_COLUMN_256_0[0]/RM_IHPSG13_1P_BITKIT_16x2_SRAM_3[1]/A_RWL<10> RM_IHPSG13_1P_COLUMN_256_0[0]/RM_IHPSG13_1P_BITKIT_16x2_SRAM_0[3]/A_RWL<7>
+ RM_IHPSG13_1P_BITKIT_16x2_EDGE_LR_7[3]/LWL<2> RM_IHPSG13_1P_COLUMN_256_0[0]/RM_IHPSG13_1P_BITKIT_16x2_SRAM_3[0]/A_RWL<14>
+ RM_IHPSG13_1P_COLUMN_256_0[0]/RM_IHPSG13_1P_BITKIT_16x2_SRAM_1[0]/A_RWL<4> RM_IHPSG13_1P_BITKIT_16x2_EDGE_LR_5[2]/LWL<11>
+ RM_IHPSG13_1P_BITKIT_16x2_EDGE_LR_5[2]/LWL<14> RM_IHPSG13_1P_BITKIT_16x2_EDGE_LR_4[0]/LWL<15>
+ RM_IHPSG13_1P_COLUMN_256_0[0]/RM_IHPSG13_1P_BITKIT_16x2_SRAM_0[0]/A_RWL<5> RM_IHPSG13_1P_BITKIT_16x2_EDGE_LR_4[3]/LWL<7>
+ RM_IHPSG13_1P_BITKIT_16x2_EDGE_LR_6[3]/LWL<9> RM_IHPSG13_1P_BITKIT_16x2_EDGE_LR_4[1]/LWL<12>
+ RM_IHPSG13_1P_BITKIT_16x2_EDGE_LR_7[3]/LWL<4> RM_IHPSG13_1P_BITKIT_16x2_EDGE_LR_5[3]/LWL<13>
+ RM_IHPSG13_1P_COLUMN_256_0[0]/RM_IHPSG13_1P_BITKIT_16x2_SRAM_3[1]/A_RWL<12> RM_IHPSG13_1P_COLUMN_256_0[0]/RM_IHPSG13_1P_BITKIT_16x2_SRAM_0[0]/A_RWL<2>
+ RM_IHPSG13_1P_COLUMN_256_0[0]/RM_IHPSG13_1P_BITKIT_16x2_SRAM_0[3]/A_RWL<14> RM_IHPSG13_1P_COLUMN_256_0[0]/RM_IHPSG13_1P_BITKIT_16x2_SRAM_3[0]/A_RWL<10>
+ RM_IHPSG13_1P_COLUMN_256_0[0]/RM_IHPSG13_1P_BITKIT_16x2_SRAM_2[0]/A_RWL<3> RM_IHPSG13_1P_COLUMN_256_0[0]/RM_IHPSG13_1P_BITKIT_16x2_SRAM_3[3]/A_RWL<8>
+ RM_IHPSG13_1P_COLUMN_256_0[0]/RM_IHPSG13_1P_BITKIT_16x2_SRAM_0[0]/A_RWL<6> RM_IHPSG13_1P_BITKIT_16x2_EDGE_LR_5[3]/LWL<8>
+ RM_IHPSG13_1P_COLUMN_256_0[0]/RM_IHPSG13_1P_BITKIT_16x2_SRAM_2[0]/A_RWL<0> RM_IHPSG13_1P_BITKIT_16x2_EDGE_LR_7[0]/LWL<1>
+ RM_IHPSG13_1P_COLUMN_256_0[0]/RM_IHPSG13_1P_BITKIT_16x2_SRAM_3[0]/A_RWL<4> RM_IHPSG13_1P_COLUMN_256_0[0]/RM_IHPSG13_1P_BITKIT_16x2_SRAM_2[0]/A_RWL<5>
+ RM_IHPSG13_1P_BITKIT_16x2_EDGE_LR_5[3]/LWL<14> RM_IHPSG13_1P_BITKIT_16x2_EDGE_LR_5[1]/LWL<11>
+ RM_IHPSG13_1P_BITKIT_16x2_EDGE_LR_4[0]/LWL<0> RM_IHPSG13_1P_COLUMN_256_0[0]/RM_IHPSG13_1P_BITKIT_16x2_SRAM_3[2]/A_RWL<10>
+ RM_IHPSG13_1P_BITKIT_16x2_EDGE_LR_6[3]/LWL<5> RM_IHPSG13_1P_BITKIT_16x2_EDGE_LR_5[1]/LWL<14>
+ RM_IHPSG13_1P_BITKIT_16x2_EDGE_LR_7[3]/LWL<7> RM_IHPSG13_1P_BITKIT_16x2_EDGE_LR_6[2]/LWL<8>
+ RM_IHPSG13_1P_BITKIT_16x2_EDGE_LR_5[3]/LWL<4> RM_IHPSG13_1P_BITKIT_16x2_EDGE_LR_4[2]/LWL<7>
+ RM_IHPSG13_1P_COLUMN_256_0[0]/RM_IHPSG13_1P_BITKIT_16x2_SRAM_0[3]/A_RWL<13> RM_IHPSG13_1P_BITKIT_16x2_EDGE_LR_6[0]/LWL<10>
+ RM_IHPSG13_1P_COLUMN_256_0[0]/RM_IHPSG13_1P_BITKIT_16x2_SRAM_3[0]/A_RWL<2> RM_IHPSG13_1P_COLUMN_256_0[0]/RM_IHPSG13_1P_BITKIT_16x2_SRAM_2[0]/A_RWL<6>
+ RM_IHPSG13_1P_COLUMN_256_0[0]/RM_IHPSG13_1P_BITKIT_16x2_SRAM_3[1]/A_RWL<14> RM_IHPSG13_1P_COLUMN_256_0[0]/RM_IHPSG13_1P_BITKIT_16x2_SRAM_1[3]/A_RWL<8>
+ RM_IHPSG13_1P_COLUMN_256_0[0]/RM_IHPSG13_1P_BITKIT_16x2_SRAM_0[0]/A_RWL<8> RM_IHPSG13_1P_COLUMN_256_0[0]/RM_IHPSG13_1P_BITKIT_16x2_SRAM_0[0]/A_RWL<0>
+ RM_IHPSG13_1P_COLUMN_256_0[0]/RM_IHPSG13_1P_BITKIT_16x2_SRAM_3[3]/A_RWL<6> RM_IHPSG13_1P_BITKIT_16x2_EDGE_LR_4[1]/LWL<15>
+ RM_IHPSG13_1P_COLUMN_256_0[0]/RM_IHPSG13_1P_BITKIT_16x2_SRAM_2[3]/A_RWL<4> RM_IHPSG13_1P_COLUMN_256_0[0]/RM_IHPSG13_1P_BITKIT_16x2_SRAM_2[0]/A_RWL<7>
+ RM_IHPSG13_1P_BITKIT_16x2_EDGE_LR_4[2]/LWL<9> RM_IHPSG13_1P_BITKIT_16x2_EDGE_LR_4[2]/LWL<12>
+ RM_IHPSG13_1P_COLUMN_256_0[0]/RM_IHPSG13_1P_BITKIT_16x2_SRAM_0[1]/A_RWL<0> RM_IHPSG13_1P_BITKIT_16x2_EDGE_LR_5[0]/LWL<1>
+ RM_IHPSG13_1P_COLUMN_256_0[0]/RM_IHPSG13_1P_BITKIT_16x2_SRAM_2[0]/A_RWL<11> RM_IHPSG13_1P_BITKIT_16x2_EDGE_LR_4[0]/LWL<2>
+ RM_IHPSG13_1P_COLUMN_256_0[0]/RM_IHPSG13_1P_BITKIT_16x2_SRAM_3[2]/A_RWL<12> RM_IHPSG13_1P_BITKIT_16x2_EDGE_LR_5[0]/LWL<14>
+ RM_IHPSG13_1P_BITKIT_16x2_EDGE_LR_6[0]/LWL<3> RM_IHPSG13_1P_BITKIT_16x2_EDGE_LR_7[0]/LWL<4>
+ RM_IHPSG13_1P_COLUMN_256_0[0]/RM_IHPSG13_1P_BITKIT_16x2_SRAM_0[2]/A_RWL<13> RM_IHPSG13_1P_COLUMN_256_0[0]/RM_IHPSG13_1P_BITKIT_16x2_SRAM_1[0]/A_RWL<9>
+ RM_IHPSG13_1P_BITKIT_16x2_EDGE_LR_6[3]/LWL<8> RM_IHPSG13_1P_BITKIT_16x2_EDGE_LR_5[1]/LWL<12>
+ RM_IHPSG13_1P_COLUMN_256_0[0]/RM_IHPSG13_1P_BITKIT_16x2_SRAM_0[0]/A_RWL<7> RM_IHPSG13_1P_COLUMN_256_0[0]/RM_IHPSG13_1P_BITKIT_16x2_SRAM_1[3]/A_RWL<6>
+ RM_IHPSG13_1P_BITKIT_16x2_EDGE_LR_6[0]/LWL<4> RM_IHPSG13_1P_BITKIT_16x2_EDGE_LR_7[0]/LWL<2>
+ RM_IHPSG13_1P_COLUMN_256_0[0]/RM_IHPSG13_1P_BITKIT_16x2_SRAM_3[0]/A_RWL<15> RM_IHPSG13_1P_COLUMN_256_0[0]/RM_IHPSG13_1P_BITKIT_16x2_SRAM_3[3]/A_RWL<10>
+ RM_IHPSG13_1P_COLUMN_256_0[0]/RM_IHPSG13_1P_BITKIT_16x2_SRAM_2[1]/A_RWL<0> RM_IHPSG13_1P_BITKIT_16x2_EDGE_LR_6[0]/LWL<13>
+ RM_IHPSG13_1P_BITKIT_16x2_EDGE_LR_6[0]/LWL<11> RM_IHPSG13_1P_BITKIT_16x2_EDGE_LR_4[3]/LWL<10>
+ RM_IHPSG13_1P_BITKIT_16x2_EDGE_LR_6[1]/LWL<10> RM_IHPSG13_1P_COLUMN_256_0[0]/RM_IHPSG13_1P_BITKIT_16x2_SRAM_0[1]/A_RWL<2>
+ RM_IHPSG13_1P_BITKIT_16x2_EDGE_LR_5[0]/LWL<3> RM_IHPSG13_1P_BITKIT_16x2_EDGE_LR_7[3]/LWL<1>
+ RM_IHPSG13_1P_COLUMN_256_0[0]/RM_IHPSG13_1P_BITKIT_16x2_SRAM_3[2]/A_RWL<14> RM_IHPSG13_1P_BITKIT_16x2_EDGE_LR_4[3]/LWL<0>
+ RM_IHPSG13_1P_BITKIT_16x2_EDGE_LR_6[0]/LWL<5> RM_IHPSG13_1P_COLUMN_256_0[0]/RM_IHPSG13_1P_BITKIT_16x2_SRAM_3[3]/A_RWL<11>
+ RM_IHPSG13_1P_BITKIT_16x2_EDGE_LR_5[3]/LWL<6> RM_IHPSG13_1P_BITKIT_16x2_EDGE_LR_7[0]/LWL<6>
+ RM_IHPSG13_1P_COLUMN_256_0[0]/RM_IHPSG13_1P_BITKIT_16x2_SRAM_3[0]/A_RWL<9> RM_IHPSG13_1P_BITKIT_16x2_EDGE_LR_4[3]/LWL<9>
+ RM_IHPSG13_1P_BITKIT_16x2_EDGE_LR_6[0]/LWL<14> RM_IHPSG13_1P_COLUMN_256_0[0]/RM_IHPSG13_1P_BITKIT_16x2_SRAM_2[0]/A_RWL<13>
+ RM_IHPSG13_1P_BITKIT_16x2_EDGE_LR_4[2]/LWL<15> RM_IHPSG13_1P_BITKIT_16x2_EDGE_LR_6[1]/LWL<11>
+ RM_IHPSG13_1P_BITKIT_16x2_EDGE_LR_5[0]/LWL<4> RM_IHPSG13_1P_COLUMN_256_0[0]/RM_IHPSG13_1P_BITKIT_16x2_SRAM_3[0]/A_RWL<8>
+ RM_IHPSG13_1P_BITKIT_16x2_EDGE_LR_4[3]/LWL<12> RM_IHPSG13_1P_BITKIT_16x2_EDGE_LR_4[0]/LWL<5>
+ RM_IHPSG13_1P_COLUMN_256_0[0]/RM_IHPSG13_1P_BITKIT_16x2_SRAM_1[1]/A_RWL<1> RM_IHPSG13_1P_COLUMN_256_0[0]/RM_IHPSG13_1P_BITKIT_16x2_SRAM_2[1]/A_RWL<11>
+ RM_IHPSG13_1P_COLUMN_256_0[0]/RM_IHPSG13_1P_BITKIT_16x2_SRAM_3[1]/A_RWL<1> RM_IHPSG13_1P_COLUMN_256_0[0]/RM_IHPSG13_1P_BITKIT_16x2_SRAM_3[0]/A_RWL<1>
+ RM_IHPSG13_1P_COLUMN_256_0[0]/RM_IHPSG13_1P_BITKIT_16x2_SRAM_3[3]/A_RWL<12> RM_IHPSG13_1P_COLUMN_256_0[0]/RM_IHPSG13_1P_BITKIT_16x2_SRAM_2[1]/A_RWL<2>
+ RM_IHPSG13_1P_COLUMN_256_0[0]/RM_IHPSG13_1P_BITKIT_16x2_SRAM_1[1]/A_RWL<3> RM_IHPSG13_1P_BITKIT_16x2_EDGE_LR_5[3]/LWL<1>
+ RM_IHPSG13_1P_BITKIT_16x2_EDGE_LR_4[2]/LWL<10> RM_IHPSG13_1P_BITKIT_16x2_EDGE_LR_5[2]/LWL<12>
+ RM_IHPSG13_1P_COLUMN_256_0[0]/RM_IHPSG13_1P_BITKIT_16x2_SRAM_2[0]/A_RWL<15> RM_IHPSG13_1P_BITKIT_16x2_EDGE_LR_4[0]/LWL<6>
+ RM_IHPSG13_1P_COLUMN_256_0[0]/RM_IHPSG13_1P_BITKIT_16x2_SRAM_3[2]/A_RWL<11> RM_IHPSG13_1P_COLUMN_256_0[0]/RM_IHPSG13_1P_BITKIT_16x2_SRAM_3[1]/A_RWL<15>
+ RM_IHPSG13_1P_BITKIT_16x2_EDGE_LR_7[0]/LWL<7> RM_IHPSG13_1P_BITKIT_16x2_EDGE_LR_6[3]/LWL<6>
+ RM_IHPSG13_1P_COLUMN_256_0[0]/RM_IHPSG13_1P_BITKIT_16x2_SRAM_3[1]/A_RWL<2> RM_IHPSG13_1P_COLUMN_256_0[0]/RM_IHPSG13_1P_BITKIT_16x2_SRAM_2[1]/A_RWL<3>
+ RM_IHPSG13_1P_BITKIT_16x2_EDGE_LR_4[3]/LWL<3> RM_IHPSG13_1P_COLUMN_256_0[0]/RM_IHPSG13_1P_BITKIT_16x2_SRAM_1[1]/A_RWL<4>
+ RM_IHPSG13_1P_BITKIT_16x2_EDGE_LR_7[0]/LWL<0> RM_IHPSG13_1P_BITKIT_16x2_EDGE_LR_6[1]/LWL<13>
+ RM_IHPSG13_1P_COLUMN_256_0[0]/RM_IHPSG13_1P_BITKIT_16x2_SRAM_1[0]/A_RWL<8> RM_IHPSG13_1P_COLUMN_256_0[0]/RM_IHPSG13_1P_BITKIT_16x2_SRAM_0[1]/A_RWL<5>
+ RM_IHPSG13_1P_COLUMN_256_0[0]/RM_IHPSG13_1P_BITKIT_16x2_SRAM_2[3]/A_RWL<9> RM_IHPSG13_1P_BITKIT_16x2_EDGE_LR_4[0]/LWL<7>
+ RM_IHPSG13_1P_BITKIT_16x2_EDGE_LR_6[2]/LWL<10> RM_IHPSG13_1P_COLUMN_256_0[0]/RM_IHPSG13_1P_BITKIT_16x2_SRAM_1[0]/A_RWL<1>
+ RM_IHPSG13_1P_COLUMN_256_0[0]/RM_IHPSG13_1P_BITKIT_16x2_SRAM_2[1]/A_RWL<13> RM_IHPSG13_1P_COLUMN_256_0[0]/RM_IHPSG13_1P_BITKIT_16x2_SRAM_3[0]/A_RWL<6>
+ RM_IHPSG13_1P_BITKIT_16x2_EDGE_LR_6[0]/LWL<8> RM_IHPSG13_1P_COLUMN_256_0[0]/RM_IHPSG13_1P_BITKIT_16x2_SRAM_0[2]/A_RWL<15>
+ RM_IHPSG13_1P_BITKIT_16x2_EDGE_LR_5[3]/LWL<15> RM_IHPSG13_1P_COLUMN_256_0[0]/RM_IHPSG13_1P_BITKIT_16x2_SRAM_0[1]/A_RWL<4>
+ RM_IHPSG13_1P_COLUMN_256_0[0]/RM_IHPSG13_1P_BITKIT_16x2_SRAM_3[3]/A_RWL<14> RM_IHPSG13_1P_BITKIT_16x2_EDGE_LR_7[0]/LWL<9>
+ RM_IHPSG13_1P_COLUMN_256_0[0]/RM_IHPSG13_1P_BITKIT_16x2_SRAM_2[1]/A_RWL<4> RM_IHPSG13_1P_COLUMN_256_0[0]/RM_IHPSG13_1P_BITKIT_16x2_SRAM_2[0]/A_RWL<4>
+ RM_IHPSG13_1P_COLUMN_256_0[0]/RM_IHPSG13_1P_BITKIT_16x2_SRAM_3[3]/A_RWL<5> RM_IHPSG13_1P_BITKIT_16x2_EDGE_LR_4[1]/LWL<10>
+ RM_IHPSG13_1P_BITKIT_16x2_EDGE_LR_6[1]/LWL<14> RM_IHPSG13_1P_COLUMN_256_0[0]/RM_IHPSG13_1P_BITKIT_16x2_SRAM_0[1]/A_RWL<6>
+ RM_IHPSG13_1P_BITKIT_16x2_EDGE_LR_4[3]/LWL<15> RM_IHPSG13_1P_BITKIT_16x2_EDGE_LR_4[0]/LWL<8>
+ RM_IHPSG13_1P_COLUMN_256_0[0]/RM_IHPSG13_1P_BITKIT_16x2_SRAM_3[1]/A_RWL<11> RM_IHPSG13_1P_BITKIT_16x2_EDGE_LR_6[2]/LWL<11>
+ RM_IHPSG13_1P_BITKIT_16x2_EDGE_LR_7[1]/LWL<1> RM_IHPSG13_1P_COLUMN_256_0[0]/RM_IHPSG13_1P_BITKIT_16x2_SRAM_1[0]/A_RWL<10>
+ RM_IHPSG13_1P_BITKIT_16x2_EDGE_LR_6[0]/LWL<1> RM_IHPSG13_1P_BITKIT_16x2_EDGE_LR_7[3]/LWL<3>
+ RM_IHPSG13_1P_COLUMN_256_0[0]/RM_IHPSG13_1P_BITKIT_16x2_SRAM_2[1]/A_RWL<5> RM_IHPSG13_1P_BITKIT_16x2_EDGE_LR_5[0]/LWL<0>
+ RM_IHPSG13_1P_COLUMN_256_0[0]/RM_IHPSG13_1P_BITKIT_16x2_SRAM_2[2]/A_RWL<11> RM_IHPSG13_1P_BITKIT_16x2_EDGE_LR_5[3]/LWL<12>
+ RM_IHPSG13_1P_COLUMN_256_0[0]/RM_IHPSG13_1P_BITKIT_16x2_SRAM_1[1]/A_RWL<6> RM_IHPSG13_1P_COLUMN_256_0[0]/RM_IHPSG13_1P_BITKIT_16x2_SRAM_0[3]/A_RWL<9>
+ RM_IHPSG13_1P_BITKIT_16x2_EDGE_LR_4[1]/LWL<0> RM_IHPSG13_1P_COLUMN_256_0[0]/RM_IHPSG13_1P_BITKIT_16x2_SRAM_0[1]/A_RWL<7>
+ RM_IHPSG13_1P_COLUMN_256_0[0]/RM_IHPSG13_1P_BITKIT_16x2_SRAM_3[2]/A_RWL<15> RM_IHPSG13_1P_BITKIT_16x2_EDGE_LR_4[0]/LWL<9>
+ RM_IHPSG13_1P_COLUMN_256_0[0]/RM_IHPSG13_1P_BITKIT_16x2_SRAM_1[0]/A_RWL<6> RM_IHPSG13_1P_COLUMN_256_0[0]/RM_IHPSG13_1P_BITKIT_16x2_SRAM_2[1]/A_RWL<15>
+ RM_IHPSG13_1P_BITKIT_16x2_EDGE_LR_7[1]/LWL<2> RM_IHPSG13_1P_BITKIT_16x2_EDGE_LR_5[2]/LWL<15>
+ RM_IHPSG13_1P_COLUMN_256_0[0]/RM_IHPSG13_1P_BITKIT_16x2_SRAM_0[0]/A_RWL<4> RM_IHPSG13_1P_COLUMN_256_0[0]/RM_IHPSG13_1P_BITKIT_16x2_SRAM_1[3]/A_RWL<5>
+ RM_IHPSG13_1P_BITKIT_16x2_EDGE_LR_7[1]/LWL<0> RM_IHPSG13_1P_BITKIT_16x2_EDGE_LR_4[0]/LWL<10>
+ RM_IHPSG13_1P_BITKIT_16x2_EDGE_LR_5[0]/LWL<9> RM_IHPSG13_1P_BITKIT_16x2_EDGE_LR_7[0]/LWL<12>
+ RM_IHPSG13_1P_COLUMN_256_0[0]/RM_IHPSG13_1P_BITKIT_16x2_SRAM_0[0]/A_RWL<3> RM_IHPSG13_1P_COLUMN_256_0[0]/RM_IHPSG13_1P_BITKIT_16x2_SRAM_0[3]/A_RWL<15>
+ RM_IHPSG13_1P_COLUMN_256_0[0]/RM_IHPSG13_1P_BITKIT_16x2_SRAM_3[0]/A_RWL<11> RM_IHPSG13_1P_BITKIT_16x2_EDGE_LR_6[2]/LWL<13>
+ RM_IHPSG13_1P_COLUMN_256_0[0]/RM_IHPSG13_1P_BITKIT_16x2_SRAM_1[0]/A_RWL<12> RM_IHPSG13_1P_COLUMN_256_0[0]/RM_IHPSG13_1P_BITKIT_16x2_SRAM_3[1]/A_RWL<6>
+ RM_IHPSG13_1P_BITKIT_16x2_EDGE_LR_5[0]/LWL<6> RM_IHPSG13_1P_COLUMN_256_0[0]/RM_IHPSG13_1P_BITKIT_16x2_SRAM_2[1]/A_RWL<7>
+ RM_IHPSG13_1P_COLUMN_256_0[0]/RM_IHPSG13_1P_BITKIT_16x2_SRAM_2[2]/A_RWL<13> RM_IHPSG13_1P_COLUMN_256_0[0]/RM_IHPSG13_1P_BITKIT_16x2_SRAM_0[2]/A_RWL<0>
+ RM_IHPSG13_1P_BITKIT_16x2_EDGE_LR_5[1]/LWL<1> RM_IHPSG13_1P_COLUMN_256_0[0]/RM_IHPSG13_1P_BITKIT_16x2_SRAM_1[1]/A_RWL<8>
+ RM_IHPSG13_1P_BITKIT_16x2_EDGE_LR_4[1]/LWL<2> RM_IHPSG13_1P_BITKIT_16x2_EDGE_LR_6[1]/LWL<3>
+ RM_IHPSG13_1P_BITKIT_16x2_EDGE_LR_6[1]/LWL<1> RM_IHPSG13_1P_BITKIT_16x2_EDGE_LR_6[2]/LWL<14>
+ RM_IHPSG13_1P_BITKIT_16x2_EDGE_LR_6[0]/LWL<12> RM_IHPSG13_1P_BITKIT_16x2_EDGE_LR_7[1]/LWL<10>
+ RM_IHPSG13_1P_BITKIT_16x2_EDGE_LR_7[1]/LWL<4> RM_IHPSG13_1P_BITKIT_16x2_EDGE_LR_6[3]/LWL<4>
+ RM_IHPSG13_1P_BITKIT_16x2_EDGE_LR_5[1]/LWL<0> RM_IHPSG13_1P_BITKIT_16x2_EDGE_LR_5[1]/LWL<15>
+ RM_IHPSG13_1P_BITKIT_16x2_EDGE_LR_6[3]/LWL<11> RM_IHPSG13_1P_COLUMN_256_0[0]/RM_IHPSG13_1P_BITKIT_16x2_SRAM_1[0]/A_RWL<2>
+ RM_IHPSG13_1P_COLUMN_256_0[0]/RM_IHPSG13_1P_BITKIT_16x2_SRAM_1[1]/A_RWL<10> RM_IHPSG13_1P_COLUMN_256_0[0]/RM_IHPSG13_1P_BITKIT_16x2_SRAM_3[1]/A_RWL<5>
+ RM_IHPSG13_1P_BITKIT_16x2_EDGE_LR_7[0]/LWL<10> RM_IHPSG13_1P_COLUMN_256_0[0]/RM_IHPSG13_1P_BITKIT_16x2_SRAM_0[3]/A_RWL<12>
+ RM_IHPSG13_1P_COLUMN_256_0[0]/RM_IHPSG13_1P_BITKIT_16x2_SRAM_3[0]/A_RWL<3> RM_IHPSG13_1P_COLUMN_256_0[0]/RM_IHPSG13_1P_BITKIT_16x2_SRAM_1[1]/A_RWL<9>
+ RM_IHPSG13_1P_COLUMN_256_0[0]/RM_IHPSG13_1P_BITKIT_16x2_SRAM_3[3]/A_RWL<15> RM_IHPSG13_1P_COLUMN_256_0[0]/RM_IHPSG13_1P_BITKIT_16x2_SRAM_2[2]/A_RWL<12>
+ RM_IHPSG13_1P_BITKIT_16x2_EDGE_LR_4[1]/LWL<3> RM_IHPSG13_1P_COLUMN_256_0[0]/RM_IHPSG13_1P_BITKIT_16x2_SRAM_1[0]/A_RWL<11>
+ RM_IHPSG13_1P_COLUMN_256_0[0]/RM_IHPSG13_1P_BITKIT_16x2_SRAM_2[3]/A_RWL<10> RM_IHPSG13_1P_BITKIT_16x2_EDGE_LR_6[1]/LWL<4>
+ RM_IHPSG13_1P_BITKIT_16x2_EDGE_LR_6[2]/LWL<15> RM_IHPSG13_1P_COLUMN_256_0[0]/RM_IHPSG13_1P_BITKIT_16x2_SRAM_2[2]/A_RWL<0>
+ RM_IHPSG13_1P_BITKIT_16x2_EDGE_LR_6[0]/LWL<6> RM_IHPSG13_1P_COLUMN_256_0[0]/RM_IHPSG13_1P_BITKIT_16x2_SRAM_1[0]/A_RWL<14>
+ RM_IHPSG13_1P_COLUMN_256_0[0]/RM_IHPSG13_1P_BITKIT_16x2_SRAM_3[1]/A_RWL<8> RM_IHPSG13_1P_COLUMN_256_0[0]/RM_IHPSG13_1P_BITKIT_16x2_SRAM_3[3]/A_RWL<7>
+ RM_IHPSG13_1P_COLUMN_256_0[0]/RM_IHPSG13_1P_BITKIT_16x2_SRAM_1[2]/A_RWL<1> RM_IHPSG13_1P_BITKIT_16x2_EDGE_LR_7[1]/LWL<3>
+ RM_IHPSG13_1P_COLUMN_256_0[0]/RM_IHPSG13_1P_BITKIT_16x2_SRAM_2[1]/A_RWL<9> RM_IHPSG13_1P_COLUMN_256_0[0]/RM_IHPSG13_1P_BITKIT_16x2_SRAM_2[2]/A_RWL<15>
+ RM_IHPSG13_1P_COLUMN_256_0[0]/RM_IHPSG13_1P_BITKIT_16x2_SRAM_1[1]/A_RWL<11> RM_IHPSG13_1P_BITKIT_16x2_EDGE_LR_4[0]/LWL<3>
+ RM_IHPSG13_1P_COLUMN_256_0[0]/RM_IHPSG13_1P_BITKIT_16x2_SRAM_0[2]/A_RWL<2> RM_IHPSG13_1P_BITKIT_16x2_EDGE_LR_5[1]/LWL<3>
+ RM_IHPSG13_1P_BITKIT_16x2_EDGE_LR_7[2]/LWL<9> RM_IHPSG13_1P_BITKIT_16x2_EDGE_LR_4[0]/LWL<13>
+ RM_IHPSG13_1P_BITKIT_16x2_EDGE_LR_5[3]/LWL<2> RM_IHPSG13_1P_COLUMN_256_0[0]/RM_IHPSG13_1P_BITKIT_16x2_SRAM_0[1]/A_RWL<3>
+ RM_IHPSG13_1P_COLUMN_256_0[0]/RM_IHPSG13_1P_BITKIT_16x2_SRAM_0[1]/A_RWL<9> RM_IHPSG13_1P_COLUMN_256_0[0]/RM_IHPSG13_1P_BITKIT_16x2_SRAM_2[3]/A_RWL<12>
+ RM_IHPSG13_1P_BITKIT_16x2_EDGE_LR_4[3]/LWL<5> RM_IHPSG13_1P_BITKIT_16x2_EDGE_LR_4[2]/LWL<8>
+ RM_IHPSG13_1P_BITKIT_16x2_EDGE_LR_7[0]/LWL<15> RM_IHPSG13_1P_COLUMN_256_0[0]/RM_IHPSG13_1P_BITKIT_16x2_SRAM_2[0]/A_RWL<9>
+ RM_IHPSG13_1P_BITKIT_16x2_EDGE_LR_6[1]/LWL<5> RM_IHPSG13_1P_COLUMN_256_0[0]/RM_IHPSG13_1P_BITKIT_16x2_SRAM_3[2]/A_RWL<0>
+ RM_IHPSG13_1P_BITKIT_16x2_EDGE_LR_6[1]/LWL<15> RM_IHPSG13_1P_BITKIT_16x2_EDGE_LR_7[1]/LWL<12>
+ RM_IHPSG13_1P_BITKIT_16x2_EDGE_LR_7[1]/LWL<6> RM_IHPSG13_1P_BITKIT_16x2_EDGE_LR_5[0]/LWL<15>
+ RM_IHPSG13_1P_COLUMN_256_0[0]/RM_IHPSG13_1P_BITKIT_16x2_SRAM_3[1]/A_RWL<9> RM_IHPSG13_1P_BITKIT_16x2_EDGE_LR_6[3]/LWL<13>
+ RM_IHPSG13_1P_COLUMN_256_0[0]/RM_IHPSG13_1P_BITKIT_16x2_SRAM_1[1]/A_RWL<5> RM_IHPSG13_1P_COLUMN_256_0[0]/RM_IHPSG13_1P_BITKIT_16x2_SRAM_1[1]/A_RWL<12>
+ RM_IHPSG13_1P_COLUMN_256_0[0]/RM_IHPSG13_1P_BITKIT_16x2_SRAM_3[0]/A_RWL<5> RM_IHPSG13_1P_BITKIT_16x2_EDGE_LR_5[1]/LWL<4>
+ RM_IHPSG13_1P_COLUMN_256_0[0]/RM_IHPSG13_1P_BITKIT_16x2_SRAM_2[3]/A_RWL<13> RM_IHPSG13_1P_COLUMN_256_0[0]/RM_IHPSG13_1P_BITKIT_16x2_SRAM_2[1]/A_RWL<12>
+ RM_IHPSG13_1P_BITKIT_16x2_EDGE_LR_4[1]/LWL<5> RM_IHPSG13_1P_COLUMN_256_0[0]/RM_IHPSG13_1P_BITKIT_16x2_SRAM_0[3]/A_RWL<10>
+ RM_IHPSG13_1P_BITKIT_16x2_EDGE_LR_6[1]/LWL<12> RM_IHPSG13_1P_COLUMN_256_0[0]/RM_IHPSG13_1P_BITKIT_16x2_SRAM_2[2]/A_RWL<10>
+ RM_IHPSG13_1P_BITKIT_16x2_EDGE_LR_6[1]/LWL<6> RM_IHPSG13_1P_COLUMN_256_0[0]/RM_IHPSG13_1P_BITKIT_16x2_SRAM_3[2]/A_RWL<1>
+ RM_IHPSG13_1P_BITKIT_16x2_EDGE_LR_7[1]/LWL<13> RM_IHPSG13_1P_COLUMN_256_0[0]/RM_IHPSG13_1P_BITKIT_16x2_SRAM_1[3]/A_RWL<7>
+ RM_IHPSG13_1P_BITKIT_16x2_EDGE_LR_7[1]/LWL<7> RM_IHPSG13_1P_COLUMN_256_0[0]/RM_IHPSG13_1P_BITKIT_16x2_SRAM_2[2]/A_RWL<2>
+ RM_IHPSG13_1P_COLUMN_256_0[0]/RM_IHPSG13_1P_BITKIT_16x2_SRAM_1[1]/A_RWL<2> RM_IHPSG13_1P_COLUMN_256_0[0]/RM_IHPSG13_1P_BITKIT_16x2_SRAM_1[2]/A_RWL<0>
+ RM_IHPSG13_1P_COLUMN_256_0[0]/RM_IHPSG13_1P_BITKIT_16x2_SRAM_1[0]/A_RWL<15> RM_IHPSG13_1P_BITKIT_16x2_EDGE_LR_5[2]/LWL<9>
+ RM_IHPSG13_1P_BITKIT_16x2_EDGE_LR_6[3]/LWL<14> RM_IHPSG13_1P_COLUMN_256_0[0]/RM_IHPSG13_1P_BITKIT_16x2_SRAM_3[1]/A_RWL<0>
+ RM_IHPSG13_1P_COLUMN_256_0[0]/RM_IHPSG13_1P_BITKIT_16x2_SRAM_3[1]/A_RWL<3> RM_IHPSG13_1P_BITKIT_16x2_EDGE_LR_7[0]/LWL<3>
+ RM_IHPSG13_1P_COLUMN_256_0[0]/RM_IHPSG13_1P_BITKIT_16x2_SRAM_1[2]/A_RWL<3> RM_IHPSG13_1P_BITKIT_16x2_EDGE_LR_7[2]/LWL<10>
+ RM_IHPSG13_1P_BITKIT_16x2_EDGE_LR_6[3]/LWL<2> RM_IHPSG13_1P_COLUMN_256_0[0]/RM_IHPSG13_1P_BITKIT_16x2_SRAM_0[2]/A_RWL<4>
+ RM_IHPSG13_1P_COLUMN_256_0[0]/RM_IHPSG13_1P_BITKIT_16x2_SRAM_0[0]/A_RWL<9> RM_IHPSG13_1P_BITKIT_16x2_EDGE_LR_4[1]/LWL<6>
+ RM_IHPSG13_1P_COLUMN_256_0[0]/RM_IHPSG13_1P_BITKIT_16x2_SRAM_1[2]/A_RWL<10> RM_IHPSG13_1P_BITKIT_16x2_EDGE_LR_4[3]/LWL<11>
+ RM_IHPSG13_1P_COLUMN_256_0[0]/RM_IHPSG13_1P_BITKIT_16x2_SRAM_3[2]/A_RWL<2> RM_IHPSG13_1P_BITKIT_16x2_EDGE_LR_6[0]/LWL<15>
+ RM_IHPSG13_1P_BITKIT_16x2_EDGE_LR_7[3]/LWL<0> RM_IHPSG13_1P_BITKIT_16x2_EDGE_LR_4[3]/LWL<14>
+ RM_IHPSG13_1P_COLUMN_256_0[0]/RM_IHPSG13_1P_BITKIT_16x2_SRAM_2[2]/A_RWL<3> RM_IHPSG13_1P_BITKIT_16x2_EDGE_LR_7[0]/LWL<5>
+ RM_IHPSG13_1P_BITKIT_16x2_EDGE_LR_6[3]/LWL<15> RM_IHPSG13_1P_COLUMN_256_0[0]/RM_IHPSG13_1P_BITKIT_16x2_SRAM_1[0]/A_RWL<5>
+ RM_IHPSG13_1P_BITKIT_16x2_EDGE_LR_4[1]/LWL<13> RM_IHPSG13_1P_BITKIT_16x2_EDGE_LR_7[3]/LWL<9>
+ RM_IHPSG13_1P_COLUMN_256_0[0]/RM_IHPSG13_1P_BITKIT_16x2_SRAM_0[2]/A_RWL<3> RM_IHPSG13_1P_BITKIT_16x2_EDGE_LR_5[3]/LWL<7>
+ RM_IHPSG13_1P_BITKIT_16x2_EDGE_LR_4[0]/LWL<4> RM_IHPSG13_1P_COLUMN_256_0[0]/RM_IHPSG13_1P_BITKIT_16x2_SRAM_1[1]/A_RWL<14>
+ RM_IHPSG13_1P_COLUMN_256_0[0]/RM_IHPSG13_1P_BITKIT_16x2_SRAM_0[2]/A_RWL<5> RM_IHPSG13_1P_BITKIT_16x2_EDGE_LR_4[3]/LWL<8>
+ RM_IHPSG13_1P_BITKIT_16x2_EDGE_LR_5[1]/LWL<6> RM_IHPSG13_1P_COLUMN_256_0[0]/RM_IHPSG13_1P_BITKIT_16x2_SRAM_2[0]/A_RWL<12>
+ RM_IHPSG13_1P_COLUMN_256_0[0]/RM_IHPSG13_1P_BITKIT_16x2_SRAM_2[3]/A_RWL<15> RM_IHPSG13_1P_COLUMN_256_0[0]/RM_IHPSG13_1P_BITKIT_16x2_SRAM_1[2]/A_RWL<11>
+ RM_IHPSG13_1P_BITKIT_16x2_EDGE_LR_4[1]/LWL<7> RM_IHPSG13_1P_COLUMN_256_0[0]/RM_IHPSG13_1P_BITKIT_16x2_SRAM_2[0]/A_RWL<14>
+ RM_IHPSG13_1P_COLUMN_256_0[0]/RM_IHPSG13_1P_BITKIT_16x2_SRAM_3[3]/A_RWL<13> RM_IHPSG13_1P_BITKIT_16x2_EDGE_LR_7[2]/LWL<0>
+ RM_IHPSG13_1P_COLUMN_256_0[0]/RM_IHPSG13_1P_BITKIT_16x2_SRAM_2[1]/A_RWL<10> RM_IHPSG13_1P_BITKIT_16x2_EDGE_LR_6[1]/LWL<8>
+ RM_IHPSG13_1P_BITKIT_16x2_EDGE_LR_7[1]/LWL<15> RM_IHPSG13_1P_BITKIT_16x2_EDGE_LR_7[1]/LWL<9>
+ RM_IHPSG13_1P_COLUMN_256_0[0]/RM_IHPSG13_1P_BITKIT_16x2_SRAM_2[2]/A_RWL<4> RM_IHPSG13_1P_COLUMN_256_0[0]/RM_IHPSG13_1P_BITKIT_16x2_SRAM_1[1]/A_RWL<0>
+ RM_IHPSG13_1P_COLUMN_256_0[0]/RM_IHPSG13_1P_BITKIT_16x2_SRAM_3[1]/A_RWL<7> RM_IHPSG13_1P_COLUMN_256_0[0]/RM_IHPSG13_1P_BITKIT_16x2_SRAM_3[0]/A_RWL<0>
+ RM_IHPSG13_1P_COLUMN_256_0[0]/RM_IHPSG13_1P_BITKIT_16x2_SRAM_1[2]/A_RWL<5> RM_IHPSG13_1P_BITKIT_16x2_EDGE_LR_7[2]/LWL<12>
+ RM_IHPSG13_1P_COLUMN_256_0[0]/RM_IHPSG13_1P_BITKIT_16x2_SRAM_0[0]/A_RWL<11> RM_IHPSG13_1P_BITKIT_16x2_EDGE_LR_6[3]/LWL<1>
+ RM_IHPSG13_1P_BITKIT_16x2_EDGE_LR_5[1]/LWL<2> RM_IHPSG13_1P_BITKIT_16x2_EDGE_LR_6[2]/LWL<12>
+ RM_IHPSG13_1P_BITKIT_16x2_EDGE_LR_6[2]/LWL<0> RM_IHPSG13_1P_BITKIT_16x2_EDGE_LR_5[3]/LWL<0>
+ RM_IHPSG13_1P_COLUMN_256_0[0]/RM_IHPSG13_1P_BITKIT_16x2_SRAM_1[2]/A_RWL<12> RM_IHPSG13_1P_BITKIT_16x2_EDGE_LR_4[1]/LWL<8>
+ RM_IHPSG13_1P_BITKIT_16x2_EDGE_LR_4[2]/LWL<11> RM_IHPSG13_1P_BITKIT_16x2_EDGE_LR_7[2]/LWL<1>
+ RM_IHPSG13_1P_COLUMN_256_0[0]/RM_IHPSG13_1P_BITKIT_16x2_SRAM_1[2]/A_RWL<2> RM_IHPSG13_1P_BITKIT_16x2_EDGE_LR_5[0]/LWL<5>
+ RM_IHPSG13_1P_COLUMN_256_0[0]/RM_IHPSG13_1P_BITKIT_16x2_SRAM_1[1]/A_RWL<15> RM_IHPSG13_1P_BITKIT_16x2_EDGE_LR_5[3]/LWL<9>
+ RM_IHPSG13_1P_BITKIT_16x2_EDGE_LR_4[2]/LWL<14> RM_IHPSG13_1P_COLUMN_256_0[0]/RM_IHPSG13_1P_BITKIT_16x2_SRAM_3[2]/A_RWL<3>
+ RM_IHPSG13_1P_COLUMN_256_0[0]/RM_IHPSG13_1P_BITKIT_16x2_SRAM_2[2]/A_RWL<5> RM_IHPSG13_1P_BITKIT_16x2_EDGE_LR_6[3]/LWL<7>
+ RM_IHPSG13_1P_COLUMN_256_0[0]/RM_IHPSG13_1P_BITKIT_16x2_SRAM_1[2]/A_RWL<6> RM_IHPSG13_1P_BITKIT_16x2_EDGE_LR_7[2]/LWL<13>
+ RM_IHPSG13_1P_BITKIT_16x2_EDGE_LR_5[2]/LWL<7> RM_IHPSG13_1P_BITKIT_16x2_EDGE_LR_4[2]/LWL<0>
+ RM_IHPSG13_1P_COLUMN_256_0[0]/RM_IHPSG13_1P_BITKIT_16x2_SRAM_0[0]/A_RWL<12> RM_IHPSG13_1P_COLUMN_256_0[0]/RM_IHPSG13_1P_BITKIT_16x2_SRAM_0[2]/A_RWL<7>
+ RM_IHPSG13_1P_BITKIT_16x2_EDGE_LR_7[3]/LWL<10> RM_IHPSG13_1P_BITKIT_16x2_EDGE_LR_6[2]/LWL<1>
+ RM_IHPSG13_1P_COLUMN_256_0[0]/RM_IHPSG13_1P_BITKIT_16x2_SRAM_3[2]/A_RWL<13> RM_IHPSG13_1P_BITKIT_16x2_EDGE_LR_4[1]/LWL<9>
+ RM_IHPSG13_1P_COLUMN_256_0[0]/RM_IHPSG13_1P_BITKIT_16x2_SRAM_2[0]/A_RWL<10> RM_IHPSG13_1P_BITKIT_16x2_EDGE_LR_7[2]/LWL<2>
+ RM_IHPSG13_1P_COLUMN_256_0[0]/RM_IHPSG13_1P_BITKIT_16x2_SRAM_2[3]/A_RWL<8> RM_IHPSG13_1P_COLUMN_256_0[0]/RM_IHPSG13_1P_BITKIT_16x2_SRAM_3[2]/A_RWL<5>
+ RM_IHPSG13_1P_COLUMN_256_0[0]/RM_IHPSG13_1P_BITKIT_16x2_SRAM_1[3]/A_RWL<10> RM_IHPSG13_1P_BITKIT_16x2_EDGE_LR_7[1]/LWL<5>
+ RM_IHPSG13_1P_BITKIT_16x2_EDGE_LR_7[0]/LWL<8> RM_IHPSG13_1P_COLUMN_256_0[0]/RM_IHPSG13_1P_BITKIT_16x2_SRAM_1[1]/A_RWL<7>
+ RM_IHPSG13_1P_BITKIT_16x2_EDGE_LR_4[2]/LWL<13> RM_IHPSG13_1P_COLUMN_256_0[0]/RM_IHPSG13_1P_BITKIT_16x2_SRAM_1[0]/A_RWL<0>
+ RM_IHPSG13_1P_BITKIT_16x2_EDGE_LR_4[1]/LWL<4> RM_IHPSG13_1P_COLUMN_256_0[0]/RM_IHPSG13_1P_BITKIT_16x2_SRAM_3[0]/A_RWL<7>
+ RM_IHPSG13_1P_BITKIT_16x2_EDGE_LR_5[2]/LWL<0> RM_IHPSG13_1P_COLUMN_256_0[0]/RM_IHPSG13_1P_BITKIT_16x2_SRAM_1[2]/A_RWL<7>
+ RM_IHPSG13_1P_BITKIT_16x2_EDGE_LR_6[1]/LWL<2> RM_IHPSG13_1P_COLUMN_256_0[0]/RM_IHPSG13_1P_BITKIT_16x2_SRAM_0[0]/A_RWL<13>
+ RM_IHPSG13_1P_COLUMN_256_0[0]/RM_IHPSG13_1P_BITKIT_16x2_SRAM_2[1]/A_RWL<14> RM_IHPSG13_1P_BITKIT_16x2_EDGE_LR_4[2]/LWL<1>
+ RM_IHPSG13_1P_BITKIT_16x2_EDGE_LR_5[1]/LWL<9> RM_IHPSG13_1P_BITKIT_16x2_EDGE_LR_5[0]/LWL<2>
+ RM_IHPSG13_1P_COLUMN_256_0[0]/RM_IHPSG13_1P_BITKIT_16x2_SRAM_3[3]/A_RWL<4> RM_IHPSG13_1P_BITKIT_16x2_EDGE_LR_7[2]/LWL<11>
+ RM_IHPSG13_1P_BITKIT_16x2_EDGE_LR_7[3]/LWL<11> RM_IHPSG13_1P_BITKIT_16x2_EDGE_LR_6[2]/LWL<2>
+ RM_IHPSG13_1P_COLUMN_256_0[0]/RM_IHPSG13_1P_BITKIT_16x2_SRAM_1[2]/A_RWL<14> RM_IHPSG13_1P_BITKIT_16x2_EDGE_LR_4[1]/LWL<11>
+ RM_IHPSG13_1P_COLUMN_256_0[0]/RM_IHPSG13_1P_BITKIT_16x2_SRAM_0[1]/A_RWL<10> RM_IHPSG13_1P_BITKIT_16x2_EDGE_LR_7[2]/LWL<3>
+ RM_IHPSG13_1P_BITKIT_16x2_EDGE_LR_7[2]/LWL<14> RM_IHPSG13_1P_COLUMN_256_0[0]/RM_IHPSG13_1P_BITKIT_16x2_SRAM_3[2]/A_RWL<6>
+ RM_IHPSG13_1P_COLUMN_256_0[0]/RM_IHPSG13_1P_BITKIT_16x2_SRAM_1[3]/A_RWL<11> RM_IHPSG13_1P_BITKIT_16x2_EDGE_LR_4[1]/LWL<14>
+ RM_IHPSG13_1P_COLUMN_256_0[0]/RM_IHPSG13_1P_BITKIT_16x2_SRAM_2[2]/A_RWL<7> RM_IHPSG13_1P_COLUMN_256_0[0]/RM_IHPSG13_1P_BITKIT_16x2_SRAM_0[3]/A_RWL<0>
+ RM_IHPSG13_1P_BITKIT_16x2_EDGE_LR_6[0]/LWL<0> RM_IHPSG13_1P_COLUMN_256_0[0]/RM_IHPSG13_1P_BITKIT_16x2_SRAM_1[2]/A_RWL<8>
+ RM_IHPSG13_1P_BITKIT_16x2_EDGE_LR_5[2]/LWL<1> RM_IHPSG13_1P_BITKIT_16x2_EDGE_LR_7[2]/LWL<15>
+ RM_IHPSG13_1P_BITKIT_16x2_EDGE_LR_6[3]/LWL<12> RM_IHPSG13_1P_BITKIT_16x2_EDGE_LR_5[1]/LWL<7>
+ RM_IHPSG13_1P_COLUMN_256_0[0]/RM_IHPSG13_1P_BITKIT_16x2_SRAM_0[2]/A_RWL<9> RM_IHPSG13_1P_COLUMN_256_0[0]/RM_IHPSG13_1P_BITKIT_16x2_SRAM_0[0]/A_RWL<14>
+ RM_IHPSG13_1P_BITKIT_16x2_EDGE_LR_4[2]/LWL<2> RM_IHPSG13_1P_COLUMN_256_0[0]/RM_IHPSG13_1P_BITKIT_16x2_SRAM_1[2]/A_RWL<13>
+ RM_IHPSG13_1P_BITKIT_16x2_EDGE_LR_6[0]/LWL<9> RM_IHPSG13_1P_BITKIT_16x2_EDGE_LR_7[3]/LWL<12>
+ RM_IHPSG13_1P_BITKIT_16x2_EDGE_LR_6[2]/LWL<3> RM_IHPSG13_1P_COLUMN_256_0[0]/RM_IHPSG13_1P_BITKIT_16x2_SRAM_3[1]/A_RWL<13>
+ RM_IHPSG13_1P_BITKIT_16x2_EDGE_LR_5[1]/LWL<5> RM_IHPSG13_1P_COLUMN_256_0[0]/RM_IHPSG13_1P_BITKIT_16x2_SRAM_0[0]/A_RWL<10>
+ RM_IHPSG13_1P_COLUMN_256_0[0]/RM_IHPSG13_1P_BITKIT_16x2_SRAM_0[3]/A_RWL<8> RM_IHPSG13_1P_COLUMN_256_0[0]/RM_IHPSG13_1P_BITKIT_16x2_SRAM_1[2]/A_RWL<15>
+ RM_IHPSG13_1P_BITKIT_16x2_EDGE_LR_5[0]/LWL<8> RM_IHPSG13_1P_COLUMN_256_0[0]/RM_IHPSG13_1P_BITKIT_16x2_SRAM_0[1]/A_RWL<11>
+ RM_IHPSG13_1P_COLUMN_256_0[0]/RM_IHPSG13_1P_BITKIT_16x2_SRAM_3[3]/A_RWL<3> RM_IHPSG13_1P_BITKIT_16x2_EDGE_LR_7[2]/LWL<4>
+ RM_IHPSG13_1P_COLUMN_256_0[0]/RM_IHPSG13_1P_BITKIT_16x2_SRAM_3[2]/A_RWL<7> RM_IHPSG13_1P_COLUMN_256_0[0]/RM_IHPSG13_1P_BITKIT_16x2_SRAM_1[3]/A_RWL<12>
+ RM_IHPSG13_1P_COLUMN_256_0[0]/RM_IHPSG13_1P_BITKIT_16x2_SRAM_1[0]/A_RWL<7> RM_IHPSG13_1P_COLUMN_256_0[0]/RM_IHPSG13_1P_BITKIT_16x2_SRAM_1[3]/A_RWL<0>
+ RM_IHPSG13_1P_COLUMN_256_0[0]/RM_IHPSG13_1P_BITKIT_16x2_SRAM_2[2]/A_RWL<8> RM_IHPSG13_1P_COLUMN_256_0[0]/RM_IHPSG13_1P_BITKIT_16x2_SRAM_2[3]/A_RWL<6>
+ RM_IHPSG13_1P_COLUMN_256_0[0]/RM_IHPSG13_1P_BITKIT_16x2_SRAM_2[2]/A_RWL<1> RM_IHPSG13_1P_COLUMN_256_0[0]/RM_IHPSG13_1P_BITKIT_16x2_SRAM_0[3]/A_RWL<1>
+ RM_IHPSG13_1P_BITKIT_16x2_EDGE_LR_5[2]/LWL<2> RM_IHPSG13_1P_COLUMN_256_0[0]/RM_IHPSG13_1P_BITKIT_16x2_SRAM_1[2]/A_RWL<9>
+ RM_IHPSG13_1P_BITKIT_16x2_EDGE_LR_6[0]/LWL<2> RM_IHPSG13_1P_BITKIT_16x2_EDGE_LR_4[2]/LWL<3>
+ RM_IHPSG13_1P_COLUMN_256_0[0]/RM_IHPSG13_1P_BITKIT_16x2_SRAM_0[0]/A_RWL<15> RM_IHPSG13_1P_BITKIT_16x2_EDGE_LR_7[1]/LWL<11>
+ RM_IHPSG13_1P_COLUMN_256_0[0]/RM_IHPSG13_1P_BITKIT_16x2_SRAM_3[2]/A_RWL<4> RM_IHPSG13_1P_BITKIT_16x2_EDGE_LR_7[3]/LWL<13>
+ RM_IHPSG13_1P_BITKIT_16x2_EDGE_LR_6[2]/LWL<4> RM_IHPSG13_1P_BITKIT_16x2_EDGE_LR_4[0]/LWL<11>
+ RM_IHPSG13_1P_COLUMN_256_0[0]/RM_IHPSG13_1P_BITKIT_16x2_SRAM_0[1]/A_RWL<12> RM_IHPSG13_1P_BITKIT_16x2_EDGE_LR_5[3]/LWL<10>
+ RM_IHPSG13_1P_BITKIT_16x2_EDGE_LR_4[0]/LWL<1> RM_IHPSG13_1P_BITKIT_16x2_EDGE_LR_7[1]/LWL<8>
+ RM_IHPSG13_1P_BITKIT_16x2_EDGE_LR_7[1]/LWL<14> RM_IHPSG13_1P_BITKIT_16x2_EDGE_LR_7[2]/LWL<5>
+ RM_IHPSG13_1P_COLUMN_256_0[0]/RM_IHPSG13_1P_BITKIT_16x2_SRAM_2[3]/A_RWL<0> RM_IHPSG13_1P_BITKIT_16x2_EDGE_LR_4[3]/LWL<13>
+ RM_IHPSG13_1P_COLUMN_256_0[0]/RM_IHPSG13_1P_BITKIT_16x2_SRAM_3[2]/A_RWL<8> RM_IHPSG13_1P_COLUMN_256_0[0]/RM_IHPSG13_1P_BITKIT_16x2_SRAM_1[3]/A_RWL<13>
+ RM_IHPSG13_1P_BITKIT_16x2_EDGE_LR_4[0]/LWL<14> RM_IHPSG13_1P_COLUMN_256_0[0]/RM_IHPSG13_1P_BITKIT_16x2_SRAM_1[3]/A_RWL<1>
+ RM_IHPSG13_1P_COLUMN_256_0[0]/RM_IHPSG13_1P_BITKIT_16x2_SRAM_2[2]/A_RWL<9> RM_IHPSG13_1P_BITKIT_16x2_EDGE_LR_6[1]/LWL<7>
+ RM_IHPSG13_1P_COLUMN_256_0[0]/RM_IHPSG13_1P_BITKIT_16x2_SRAM_2[2]/A_RWL<14> RM_IHPSG13_1P_COLUMN_256_0[0]/RM_IHPSG13_1P_BITKIT_16x2_SRAM_0[3]/A_RWL<2>
+ RM_IHPSG13_1P_BITKIT_16x2_EDGE_LR_5[2]/LWL<3> RM_IHPSG13_1P_BITKIT_16x2_EDGE_LR_5[0]/LWL<7>
+ RM_IHPSG13_1P_BITKIT_16x2_EDGE_LR_4[2]/LWL<4> RM_IHPSG13_1P_COLUMN_256_0[0]/RM_IHPSG13_1P_BITKIT_16x2_SRAM_1[1]/A_RWL<13>
+ RM_IHPSG13_1P_BITKIT_16x2_EDGE_LR_7[3]/LWL<14> RM_IHPSG13_1P_COLUMN_256_0[0]/RM_IHPSG13_1P_BITKIT_16x2_SRAM_3[0]/A_RWL<13>
+ RM_IHPSG13_1P_BITKIT_16x2_EDGE_LR_6[2]/LWL<5> RM_IHPSG13_1P_COLUMN_256_0[0]/RM_IHPSG13_1P_BITKIT_16x2_SRAM_3[3]/A_RWL<0>
+ RM_IHPSG13_1P_COLUMN_256_0[0]/RM_IHPSG13_1P_BITKIT_16x2_SRAM_0[2]/A_RWL<8> RM_IHPSG13_1P_COLUMN_256_0[0]/RM_IHPSG13_1P_BITKIT_16x2_SRAM_0[1]/A_RWL<13>
+ RM_IHPSG13_1P_BITKIT_16x2_EDGE_LR_5[0]/LWL<10> RM_IHPSG13_1P_COLUMN_256_0[0]/RM_IHPSG13_1P_BITKIT_16x2_SRAM_2[1]/A_RWL<8>
+ RM_IHPSG13_1P_BITKIT_16x2_EDGE_LR_7[2]/LWL<6> RM_IHPSG13_1P_COLUMN_256_0[0]/RM_IHPSG13_1P_BITKIT_16x2_SRAM_2[3]/A_RWL<1>
+ RM_IHPSG13_1P_COLUMN_256_0[0]/RM_IHPSG13_1P_BITKIT_16x2_SRAM_3[2]/A_RWL<9> RM_IHPSG13_1P_COLUMN_256_0[0]/RM_IHPSG13_1P_BITKIT_16x2_SRAM_0[3]/A_RWL<6>
+ RM_IHPSG13_1P_COLUMN_256_0[0]/RM_IHPSG13_1P_BITKIT_16x2_SRAM_1[3]/A_RWL<14> RM_IHPSG13_1P_COLUMN_256_0[0]/RM_IHPSG13_1P_BITKIT_16x2_SRAM_0[2]/A_RWL<1>
+ RM_IHPSG13_1P_BITKIT_16x2_EDGE_LR_6[1]/LWL<0> RM_IHPSG13_1P_COLUMN_256_0[0]/RM_IHPSG13_1P_BITKIT_16x2_SRAM_0[2]/A_RWL<10>
+ RM_IHPSG13_1P_COLUMN_256_0[0]/RM_IHPSG13_1P_BITKIT_16x2_SRAM_1[3]/A_RWL<2> RM_IHPSG13_1P_COLUMN_256_0[0]/RM_IHPSG13_1P_BITKIT_16x2_SRAM_2[2]/A_RWL<6>
+ RM_IHPSG13_1P_COLUMN_256_0[0]/RM_IHPSG13_1P_BITKIT_16x2_SRAM_2[1]/A_RWL<1> RM_IHPSG13_1P_COLUMN_256_0[0]/RM_IHPSG13_1P_BITKIT_16x2_SRAM_0[3]/A_RWL<3>
+ RM_IHPSG13_1P_BITKIT_16x2_EDGE_LR_5[2]/LWL<4> RM_IHPSG13_1P_BITKIT_16x2_EDGE_LR_6[1]/LWL<9>
+ RM_IHPSG13_1P_COLUMN_256_0[0]/RM_IHPSG13_1P_BITKIT_16x2_SRAM_1[2]/A_RWL<4> RM_IHPSG13_1P_COLUMN_256_0[0]/RM_IHPSG13_1P_BITKIT_16x2_SRAM_1[0]/A_RWL<3>
+ RM_IHPSG13_1P_BITKIT_16x2_EDGE_LR_4[2]/LWL<5> RM_IHPSG13_1P_BITKIT_16x2_EDGE_LR_5[1]/LWL<8>
+ RM_IHPSG13_1P_BITKIT_16x2_EDGE_LR_7[0]/LWL<11> RM_IHPSG13_1P_COLUMN_256_0[0]/RM_IHPSG13_1P_BITKIT_16x2_SRAM_3[1]/A_RWL<4>
+ RM_IHPSG13_1P_BITKIT_16x2_EDGE_LR_7[3]/LWL<15> RM_IHPSG13_1P_BITKIT_16x2_EDGE_LR_6[3]/LWL<10>
+ RM_IHPSG13_1P_BITKIT_16x2_EDGE_LR_6[2]/LWL<6> RM_IHPSG13_1P_COLUMN_256_0[0]/RM_IHPSG13_1P_BITKIT_16x2_SRAM_3[3]/A_RWL<1>
+ RM_IHPSG13_1P_COLUMN_256_0[0]/RM_IHPSG13_1P_BITKIT_16x2_SRAM_0[1]/A_RWL<14> RM_IHPSG13_1P_BITKIT_16x2_EDGE_LR_5[2]/LWL<10>
+ RM_IHPSG13_1P_BITKIT_16x2_EDGE_LR_5[0]/LWL<11> RM_IHPSG13_1P_BITKIT_16x2_EDGE_LR_7[0]/LWL<14>
+ RM_IHPSG13_1P_BITKIT_16x2_EDGE_LR_7[2]/LWL<7> RM_IHPSG13_1P_COLUMN_256_0[0]/RM_IHPSG13_1P_BITKIT_16x2_SRAM_2[3]/A_RWL<2>
+ RM_IHPSG13_1P_COLUMN_256_0[0]/RM_IHPSG13_1P_BITKIT_16x2_SRAM_2[3]/A_RWL<11> RM_IHPSG13_1P_COLUMN_256_0[0]/RM_IHPSG13_1P_BITKIT_16x2_SRAM_1[3]/A_RWL<15>
+ RM_IHPSG13_1P_COLUMN_256_0[0]/RM_IHPSG13_1P_BITKIT_16x2_SRAM_0[2]/A_RWL<11> RM_IHPSG13_1P_COLUMN_256_0[0]/RM_IHPSG13_1P_BITKIT_16x2_SRAM_1[3]/A_RWL<3>
+ RM_IHPSG13_1P_BITKIT_16x2_EDGE_LR_6[0]/LWL<7> RM_IHPSG13_1P_COLUMN_256_0[0]/RM_IHPSG13_1P_BITKIT_16x2_SRAM_0[3]/A_RWL<4>
+ RM_IHPSG13_1P_BITKIT_16x2_EDGE_LR_4[3]/LWL<6> RM_IHPSG13_1P_BITKIT_16x2_EDGE_LR_5[2]/LWL<5>
+ RM_IHPSG13_1P_BITKIT_16x2_EDGE_LR_7[0]/LWL<13> RM_IHPSG13_1P_BITKIT_16x2_EDGE_LR_4[2]/LWL<6>
+ RM_IHPSG13_1P_COLUMN_256_0[0]/RM_IHPSG13_1P_BITKIT_16x2_SRAM_1[0]/A_RWL<13> RM_IHPSG13_1P_BITKIT_16x2_EDGE_LR_4[1]/LWL<1>
+ RM_IHPSG13_1P_BITKIT_16x2_EDGE_LR_7[3]/LWL<5> RM_IHPSG13_1P_BITKIT_16x2_EDGE_LR_4[0]/LWL<12>
+ RM_IHPSG13_1P_BITKIT_16x2_EDGE_LR_5[3]/LWL<3> RM_IHPSG13_1P_BITKIT_16x2_EDGE_LR_6[2]/LWL<7>
+ RM_IHPSG13_1P_COLUMN_256_0[0]/RM_IHPSG13_1P_BITKIT_16x2_SRAM_3[3]/A_RWL<2> RM_IHPSG13_1P_COLUMN_256_0[0]/RM_IHPSG13_1P_BITKIT_16x2_SRAM_0[1]/A_RWL<8>
+ RM_IHPSG13_1P_BITKIT_16x2_EDGE_LR_4[3]/LWL<4> RM_IHPSG13_1P_COLUMN_256_0[0]/RM_IHPSG13_1P_BITKIT_16x2_SRAM_0[1]/A_RWL<15>
+ RM_IHPSG13_1P_BITKIT_16x2_EDGE_LR_5[0]/LWL<12> RM_IHPSG13_1P_COLUMN_256_0[0]/RM_IHPSG13_1P_BITKIT_16x2_SRAM_2[0]/A_RWL<8>
+ RM_IHPSG13_1P_BITKIT_16x2_EDGE_LR_7[2]/LWL<8> RM_IHPSG13_1P_COLUMN_256_0[0]/RM_IHPSG13_1P_BITKIT_16x2_SRAM_2[3]/A_RWL<3>
+ RM_IHPSG13_1P_COLUMN_256_0[0]/RM_IHPSG13_1P_BITKIT_16x2_SRAM_2[0]/A_RWL<2> RM_IHPSG13_1P_COLUMN_256_0[0]/RM_IHPSG13_1P_BITKIT_16x2_SRAM_3[3]/A_RWL<9>
+ RM_IHPSG13_1P_COLUMN_256_0[0]/RM_IHPSG13_1P_BITKIT_16x2_SRAM_0[2]/A_RWL<6> RM_IHPSG13_1P_COLUMN_256_0[0]/RM_IHPSG13_1P_BITKIT_16x2_SRAM_0[1]/A_RWL<1>
+ RM_IHPSG13_1P_COLUMN_256_0[0]/RM_IHPSG13_1P_BITKIT_16x2_SRAM_2[3]/A_RWL<14> RM_IHPSG13_1P_COLUMN_256_0[0]/RM_IHPSG13_1P_BITKIT_16x2_SRAM_0[2]/A_RWL<12>
+ RM_IHPSG13_1P_COLUMN_256_0[0]/RM_IHPSG13_1P_BITKIT_16x2_SRAM_1[3]/A_RWL<4> RM_IHPSG13_1P_COLUMN_256_0[0]/RM_IHPSG13_1P_BITKIT_16x2_SRAM_2[1]/A_RWL<6>
+ RM_IHPSG13_1P_COLUMN_256_0[0]/RM_IHPSG13_1P_BITKIT_16x2_SRAM_2[0]/A_RWL<1> RM_IHPSG13_1P_COLUMN_256_0[7]/RM_IHPSG13_1P_BITKIT_16x2_SRAM_3[3]/VSS
+ RM_IHPSG13_1P_COLUMN_256_0[7]/RM_IHPSG13_1P_BITKIT_16x2_SRAM_3[3]/VDD RM_IHPSG13_1P_COLUMN_256_0[0]/RM_IHPSG13_1P_BITKIT_16x2_SRAM_0[3]/A_RWL<5>
+ RM_IHPSG13_1P_BITKIT_16x2_EDGE_LR_5[2]/LWL<6> RM_IHPSG13_1P_COLUMN_256
XRM_IHPSG13_1P_COLUMN_256_0[1] RM_IHPSG13_1P_COLUMN_256_0[1]/RM_IHPSG13_1P_BITKIT_16x2_SRAM_0[0]/A_BLT_BOT<0>
+ RM_IHPSG13_1P_COLUMN_256_0[1]/RM_IHPSG13_1P_BITKIT_16x2_SRAM_3[1]/A_LWL<10> RM_IHPSG13_1P_COLUMN_256_0[1]/RM_IHPSG13_1P_BITKIT_16x2_SRAM_3[0]/A_LWL<13>
+ RM_IHPSG13_1P_COLUMN_256_0[1]/RM_IHPSG13_1P_BITKIT_16x2_SRAM_0[0]/A_BLT_BOT<1> RM_IHPSG13_1P_COLUMN_256_0[1]/RM_IHPSG13_1P_BITKIT_16x2_SRAM_1[2]/A_LWL<9>
+ RM_IHPSG13_1P_COLUMN_256_0[1]/RM_IHPSG13_1P_BITKIT_16x2_SRAM_0[0]/A_BLC_BOT<0> RM_IHPSG13_1P_COLUMN_256_0[1]/RM_IHPSG13_1P_BITKIT_16x2_SRAM_3[2]/A_LWL<8>
+ RM_IHPSG13_1P_COLUMN_256_0[1]/RM_IHPSG13_1P_BITKIT_16x2_SRAM_0[3]/A_RWL<11> RM_IHPSG13_1P_COLUMN_256_0[1]/RM_IHPSG13_1P_BITKIT_16x2_SRAM_2[3]/A_RWL<5>
+ RM_IHPSG13_1P_COLUMN_256_0[1]/RM_IHPSG13_1P_BITKIT_16x2_SRAM_0[0]/A_BLC_BOT<1> RM_IHPSG13_1P_COLUMN_256_0[1]/RM_IHPSG13_1P_BITKIT_16x2_SRAM_1[3]/A_LWL<0>
+ RM_IHPSG13_1P_COLUMN_256_0[1]/RM_IHPSG13_1P_BITKIT_16x2_SRAM_3[1]/A_LWL<13> RM_IHPSG13_1P_COLUMN_256_0[1]/RM_IHPSG13_1P_BITKIT_16x2_SRAM_1[3]/A_LWL<3>
+ RM_IHPSG13_1P_COLUMN_256_0[1]/RM_IHPSG13_1P_BITKIT_16x2_SRAM_1[3]/A_RWL<9> RM_IHPSG13_1P_COLUMN_256_0[1]/RM_IHPSG13_1P_BITKIT_16x2_SRAM_2[3]/A_LWL<1>
+ RM_IHPSG13_1P_COLUMN_256_0[1]/RM_IHPSG13_1P_BITKIT_16x2_SRAM_0[0]/A_RWL<1> RM_IHPSG13_1P_COLUMN_256_0[1]/RM_IHPSG13_1P_BITKIT_16x2_SRAM_0[3]/A_LWL<6>
+ RM_IHPSG13_1P_COLUMN_256_0[1]/RM_IHPSG13_1P_BITKIT_16x2_SRAM_2[3]/A_RWL<7> RM_IHPSG13_1P_COLUMN_256_0[1]/RM_IHPSG13_1P_BITKIT_16x2_SRAM_3[2]/A_LWL<13>
+ RM_IHPSG13_1P_COLUMN_256_0[1]/RM_IHPSG13_1P_BITKIT_16x2_SRAM_2[3]/A_LWL<2> RM_IHPSG13_1P_COLUMN_256_0[1]/RM_IHPSG13_1P_BITKIT_16x2_SRAM_3[3]/A_LWL<5>
+ RM_IHPSG13_1P_COLUMN_256_0[1]/RM_IHPSG13_1P_BITKIT_16x2_SRAM_0[2]/A_RWL<14> RM_IHPSG13_1P_COLUMN_256_0[1]/RM_IHPSG13_1P_BITKIT_16x2_SRAM_0[3]/A_LWL<8>
+ RM_IHPSG13_1P_COLUMN_256_0[1]/RM_IHPSG13_1P_BITKIT_16x2_SRAM_3[3]/A_LWL<11> RM_IHPSG13_1P_COLUMN_256_0[1]/RM_IHPSG13_1P_BITKIT_16x2_SRAM_3[0]/A_RWL<12>
+ RM_IHPSG13_1P_COLUMN_256_0[1]/RM_IHPSG13_1P_BITKIT_16x2_SRAM_3[1]/A_RWL<10> RM_IHPSG13_1P_COLUMN_256_0[1]/RM_IHPSG13_1P_BITKIT_16x2_SRAM_0[3]/A_RWL<7>
+ RM_IHPSG13_1P_COLUMN_256_0[1]/RM_IHPSG13_1P_BITKIT_16x2_SRAM_0[3]/A_LWL<2> RM_IHPSG13_1P_COLUMN_256_0[1]/RM_IHPSG13_1P_BITKIT_16x2_SRAM_3[0]/A_RWL<14>
+ RM_IHPSG13_1P_COLUMN_256_0[1]/RM_IHPSG13_1P_BITKIT_16x2_SRAM_1[0]/A_RWL<4> RM_IHPSG13_1P_COLUMN_256_0[1]/RM_IHPSG13_1P_BITKIT_16x2_SRAM_3[2]/A_LWL<11>
+ RM_IHPSG13_1P_COLUMN_256_0[1]/RM_IHPSG13_1P_BITKIT_16x2_SRAM_3[2]/A_LWL<14> RM_IHPSG13_1P_COLUMN_256_0[1]/RM_IHPSG13_1P_BITKIT_16x2_SRAM_2[0]/A_LWL<15>
+ RM_IHPSG13_1P_COLUMN_256_0[1]/RM_IHPSG13_1P_BITKIT_16x2_SRAM_0[0]/A_RWL<5> RM_IHPSG13_1P_COLUMN_256_0[1]/RM_IHPSG13_1P_BITKIT_16x2_SRAM_2[3]/A_LWL<7>
+ RM_IHPSG13_1P_COLUMN_256_0[1]/RM_IHPSG13_1P_BITKIT_16x2_SRAM_1[3]/A_LWL<9> RM_IHPSG13_1P_COLUMN_256_0[1]/RM_IHPSG13_1P_BITKIT_16x2_SRAM_2[1]/A_LWL<12>
+ RM_IHPSG13_1P_COLUMN_256_0[1]/RM_IHPSG13_1P_BITKIT_16x2_SRAM_0[3]/A_LWL<4> RM_IHPSG13_1P_COLUMN_256_0[1]/RM_IHPSG13_1P_BITKIT_16x2_SRAM_3[3]/A_LWL<13>
+ RM_IHPSG13_1P_COLUMN_256_0[1]/RM_IHPSG13_1P_BITKIT_16x2_SRAM_3[1]/A_RWL<12> RM_IHPSG13_1P_COLUMN_256_0[1]/RM_IHPSG13_1P_BITKIT_16x2_SRAM_0[0]/A_RWL<2>
+ RM_IHPSG13_1P_COLUMN_256_0[1]/RM_IHPSG13_1P_BITKIT_16x2_SRAM_0[3]/A_RWL<14> RM_IHPSG13_1P_COLUMN_256_0[1]/RM_IHPSG13_1P_BITKIT_16x2_SRAM_3[0]/A_RWL<10>
+ RM_IHPSG13_1P_COLUMN_256_0[1]/RM_IHPSG13_1P_BITKIT_16x2_SRAM_2[0]/A_RWL<3> RM_IHPSG13_1P_COLUMN_256_0[1]/RM_IHPSG13_1P_BITKIT_16x2_SRAM_3[3]/A_RWL<8>
+ RM_IHPSG13_1P_COLUMN_256_0[1]/RM_IHPSG13_1P_BITKIT_16x2_SRAM_0[0]/A_RWL<6> RM_IHPSG13_1P_COLUMN_256_0[1]/RM_IHPSG13_1P_BITKIT_16x2_SRAM_3[3]/A_LWL<8>
+ RM_IHPSG13_1P_COLUMN_256_0[1]/RM_IHPSG13_1P_BITKIT_16x2_SRAM_2[0]/A_RWL<0> RM_IHPSG13_1P_COLUMN_256_0[1]/RM_IHPSG13_1P_BITKIT_16x2_SRAM_0[0]/A_LWL<1>
+ RM_IHPSG13_1P_COLUMN_256_0[1]/RM_IHPSG13_1P_BITKIT_16x2_SRAM_3[0]/A_RWL<4> RM_IHPSG13_1P_COLUMN_256_0[1]/RM_IHPSG13_1P_BITKIT_16x2_SRAM_2[0]/A_RWL<5>
+ RM_IHPSG13_1P_COLUMN_256_0[1]/RM_IHPSG13_1P_BITKIT_16x2_SRAM_3[3]/A_LWL<14> RM_IHPSG13_1P_COLUMN_256_0[1]/RM_IHPSG13_1P_BITKIT_16x2_SRAM_3[1]/A_LWL<11>
+ RM_IHPSG13_1P_COLUMN_256_0[1]/RM_IHPSG13_1P_BITKIT_16x2_SRAM_2[0]/A_LWL<0> RM_IHPSG13_1P_COLUMN_256_0[1]/RM_IHPSG13_1P_BITKIT_16x2_SRAM_3[2]/A_RWL<10>
+ RM_IHPSG13_1P_COLUMN_256_0[1]/RM_IHPSG13_1P_BITKIT_16x2_SRAM_1[3]/A_LWL<5> RM_IHPSG13_1P_COLUMN_256_0[1]/RM_IHPSG13_1P_BITKIT_16x2_SRAM_3[1]/A_LWL<14>
+ RM_IHPSG13_1P_COLUMN_256_0[1]/RM_IHPSG13_1P_BITKIT_16x2_SRAM_0[3]/A_LWL<7> RM_IHPSG13_1P_COLUMN_256_0[1]/RM_IHPSG13_1P_BITKIT_16x2_SRAM_1[2]/A_LWL<8>
+ RM_IHPSG13_1P_COLUMN_256_0[1]/RM_IHPSG13_1P_BITKIT_16x2_SRAM_3[3]/A_LWL<4> RM_IHPSG13_1P_COLUMN_256_0[1]/RM_IHPSG13_1P_BITKIT_16x2_SRAM_2[2]/A_LWL<7>
+ RM_IHPSG13_1P_COLUMN_256_0[1]/RM_IHPSG13_1P_BITKIT_16x2_SRAM_0[3]/A_RWL<13> RM_IHPSG13_1P_COLUMN_256_0[1]/RM_IHPSG13_1P_BITKIT_16x2_SRAM_1[0]/A_LWL<10>
+ RM_IHPSG13_1P_COLUMN_256_0[1]/RM_IHPSG13_1P_BITKIT_16x2_SRAM_3[0]/A_RWL<2> RM_IHPSG13_1P_COLUMN_256_0[1]/RM_IHPSG13_1P_BITKIT_16x2_SRAM_2[0]/A_RWL<6>
+ RM_IHPSG13_1P_COLUMN_256_0[1]/RM_IHPSG13_1P_BITKIT_16x2_SRAM_3[1]/A_RWL<14> RM_IHPSG13_1P_COLUMN_256_0[1]/RM_IHPSG13_1P_BITKIT_16x2_SRAM_1[3]/A_RWL<8>
+ RM_IHPSG13_1P_COLUMN_256_0[1]/RM_IHPSG13_1P_BITKIT_16x2_SRAM_0[0]/A_RWL<8> RM_IHPSG13_1P_COLUMN_256_0[1]/RM_IHPSG13_1P_BITKIT_16x2_SRAM_0[0]/A_RWL<0>
+ RM_IHPSG13_1P_COLUMN_256_0[1]/RM_IHPSG13_1P_BITKIT_16x2_SRAM_3[3]/A_RWL<6> RM_IHPSG13_1P_COLUMN_256_0[1]/RM_IHPSG13_1P_BITKIT_16x2_SRAM_2[1]/A_LWL<15>
+ RM_IHPSG13_1P_COLUMN_256_0[1]/RM_IHPSG13_1P_BITKIT_16x2_SRAM_2[3]/A_RWL<4> RM_IHPSG13_1P_COLUMN_256_0[1]/RM_IHPSG13_1P_BITKIT_16x2_SRAM_2[0]/A_RWL<7>
+ RM_IHPSG13_1P_COLUMN_256_0[1]/RM_IHPSG13_1P_BITKIT_16x2_SRAM_2[2]/A_LWL<9> RM_IHPSG13_1P_COLUMN_256_0[1]/RM_IHPSG13_1P_BITKIT_16x2_SRAM_2[2]/A_LWL<12>
+ RM_IHPSG13_1P_COLUMN_256_0[1]/RM_IHPSG13_1P_BITKIT_16x2_SRAM_0[1]/A_RWL<0> RM_IHPSG13_1P_COLUMN_256_0[1]/RM_IHPSG13_1P_BITKIT_16x2_SRAM_3[0]/A_LWL<1>
+ RM_IHPSG13_1P_COLUMN_256_0[1]/RM_IHPSG13_1P_BITKIT_16x2_SRAM_2[0]/A_RWL<11> RM_IHPSG13_1P_COLUMN_256_0[1]/RM_IHPSG13_1P_BITKIT_16x2_SRAM_2[0]/A_LWL<2>
+ RM_IHPSG13_1P_COLUMN_256_0[1]/RM_IHPSG13_1P_BITKIT_16x2_SRAM_3[2]/A_RWL<12> RM_IHPSG13_1P_COLUMN_256_0[1]/RM_IHPSG13_1P_BITKIT_16x2_SRAM_3[0]/A_LWL<14>
+ RM_IHPSG13_1P_COLUMN_256_0[1]/RM_IHPSG13_1P_BITKIT_16x2_SRAM_1[0]/A_LWL<3> RM_IHPSG13_1P_COLUMN_256_0[1]/RM_IHPSG13_1P_BITKIT_16x2_SRAM_0[0]/A_LWL<4>
+ RM_IHPSG13_1P_COLUMN_256_0[1]/RM_IHPSG13_1P_BITKIT_16x2_SRAM_0[2]/A_RWL<13> RM_IHPSG13_1P_COLUMN_256_0[1]/RM_IHPSG13_1P_BITKIT_16x2_SRAM_1[0]/A_RWL<9>
+ RM_IHPSG13_1P_COLUMN_256_0[1]/RM_IHPSG13_1P_BITKIT_16x2_SRAM_1[3]/A_LWL<8> RM_IHPSG13_1P_COLUMN_256_0[1]/RM_IHPSG13_1P_BITKIT_16x2_SRAM_3[1]/A_LWL<12>
+ RM_IHPSG13_1P_COLUMN_256_0[1]/RM_IHPSG13_1P_BITKIT_16x2_SRAM_0[0]/A_RWL<7> RM_IHPSG13_1P_COLUMN_256_0[1]/RM_IHPSG13_1P_BITKIT_16x2_SRAM_1[3]/A_RWL<6>
+ RM_IHPSG13_1P_COLUMN_256_0[1]/RM_IHPSG13_1P_BITKIT_16x2_SRAM_1[0]/A_LWL<4> RM_IHPSG13_1P_COLUMN_256_0[1]/RM_IHPSG13_1P_BITKIT_16x2_SRAM_0[0]/A_LWL<2>
+ RM_IHPSG13_1P_COLUMN_256_0[1]/RM_IHPSG13_1P_BITKIT_16x2_SRAM_3[0]/A_RWL<15> RM_IHPSG13_1P_COLUMN_256_0[1]/RM_IHPSG13_1P_BITKIT_16x2_SRAM_3[3]/A_RWL<10>
+ RM_IHPSG13_1P_COLUMN_256_0[1]/RM_IHPSG13_1P_BITKIT_16x2_SRAM_2[1]/A_RWL<0> RM_IHPSG13_1P_COLUMN_256_0[1]/RM_IHPSG13_1P_BITKIT_16x2_SRAM_1[0]/A_LWL<13>
+ RM_IHPSG13_1P_COLUMN_256_0[1]/RM_IHPSG13_1P_BITKIT_16x2_SRAM_1[0]/A_LWL<11> RM_IHPSG13_1P_COLUMN_256_0[1]/RM_IHPSG13_1P_BITKIT_16x2_SRAM_2[3]/A_LWL<10>
+ RM_IHPSG13_1P_COLUMN_256_0[1]/RM_IHPSG13_1P_BITKIT_16x2_SRAM_1[1]/A_LWL<10> RM_IHPSG13_1P_COLUMN_256_0[1]/RM_IHPSG13_1P_BITKIT_16x2_SRAM_0[1]/A_RWL<2>
+ RM_IHPSG13_1P_COLUMN_256_0[1]/RM_IHPSG13_1P_BITKIT_16x2_SRAM_3[0]/A_LWL<3> RM_IHPSG13_1P_COLUMN_256_0[1]/RM_IHPSG13_1P_BITKIT_16x2_SRAM_0[3]/A_LWL<1>
+ RM_IHPSG13_1P_COLUMN_256_0[1]/RM_IHPSG13_1P_BITKIT_16x2_SRAM_3[2]/A_RWL<14> RM_IHPSG13_1P_COLUMN_256_0[1]/RM_IHPSG13_1P_BITKIT_16x2_SRAM_2[3]/A_LWL<0>
+ RM_IHPSG13_1P_COLUMN_256_0[1]/RM_IHPSG13_1P_BITKIT_16x2_SRAM_1[0]/A_LWL<5> RM_IHPSG13_1P_COLUMN_256_0[1]/RM_IHPSG13_1P_BITKIT_16x2_SRAM_3[3]/A_RWL<11>
+ RM_IHPSG13_1P_COLUMN_256_0[1]/RM_IHPSG13_1P_BITKIT_16x2_SRAM_3[3]/A_LWL<6> RM_IHPSG13_1P_COLUMN_256_0[1]/RM_IHPSG13_1P_BITKIT_16x2_SRAM_0[0]/A_LWL<6>
+ RM_IHPSG13_1P_COLUMN_256_0[1]/RM_IHPSG13_1P_BITKIT_16x2_SRAM_3[0]/A_RWL<9> RM_IHPSG13_1P_COLUMN_256_0[1]/RM_IHPSG13_1P_BITKIT_16x2_SRAM_2[3]/A_LWL<9>
+ RM_IHPSG13_1P_COLUMN_256_0[1]/RM_IHPSG13_1P_BITKIT_16x2_SRAM_1[0]/A_LWL<14> RM_IHPSG13_1P_COLUMN_256_0[1]/RM_IHPSG13_1P_BITKIT_16x2_SRAM_2[0]/A_RWL<13>
+ RM_IHPSG13_1P_COLUMN_256_0[1]/RM_IHPSG13_1P_BITKIT_16x2_SRAM_2[2]/A_LWL<15> RM_IHPSG13_1P_COLUMN_256_0[1]/RM_IHPSG13_1P_BITKIT_16x2_SRAM_1[1]/A_LWL<11>
+ RM_IHPSG13_1P_COLUMN_256_0[1]/RM_IHPSG13_1P_BITKIT_16x2_SRAM_3[0]/A_LWL<4> RM_IHPSG13_1P_COLUMN_256_0[1]/RM_IHPSG13_1P_BITKIT_16x2_SRAM_3[0]/A_RWL<8>
+ RM_IHPSG13_1P_COLUMN_256_0[1]/RM_IHPSG13_1P_BITKIT_16x2_SRAM_2[3]/A_LWL<12> RM_IHPSG13_1P_COLUMN_256_0[1]/RM_IHPSG13_1P_BITKIT_16x2_SRAM_2[0]/A_LWL<5>
+ RM_IHPSG13_1P_COLUMN_256_0[1]/RM_IHPSG13_1P_BITKIT_16x2_SRAM_1[1]/A_RWL<1> RM_IHPSG13_1P_COLUMN_256_0[1]/RM_IHPSG13_1P_BITKIT_16x2_SRAM_2[1]/A_RWL<11>
+ RM_IHPSG13_1P_COLUMN_256_0[1]/RM_IHPSG13_1P_BITKIT_16x2_SRAM_3[1]/A_RWL<1> RM_IHPSG13_1P_COLUMN_256_0[1]/RM_IHPSG13_1P_BITKIT_16x2_SRAM_3[0]/A_RWL<1>
+ RM_IHPSG13_1P_COLUMN_256_0[1]/RM_IHPSG13_1P_BITKIT_16x2_SRAM_3[3]/A_RWL<12> RM_IHPSG13_1P_COLUMN_256_0[1]/RM_IHPSG13_1P_BITKIT_16x2_SRAM_2[1]/A_RWL<2>
+ RM_IHPSG13_1P_COLUMN_256_0[1]/RM_IHPSG13_1P_BITKIT_16x2_SRAM_1[1]/A_RWL<3> RM_IHPSG13_1P_COLUMN_256_0[1]/RM_IHPSG13_1P_BITKIT_16x2_SRAM_3[3]/A_LWL<1>
+ RM_IHPSG13_1P_COLUMN_256_0[1]/RM_IHPSG13_1P_BITKIT_16x2_SRAM_2[2]/A_LWL<10> RM_IHPSG13_1P_COLUMN_256_0[1]/RM_IHPSG13_1P_BITKIT_16x2_SRAM_3[2]/A_LWL<12>
+ RM_IHPSG13_1P_COLUMN_256_0[1]/RM_IHPSG13_1P_BITKIT_16x2_SRAM_2[0]/A_RWL<15> RM_IHPSG13_1P_COLUMN_256_0[1]/RM_IHPSG13_1P_BITKIT_16x2_SRAM_2[0]/A_LWL<6>
+ RM_IHPSG13_1P_COLUMN_256_0[1]/RM_IHPSG13_1P_BITKIT_16x2_SRAM_3[2]/A_RWL<11> RM_IHPSG13_1P_COLUMN_256_0[1]/RM_IHPSG13_1P_BITKIT_16x2_SRAM_3[1]/A_RWL<15>
+ RM_IHPSG13_1P_COLUMN_256_0[1]/RM_IHPSG13_1P_BITKIT_16x2_SRAM_0[0]/A_LWL<7> RM_IHPSG13_1P_COLUMN_256_0[1]/RM_IHPSG13_1P_BITKIT_16x2_SRAM_1[3]/A_LWL<6>
+ RM_IHPSG13_1P_COLUMN_256_0[1]/RM_IHPSG13_1P_BITKIT_16x2_SRAM_3[1]/A_RWL<2> RM_IHPSG13_1P_COLUMN_256_0[1]/RM_IHPSG13_1P_BITKIT_16x2_SRAM_2[1]/A_RWL<3>
+ RM_IHPSG13_1P_COLUMN_256_0[1]/RM_IHPSG13_1P_BITKIT_16x2_SRAM_2[3]/A_LWL<3> RM_IHPSG13_1P_COLUMN_256_0[1]/RM_IHPSG13_1P_BITKIT_16x2_SRAM_1[1]/A_RWL<4>
+ RM_IHPSG13_1P_COLUMN_256_0[1]/RM_IHPSG13_1P_BITKIT_16x2_SRAM_0[0]/A_LWL<0> RM_IHPSG13_1P_COLUMN_256_0[1]/RM_IHPSG13_1P_BITKIT_16x2_SRAM_1[1]/A_LWL<13>
+ RM_IHPSG13_1P_COLUMN_256_0[1]/RM_IHPSG13_1P_BITKIT_16x2_SRAM_1[0]/A_RWL<8> RM_IHPSG13_1P_COLUMN_256_0[1]/RM_IHPSG13_1P_BITKIT_16x2_SRAM_0[1]/A_RWL<5>
+ RM_IHPSG13_1P_COLUMN_256_0[1]/RM_IHPSG13_1P_BITKIT_16x2_SRAM_2[3]/A_RWL<9> RM_IHPSG13_1P_COLUMN_256_0[1]/RM_IHPSG13_1P_BITKIT_16x2_SRAM_2[0]/A_LWL<7>
+ RM_IHPSG13_1P_COLUMN_256_0[1]/RM_IHPSG13_1P_BITKIT_16x2_SRAM_1[2]/A_LWL<10> RM_IHPSG13_1P_COLUMN_256_0[1]/RM_IHPSG13_1P_BITKIT_16x2_SRAM_1[0]/A_RWL<1>
+ RM_IHPSG13_1P_COLUMN_256_0[1]/RM_IHPSG13_1P_BITKIT_16x2_SRAM_2[1]/A_RWL<13> RM_IHPSG13_1P_COLUMN_256_0[1]/RM_IHPSG13_1P_BITKIT_16x2_SRAM_3[0]/A_RWL<6>
+ RM_IHPSG13_1P_COLUMN_256_0[1]/RM_IHPSG13_1P_BITKIT_16x2_SRAM_1[0]/A_LWL<8> RM_IHPSG13_1P_COLUMN_256_0[1]/RM_IHPSG13_1P_BITKIT_16x2_SRAM_0[2]/A_RWL<15>
+ RM_IHPSG13_1P_COLUMN_256_0[1]/RM_IHPSG13_1P_BITKIT_16x2_SRAM_3[3]/A_LWL<15> RM_IHPSG13_1P_COLUMN_256_0[1]/RM_IHPSG13_1P_BITKIT_16x2_SRAM_0[1]/A_RWL<4>
+ RM_IHPSG13_1P_COLUMN_256_0[1]/RM_IHPSG13_1P_BITKIT_16x2_SRAM_3[3]/A_RWL<14> RM_IHPSG13_1P_COLUMN_256_0[1]/RM_IHPSG13_1P_BITKIT_16x2_SRAM_0[0]/A_LWL<9>
+ RM_IHPSG13_1P_COLUMN_256_0[1]/RM_IHPSG13_1P_BITKIT_16x2_SRAM_2[1]/A_RWL<4> RM_IHPSG13_1P_COLUMN_256_0[1]/RM_IHPSG13_1P_BITKIT_16x2_SRAM_2[0]/A_RWL<4>
+ RM_IHPSG13_1P_COLUMN_256_0[1]/RM_IHPSG13_1P_BITKIT_16x2_SRAM_3[3]/A_RWL<5> RM_IHPSG13_1P_COLUMN_256_0[1]/RM_IHPSG13_1P_BITKIT_16x2_SRAM_2[1]/A_LWL<10>
+ RM_IHPSG13_1P_COLUMN_256_0[1]/RM_IHPSG13_1P_BITKIT_16x2_SRAM_1[1]/A_LWL<14> RM_IHPSG13_1P_COLUMN_256_0[1]/RM_IHPSG13_1P_BITKIT_16x2_SRAM_0[1]/A_RWL<6>
+ RM_IHPSG13_1P_COLUMN_256_0[1]/RM_IHPSG13_1P_BITKIT_16x2_SRAM_2[3]/A_LWL<15> RM_IHPSG13_1P_COLUMN_256_0[1]/RM_IHPSG13_1P_BITKIT_16x2_SRAM_2[0]/A_LWL<8>
+ RM_IHPSG13_1P_COLUMN_256_0[1]/RM_IHPSG13_1P_BITKIT_16x2_SRAM_3[1]/A_RWL<11> RM_IHPSG13_1P_COLUMN_256_0[1]/RM_IHPSG13_1P_BITKIT_16x2_SRAM_1[2]/A_LWL<11>
+ RM_IHPSG13_1P_COLUMN_256_0[1]/RM_IHPSG13_1P_BITKIT_16x2_SRAM_0[1]/A_LWL<1> RM_IHPSG13_1P_COLUMN_256_0[1]/RM_IHPSG13_1P_BITKIT_16x2_SRAM_1[0]/A_RWL<10>
+ RM_IHPSG13_1P_COLUMN_256_0[1]/RM_IHPSG13_1P_BITKIT_16x2_SRAM_1[0]/A_LWL<1> RM_IHPSG13_1P_COLUMN_256_0[1]/RM_IHPSG13_1P_BITKIT_16x2_SRAM_0[3]/A_LWL<3>
+ RM_IHPSG13_1P_COLUMN_256_0[1]/RM_IHPSG13_1P_BITKIT_16x2_SRAM_2[1]/A_RWL<5> RM_IHPSG13_1P_COLUMN_256_0[1]/RM_IHPSG13_1P_BITKIT_16x2_SRAM_3[0]/A_LWL<0>
+ RM_IHPSG13_1P_COLUMN_256_0[1]/RM_IHPSG13_1P_BITKIT_16x2_SRAM_2[2]/A_RWL<11> RM_IHPSG13_1P_COLUMN_256_0[1]/RM_IHPSG13_1P_BITKIT_16x2_SRAM_3[3]/A_LWL<12>
+ RM_IHPSG13_1P_COLUMN_256_0[1]/RM_IHPSG13_1P_BITKIT_16x2_SRAM_1[1]/A_RWL<6> RM_IHPSG13_1P_COLUMN_256_0[1]/RM_IHPSG13_1P_BITKIT_16x2_SRAM_0[3]/A_RWL<9>
+ RM_IHPSG13_1P_COLUMN_256_0[1]/RM_IHPSG13_1P_BITKIT_16x2_SRAM_2[1]/A_LWL<0> RM_IHPSG13_1P_COLUMN_256_0[1]/RM_IHPSG13_1P_BITKIT_16x2_SRAM_0[1]/A_RWL<7>
+ RM_IHPSG13_1P_COLUMN_256_0[1]/RM_IHPSG13_1P_BITKIT_16x2_SRAM_3[2]/A_RWL<15> RM_IHPSG13_1P_COLUMN_256_0[1]/RM_IHPSG13_1P_BITKIT_16x2_SRAM_2[0]/A_LWL<9>
+ RM_IHPSG13_1P_COLUMN_256_0[1]/RM_IHPSG13_1P_BITKIT_16x2_SRAM_1[0]/A_RWL<6> RM_IHPSG13_1P_COLUMN_256_0[1]/RM_IHPSG13_1P_BITKIT_16x2_SRAM_2[1]/A_RWL<15>
+ RM_IHPSG13_1P_COLUMN_256_0[1]/RM_IHPSG13_1P_BITKIT_16x2_SRAM_0[1]/A_LWL<2> RM_IHPSG13_1P_COLUMN_256_0[1]/RM_IHPSG13_1P_BITKIT_16x2_SRAM_3[2]/A_LWL<15>
+ RM_IHPSG13_1P_COLUMN_256_0[1]/RM_IHPSG13_1P_BITKIT_16x2_SRAM_0[0]/A_RWL<4> RM_IHPSG13_1P_COLUMN_256_0[1]/RM_IHPSG13_1P_BITKIT_16x2_SRAM_1[3]/A_RWL<5>
+ RM_IHPSG13_1P_COLUMN_256_0[1]/RM_IHPSG13_1P_BITKIT_16x2_SRAM_0[1]/A_LWL<0> RM_IHPSG13_1P_COLUMN_256_0[1]/RM_IHPSG13_1P_BITKIT_16x2_SRAM_2[0]/A_LWL<10>
+ RM_IHPSG13_1P_COLUMN_256_0[1]/RM_IHPSG13_1P_BITKIT_16x2_SRAM_3[0]/A_LWL<9> RM_IHPSG13_1P_COLUMN_256_0[1]/RM_IHPSG13_1P_BITKIT_16x2_SRAM_0[0]/A_LWL<12>
+ RM_IHPSG13_1P_COLUMN_256_0[1]/RM_IHPSG13_1P_BITKIT_16x2_SRAM_0[0]/A_RWL<3> RM_IHPSG13_1P_COLUMN_256_0[1]/RM_IHPSG13_1P_BITKIT_16x2_SRAM_0[3]/A_RWL<15>
+ RM_IHPSG13_1P_COLUMN_256_0[1]/RM_IHPSG13_1P_BITKIT_16x2_SRAM_3[0]/A_RWL<11> RM_IHPSG13_1P_COLUMN_256_0[1]/RM_IHPSG13_1P_BITKIT_16x2_SRAM_1[2]/A_LWL<13>
+ RM_IHPSG13_1P_COLUMN_256_0[1]/RM_IHPSG13_1P_BITKIT_16x2_SRAM_1[0]/A_RWL<12> RM_IHPSG13_1P_COLUMN_256_0[1]/RM_IHPSG13_1P_BITKIT_16x2_SRAM_3[1]/A_RWL<6>
+ RM_IHPSG13_1P_COLUMN_256_0[1]/RM_IHPSG13_1P_BITKIT_16x2_SRAM_3[0]/A_LWL<6> RM_IHPSG13_1P_COLUMN_256_0[1]/RM_IHPSG13_1P_BITKIT_16x2_SRAM_2[1]/A_RWL<7>
+ RM_IHPSG13_1P_COLUMN_256_0[1]/RM_IHPSG13_1P_BITKIT_16x2_SRAM_2[2]/A_RWL<13> RM_IHPSG13_1P_COLUMN_256_0[1]/RM_IHPSG13_1P_BITKIT_16x2_SRAM_0[2]/A_RWL<0>
+ RM_IHPSG13_1P_COLUMN_256_0[1]/RM_IHPSG13_1P_BITKIT_16x2_SRAM_3[1]/A_LWL<1> RM_IHPSG13_1P_COLUMN_256_0[1]/RM_IHPSG13_1P_BITKIT_16x2_SRAM_1[1]/A_RWL<8>
+ RM_IHPSG13_1P_COLUMN_256_0[1]/RM_IHPSG13_1P_BITKIT_16x2_SRAM_2[1]/A_LWL<2> RM_IHPSG13_1P_COLUMN_256_0[1]/RM_IHPSG13_1P_BITKIT_16x2_SRAM_1[1]/A_LWL<3>
+ RM_IHPSG13_1P_COLUMN_256_0[1]/RM_IHPSG13_1P_BITKIT_16x2_SRAM_1[1]/A_LWL<1> RM_IHPSG13_1P_COLUMN_256_0[1]/RM_IHPSG13_1P_BITKIT_16x2_SRAM_1[2]/A_LWL<14>
+ RM_IHPSG13_1P_COLUMN_256_0[1]/RM_IHPSG13_1P_BITKIT_16x2_SRAM_1[0]/A_LWL<12> RM_IHPSG13_1P_COLUMN_256_0[1]/RM_IHPSG13_1P_BITKIT_16x2_SRAM_0[1]/A_LWL<10>
+ RM_IHPSG13_1P_COLUMN_256_0[1]/RM_IHPSG13_1P_BITKIT_16x2_SRAM_0[1]/A_LWL<4> RM_IHPSG13_1P_COLUMN_256_0[1]/RM_IHPSG13_1P_BITKIT_16x2_SRAM_1[3]/A_LWL<4>
+ RM_IHPSG13_1P_COLUMN_256_0[1]/RM_IHPSG13_1P_BITKIT_16x2_SRAM_3[1]/A_LWL<0> RM_IHPSG13_1P_COLUMN_256_0[1]/RM_IHPSG13_1P_BITKIT_16x2_SRAM_3[1]/A_LWL<15>
+ RM_IHPSG13_1P_COLUMN_256_0[1]/RM_IHPSG13_1P_BITKIT_16x2_SRAM_1[3]/A_LWL<11> RM_IHPSG13_1P_COLUMN_256_0[1]/RM_IHPSG13_1P_BITKIT_16x2_SRAM_1[0]/A_RWL<2>
+ RM_IHPSG13_1P_COLUMN_256_0[1]/RM_IHPSG13_1P_BITKIT_16x2_SRAM_1[1]/A_RWL<10> RM_IHPSG13_1P_COLUMN_256_0[1]/RM_IHPSG13_1P_BITKIT_16x2_SRAM_3[1]/A_RWL<5>
+ RM_IHPSG13_1P_COLUMN_256_0[1]/RM_IHPSG13_1P_BITKIT_16x2_SRAM_0[0]/A_LWL<10> RM_IHPSG13_1P_COLUMN_256_0[1]/RM_IHPSG13_1P_BITKIT_16x2_SRAM_0[3]/A_RWL<12>
+ RM_IHPSG13_1P_COLUMN_256_0[1]/RM_IHPSG13_1P_BITKIT_16x2_SRAM_3[0]/A_RWL<3> RM_IHPSG13_1P_COLUMN_256_0[1]/RM_IHPSG13_1P_BITKIT_16x2_SRAM_1[1]/A_RWL<9>
+ RM_IHPSG13_1P_COLUMN_256_0[1]/RM_IHPSG13_1P_BITKIT_16x2_SRAM_3[3]/A_RWL<15> RM_IHPSG13_1P_COLUMN_256_0[1]/RM_IHPSG13_1P_BITKIT_16x2_SRAM_2[2]/A_RWL<12>
+ RM_IHPSG13_1P_COLUMN_256_0[1]/RM_IHPSG13_1P_BITKIT_16x2_SRAM_2[1]/A_LWL<3> RM_IHPSG13_1P_COLUMN_256_0[1]/RM_IHPSG13_1P_BITKIT_16x2_SRAM_1[0]/A_RWL<11>
+ RM_IHPSG13_1P_COLUMN_256_0[1]/RM_IHPSG13_1P_BITKIT_16x2_SRAM_2[3]/A_RWL<10> RM_IHPSG13_1P_COLUMN_256_0[1]/RM_IHPSG13_1P_BITKIT_16x2_SRAM_1[1]/A_LWL<4>
+ RM_IHPSG13_1P_COLUMN_256_0[1]/RM_IHPSG13_1P_BITKIT_16x2_SRAM_1[2]/A_LWL<15> RM_IHPSG13_1P_COLUMN_256_0[1]/RM_IHPSG13_1P_BITKIT_16x2_SRAM_2[2]/A_RWL<0>
+ RM_IHPSG13_1P_COLUMN_256_0[1]/RM_IHPSG13_1P_BITKIT_16x2_SRAM_1[0]/A_LWL<6> RM_IHPSG13_1P_COLUMN_256_0[1]/RM_IHPSG13_1P_BITKIT_16x2_SRAM_1[0]/A_RWL<14>
+ RM_IHPSG13_1P_COLUMN_256_0[1]/RM_IHPSG13_1P_BITKIT_16x2_SRAM_3[1]/A_RWL<8> RM_IHPSG13_1P_COLUMN_256_0[1]/RM_IHPSG13_1P_BITKIT_16x2_SRAM_3[3]/A_RWL<7>
+ RM_IHPSG13_1P_COLUMN_256_0[1]/RM_IHPSG13_1P_BITKIT_16x2_SRAM_1[2]/A_RWL<1> RM_IHPSG13_1P_COLUMN_256_0[1]/RM_IHPSG13_1P_BITKIT_16x2_SRAM_0[1]/A_LWL<3>
+ RM_IHPSG13_1P_COLUMN_256_0[1]/RM_IHPSG13_1P_BITKIT_16x2_SRAM_2[1]/A_RWL<9> RM_IHPSG13_1P_COLUMN_256_0[1]/RM_IHPSG13_1P_BITKIT_16x2_SRAM_2[2]/A_RWL<15>
+ RM_IHPSG13_1P_COLUMN_256_0[1]/RM_IHPSG13_1P_BITKIT_16x2_SRAM_1[1]/A_RWL<11> RM_IHPSG13_1P_COLUMN_256_0[1]/RM_IHPSG13_1P_BITKIT_16x2_SRAM_2[0]/A_LWL<3>
+ RM_IHPSG13_1P_COLUMN_256_0[1]/RM_IHPSG13_1P_BITKIT_16x2_SRAM_0[2]/A_RWL<2> RM_IHPSG13_1P_COLUMN_256_0[1]/RM_IHPSG13_1P_BITKIT_16x2_SRAM_3[1]/A_LWL<3>
+ RM_IHPSG13_1P_COLUMN_256_0[1]/RM_IHPSG13_1P_BITKIT_16x2_SRAM_0[2]/A_LWL<9> RM_IHPSG13_1P_COLUMN_256_0[1]/RM_IHPSG13_1P_BITKIT_16x2_SRAM_2[0]/A_LWL<13>
+ RM_IHPSG13_1P_COLUMN_256_0[1]/RM_IHPSG13_1P_BITKIT_16x2_SRAM_3[3]/A_LWL<2> RM_IHPSG13_1P_COLUMN_256_0[1]/RM_IHPSG13_1P_BITKIT_16x2_SRAM_0[1]/A_RWL<3>
+ RM_IHPSG13_1P_COLUMN_256_0[1]/RM_IHPSG13_1P_BITKIT_16x2_SRAM_0[1]/A_RWL<9> RM_IHPSG13_1P_COLUMN_256_0[1]/RM_IHPSG13_1P_BITKIT_16x2_SRAM_2[3]/A_RWL<12>
+ RM_IHPSG13_1P_COLUMN_256_0[1]/RM_IHPSG13_1P_BITKIT_16x2_SRAM_2[3]/A_LWL<5> RM_IHPSG13_1P_COLUMN_256_0[1]/RM_IHPSG13_1P_BITKIT_16x2_SRAM_2[2]/A_LWL<8>
+ RM_IHPSG13_1P_COLUMN_256_0[1]/RM_IHPSG13_1P_BITKIT_16x2_SRAM_0[0]/A_LWL<15> RM_IHPSG13_1P_COLUMN_256_0[1]/RM_IHPSG13_1P_BITKIT_16x2_SRAM_2[0]/A_RWL<9>
+ RM_IHPSG13_1P_COLUMN_256_0[1]/RM_IHPSG13_1P_BITKIT_16x2_SRAM_1[1]/A_LWL<5> RM_IHPSG13_1P_COLUMN_256_0[1]/RM_IHPSG13_1P_BITKIT_16x2_SRAM_3[2]/A_RWL<0>
+ RM_IHPSG13_1P_COLUMN_256_0[1]/RM_IHPSG13_1P_BITKIT_16x2_SRAM_1[1]/A_LWL<15> RM_IHPSG13_1P_COLUMN_256_0[1]/RM_IHPSG13_1P_BITKIT_16x2_SRAM_0[1]/A_LWL<12>
+ RM_IHPSG13_1P_COLUMN_256_0[1]/RM_IHPSG13_1P_BITKIT_16x2_SRAM_0[1]/A_LWL<6> RM_IHPSG13_1P_COLUMN_256_0[1]/RM_IHPSG13_1P_BITKIT_16x2_SRAM_3[0]/A_LWL<15>
+ RM_IHPSG13_1P_COLUMN_256_0[1]/RM_IHPSG13_1P_BITKIT_16x2_SRAM_3[1]/A_RWL<9> RM_IHPSG13_1P_COLUMN_256_0[1]/RM_IHPSG13_1P_BITKIT_16x2_SRAM_1[3]/A_LWL<13>
+ RM_IHPSG13_1P_COLUMN_256_0[1]/RM_IHPSG13_1P_BITKIT_16x2_SRAM_1[1]/A_RWL<5> RM_IHPSG13_1P_COLUMN_256_0[1]/RM_IHPSG13_1P_BITKIT_16x2_SRAM_1[1]/A_RWL<12>
+ RM_IHPSG13_1P_COLUMN_256_0[1]/RM_IHPSG13_1P_BITKIT_16x2_SRAM_3[0]/A_RWL<5> RM_IHPSG13_1P_COLUMN_256_0[1]/RM_IHPSG13_1P_BITKIT_16x2_SRAM_3[1]/A_LWL<4>
+ RM_IHPSG13_1P_COLUMN_256_0[1]/RM_IHPSG13_1P_BITKIT_16x2_SRAM_2[3]/A_RWL<13> RM_IHPSG13_1P_COLUMN_256_0[1]/RM_IHPSG13_1P_BITKIT_16x2_SRAM_2[1]/A_RWL<12>
+ RM_IHPSG13_1P_COLUMN_256_0[1]/RM_IHPSG13_1P_BITKIT_16x2_SRAM_2[1]/A_LWL<5> RM_IHPSG13_1P_COLUMN_256_0[1]/RM_IHPSG13_1P_BITKIT_16x2_SRAM_0[3]/A_RWL<10>
+ RM_IHPSG13_1P_COLUMN_256_0[1]/RM_IHPSG13_1P_BITKIT_16x2_SRAM_1[1]/A_LWL<12> RM_IHPSG13_1P_COLUMN_256_0[1]/RM_IHPSG13_1P_BITKIT_16x2_SRAM_2[2]/A_RWL<10>
+ RM_IHPSG13_1P_COLUMN_256_0[1]/RM_IHPSG13_1P_BITKIT_16x2_SRAM_1[1]/A_LWL<6> RM_IHPSG13_1P_COLUMN_256_0[1]/RM_IHPSG13_1P_BITKIT_16x2_SRAM_3[2]/A_RWL<1>
+ RM_IHPSG13_1P_COLUMN_256_0[1]/RM_IHPSG13_1P_BITKIT_16x2_SRAM_0[1]/A_LWL<13> RM_IHPSG13_1P_COLUMN_256_0[1]/RM_IHPSG13_1P_BITKIT_16x2_SRAM_1[3]/A_RWL<7>
+ RM_IHPSG13_1P_COLUMN_256_0[1]/RM_IHPSG13_1P_BITKIT_16x2_SRAM_0[1]/A_LWL<7> RM_IHPSG13_1P_COLUMN_256_0[1]/RM_IHPSG13_1P_BITKIT_16x2_SRAM_2[2]/A_RWL<2>
+ RM_IHPSG13_1P_COLUMN_256_0[1]/RM_IHPSG13_1P_BITKIT_16x2_SRAM_1[1]/A_RWL<2> RM_IHPSG13_1P_COLUMN_256_0[1]/RM_IHPSG13_1P_BITKIT_16x2_SRAM_1[2]/A_RWL<0>
+ RM_IHPSG13_1P_COLUMN_256_0[1]/RM_IHPSG13_1P_BITKIT_16x2_SRAM_1[0]/A_RWL<15> RM_IHPSG13_1P_COLUMN_256_0[1]/RM_IHPSG13_1P_BITKIT_16x2_SRAM_3[2]/A_LWL<9>
+ RM_IHPSG13_1P_COLUMN_256_0[1]/RM_IHPSG13_1P_BITKIT_16x2_SRAM_1[3]/A_LWL<14> RM_IHPSG13_1P_COLUMN_256_0[1]/RM_IHPSG13_1P_BITKIT_16x2_SRAM_3[1]/A_RWL<0>
+ RM_IHPSG13_1P_COLUMN_256_0[1]/RM_IHPSG13_1P_BITKIT_16x2_SRAM_3[1]/A_RWL<3> RM_IHPSG13_1P_COLUMN_256_0[1]/RM_IHPSG13_1P_BITKIT_16x2_SRAM_0[0]/A_LWL<3>
+ RM_IHPSG13_1P_COLUMN_256_0[1]/RM_IHPSG13_1P_BITKIT_16x2_SRAM_1[2]/A_RWL<3> RM_IHPSG13_1P_COLUMN_256_0[1]/RM_IHPSG13_1P_BITKIT_16x2_SRAM_0[2]/A_LWL<10>
+ RM_IHPSG13_1P_COLUMN_256_0[1]/RM_IHPSG13_1P_BITKIT_16x2_SRAM_1[3]/A_LWL<2> RM_IHPSG13_1P_COLUMN_256_0[1]/RM_IHPSG13_1P_BITKIT_16x2_SRAM_0[2]/A_RWL<4>
+ RM_IHPSG13_1P_COLUMN_256_0[1]/RM_IHPSG13_1P_BITKIT_16x2_SRAM_0[0]/A_RWL<9> RM_IHPSG13_1P_COLUMN_256_0[1]/RM_IHPSG13_1P_BITKIT_16x2_SRAM_2[1]/A_LWL<6>
+ RM_IHPSG13_1P_COLUMN_256_0[1]/RM_IHPSG13_1P_BITKIT_16x2_SRAM_1[2]/A_RWL<10> RM_IHPSG13_1P_COLUMN_256_0[1]/RM_IHPSG13_1P_BITKIT_16x2_SRAM_2[3]/A_LWL<11>
+ RM_IHPSG13_1P_COLUMN_256_0[1]/RM_IHPSG13_1P_BITKIT_16x2_SRAM_3[2]/A_RWL<2> RM_IHPSG13_1P_COLUMN_256_0[1]/RM_IHPSG13_1P_BITKIT_16x2_SRAM_1[0]/A_LWL<15>
+ RM_IHPSG13_1P_COLUMN_256_0[1]/RM_IHPSG13_1P_BITKIT_16x2_SRAM_0[3]/A_LWL<0> RM_IHPSG13_1P_COLUMN_256_0[1]/RM_IHPSG13_1P_BITKIT_16x2_SRAM_2[3]/A_LWL<14>
+ RM_IHPSG13_1P_COLUMN_256_0[1]/RM_IHPSG13_1P_BITKIT_16x2_SRAM_2[2]/A_RWL<3> RM_IHPSG13_1P_COLUMN_256_0[1]/RM_IHPSG13_1P_BITKIT_16x2_SRAM_0[0]/A_LWL<5>
+ RM_IHPSG13_1P_COLUMN_256_0[1]/RM_IHPSG13_1P_BITKIT_16x2_SRAM_1[3]/A_LWL<15> RM_IHPSG13_1P_COLUMN_256_0[1]/RM_IHPSG13_1P_BITKIT_16x2_SRAM_1[0]/A_RWL<5>
+ RM_IHPSG13_1P_COLUMN_256_0[1]/RM_IHPSG13_1P_BITKIT_16x2_SRAM_2[1]/A_LWL<13> RM_IHPSG13_1P_COLUMN_256_0[1]/RM_IHPSG13_1P_BITKIT_16x2_SRAM_0[3]/A_LWL<9>
+ RM_IHPSG13_1P_COLUMN_256_0[1]/RM_IHPSG13_1P_BITKIT_16x2_SRAM_0[2]/A_RWL<3> RM_IHPSG13_1P_COLUMN_256_0[1]/RM_IHPSG13_1P_BITKIT_16x2_SRAM_3[3]/A_LWL<7>
+ RM_IHPSG13_1P_COLUMN_256_0[1]/RM_IHPSG13_1P_BITKIT_16x2_SRAM_2[0]/A_LWL<4> RM_IHPSG13_1P_COLUMN_256_0[1]/RM_IHPSG13_1P_BITKIT_16x2_SRAM_1[1]/A_RWL<14>
+ RM_IHPSG13_1P_COLUMN_256_0[1]/RM_IHPSG13_1P_BITKIT_16x2_SRAM_0[2]/A_RWL<5> RM_IHPSG13_1P_COLUMN_256_0[1]/RM_IHPSG13_1P_BITKIT_16x2_SRAM_2[3]/A_LWL<8>
+ RM_IHPSG13_1P_COLUMN_256_0[1]/RM_IHPSG13_1P_BITKIT_16x2_SRAM_3[1]/A_LWL<6> RM_IHPSG13_1P_COLUMN_256_0[1]/RM_IHPSG13_1P_BITKIT_16x2_SRAM_2[0]/A_RWL<12>
+ RM_IHPSG13_1P_COLUMN_256_0[1]/RM_IHPSG13_1P_BITKIT_16x2_SRAM_2[3]/A_RWL<15> RM_IHPSG13_1P_COLUMN_256_0[1]/RM_IHPSG13_1P_BITKIT_16x2_SRAM_1[2]/A_RWL<11>
+ RM_IHPSG13_1P_COLUMN_256_0[1]/RM_IHPSG13_1P_BITKIT_16x2_SRAM_2[1]/A_LWL<7> RM_IHPSG13_1P_COLUMN_256_0[1]/RM_IHPSG13_1P_BITKIT_16x2_SRAM_2[0]/A_RWL<14>
+ RM_IHPSG13_1P_COLUMN_256_0[1]/RM_IHPSG13_1P_BITKIT_16x2_SRAM_3[3]/A_RWL<13> RM_IHPSG13_1P_COLUMN_256_0[1]/RM_IHPSG13_1P_BITKIT_16x2_SRAM_0[2]/A_LWL<0>
+ RM_IHPSG13_1P_COLUMN_256_0[1]/RM_IHPSG13_1P_BITKIT_16x2_SRAM_2[1]/A_RWL<10> RM_IHPSG13_1P_COLUMN_256_0[1]/RM_IHPSG13_1P_BITKIT_16x2_SRAM_1[1]/A_LWL<8>
+ RM_IHPSG13_1P_COLUMN_256_0[1]/RM_IHPSG13_1P_BITKIT_16x2_SRAM_0[1]/A_LWL<15> RM_IHPSG13_1P_COLUMN_256_0[1]/RM_IHPSG13_1P_BITKIT_16x2_SRAM_0[1]/A_LWL<9>
+ RM_IHPSG13_1P_COLUMN_256_0[1]/RM_IHPSG13_1P_BITKIT_16x2_SRAM_2[2]/A_RWL<4> RM_IHPSG13_1P_COLUMN_256_0[1]/RM_IHPSG13_1P_BITKIT_16x2_SRAM_1[1]/A_RWL<0>
+ RM_IHPSG13_1P_COLUMN_256_0[1]/RM_IHPSG13_1P_BITKIT_16x2_SRAM_3[1]/A_RWL<7> RM_IHPSG13_1P_COLUMN_256_0[1]/RM_IHPSG13_1P_BITKIT_16x2_SRAM_3[0]/A_RWL<0>
+ RM_IHPSG13_1P_COLUMN_256_0[1]/RM_IHPSG13_1P_BITKIT_16x2_SRAM_1[2]/A_RWL<5> RM_IHPSG13_1P_COLUMN_256_0[1]/RM_IHPSG13_1P_BITKIT_16x2_SRAM_0[2]/A_LWL<12>
+ RM_IHPSG13_1P_COLUMN_256_0[1]/RM_IHPSG13_1P_BITKIT_16x2_SRAM_0[0]/A_RWL<11> RM_IHPSG13_1P_COLUMN_256_0[1]/RM_IHPSG13_1P_BITKIT_16x2_SRAM_1[3]/A_LWL<1>
+ RM_IHPSG13_1P_COLUMN_256_0[1]/RM_IHPSG13_1P_BITKIT_16x2_SRAM_3[1]/A_LWL<2> RM_IHPSG13_1P_COLUMN_256_0[1]/RM_IHPSG13_1P_BITKIT_16x2_SRAM_1[2]/A_LWL<12>
+ RM_IHPSG13_1P_COLUMN_256_0[1]/RM_IHPSG13_1P_BITKIT_16x2_SRAM_1[2]/A_LWL<0> RM_IHPSG13_1P_COLUMN_256_0[1]/RM_IHPSG13_1P_BITKIT_16x2_SRAM_3[3]/A_LWL<0>
+ RM_IHPSG13_1P_COLUMN_256_0[1]/RM_IHPSG13_1P_BITKIT_16x2_SRAM_1[2]/A_RWL<12> RM_IHPSG13_1P_COLUMN_256_0[1]/RM_IHPSG13_1P_BITKIT_16x2_SRAM_2[1]/A_LWL<8>
+ RM_IHPSG13_1P_COLUMN_256_0[1]/RM_IHPSG13_1P_BITKIT_16x2_SRAM_2[2]/A_LWL<11> RM_IHPSG13_1P_COLUMN_256_0[1]/RM_IHPSG13_1P_BITKIT_16x2_SRAM_0[2]/A_LWL<1>
+ RM_IHPSG13_1P_COLUMN_256_0[1]/RM_IHPSG13_1P_BITKIT_16x2_SRAM_1[2]/A_RWL<2> RM_IHPSG13_1P_COLUMN_256_0[1]/RM_IHPSG13_1P_BITKIT_16x2_SRAM_3[0]/A_LWL<5>
+ RM_IHPSG13_1P_COLUMN_256_0[1]/RM_IHPSG13_1P_BITKIT_16x2_SRAM_1[1]/A_RWL<15> RM_IHPSG13_1P_COLUMN_256_0[1]/RM_IHPSG13_1P_BITKIT_16x2_SRAM_3[3]/A_LWL<9>
+ RM_IHPSG13_1P_COLUMN_256_0[1]/RM_IHPSG13_1P_BITKIT_16x2_SRAM_2[2]/A_LWL<14> RM_IHPSG13_1P_COLUMN_256_0[1]/RM_IHPSG13_1P_BITKIT_16x2_SRAM_3[2]/A_RWL<3>
+ RM_IHPSG13_1P_COLUMN_256_0[1]/RM_IHPSG13_1P_BITKIT_16x2_SRAM_2[2]/A_RWL<5> RM_IHPSG13_1P_COLUMN_256_0[1]/RM_IHPSG13_1P_BITKIT_16x2_SRAM_1[3]/A_LWL<7>
+ RM_IHPSG13_1P_COLUMN_256_0[1]/RM_IHPSG13_1P_BITKIT_16x2_SRAM_1[2]/A_RWL<6> RM_IHPSG13_1P_COLUMN_256_0[1]/RM_IHPSG13_1P_BITKIT_16x2_SRAM_0[2]/A_LWL<13>
+ RM_IHPSG13_1P_COLUMN_256_0[1]/RM_IHPSG13_1P_BITKIT_16x2_SRAM_3[2]/A_LWL<7> RM_IHPSG13_1P_COLUMN_256_0[1]/RM_IHPSG13_1P_BITKIT_16x2_SRAM_2[2]/A_LWL<0>
+ RM_IHPSG13_1P_COLUMN_256_0[1]/RM_IHPSG13_1P_BITKIT_16x2_SRAM_0[0]/A_RWL<12> RM_IHPSG13_1P_COLUMN_256_0[1]/RM_IHPSG13_1P_BITKIT_16x2_SRAM_0[2]/A_RWL<7>
+ RM_IHPSG13_1P_COLUMN_256_0[1]/RM_IHPSG13_1P_BITKIT_16x2_SRAM_0[3]/A_LWL<10> RM_IHPSG13_1P_COLUMN_256_0[1]/RM_IHPSG13_1P_BITKIT_16x2_SRAM_1[2]/A_LWL<1>
+ RM_IHPSG13_1P_COLUMN_256_0[1]/RM_IHPSG13_1P_BITKIT_16x2_SRAM_3[2]/A_RWL<13> RM_IHPSG13_1P_COLUMN_256_0[1]/RM_IHPSG13_1P_BITKIT_16x2_SRAM_2[1]/A_LWL<9>
+ RM_IHPSG13_1P_COLUMN_256_0[1]/RM_IHPSG13_1P_BITKIT_16x2_SRAM_2[0]/A_RWL<10> RM_IHPSG13_1P_COLUMN_256_0[1]/RM_IHPSG13_1P_BITKIT_16x2_SRAM_0[2]/A_LWL<2>
+ RM_IHPSG13_1P_COLUMN_256_0[1]/RM_IHPSG13_1P_BITKIT_16x2_SRAM_2[3]/A_RWL<8> RM_IHPSG13_1P_COLUMN_256_0[1]/RM_IHPSG13_1P_BITKIT_16x2_SRAM_3[2]/A_RWL<5>
+ RM_IHPSG13_1P_COLUMN_256_0[1]/RM_IHPSG13_1P_BITKIT_16x2_SRAM_1[3]/A_RWL<10> RM_IHPSG13_1P_COLUMN_256_0[1]/RM_IHPSG13_1P_BITKIT_16x2_SRAM_0[1]/A_LWL<5>
+ RM_IHPSG13_1P_COLUMN_256_0[1]/RM_IHPSG13_1P_BITKIT_16x2_SRAM_0[0]/A_LWL<8> RM_IHPSG13_1P_COLUMN_256_0[1]/RM_IHPSG13_1P_BITKIT_16x2_SRAM_1[1]/A_RWL<7>
+ RM_IHPSG13_1P_COLUMN_256_0[1]/RM_IHPSG13_1P_BITKIT_16x2_SRAM_2[2]/A_LWL<13> RM_IHPSG13_1P_COLUMN_256_0[1]/RM_IHPSG13_1P_BITKIT_16x2_SRAM_1[0]/A_RWL<0>
+ RM_IHPSG13_1P_COLUMN_256_0[1]/RM_IHPSG13_1P_BITKIT_16x2_SRAM_2[1]/A_LWL<4> RM_IHPSG13_1P_COLUMN_256_0[1]/RM_IHPSG13_1P_BITKIT_16x2_SRAM_3[0]/A_RWL<7>
+ RM_IHPSG13_1P_COLUMN_256_0[1]/RM_IHPSG13_1P_BITKIT_16x2_SRAM_3[2]/A_LWL<0> RM_IHPSG13_1P_COLUMN_256_0[1]/RM_IHPSG13_1P_BITKIT_16x2_SRAM_1[2]/A_RWL<7>
+ RM_IHPSG13_1P_COLUMN_256_0[1]/RM_IHPSG13_1P_BITKIT_16x2_SRAM_1[1]/A_LWL<2> RM_IHPSG13_1P_COLUMN_256_0[1]/RM_IHPSG13_1P_BITKIT_16x2_SRAM_0[0]/A_RWL<13>
+ RM_IHPSG13_1P_COLUMN_256_0[1]/RM_IHPSG13_1P_BITKIT_16x2_SRAM_2[1]/A_RWL<14> RM_IHPSG13_1P_COLUMN_256_0[1]/RM_IHPSG13_1P_BITKIT_16x2_SRAM_2[2]/A_LWL<1>
+ RM_IHPSG13_1P_COLUMN_256_0[1]/RM_IHPSG13_1P_BITKIT_16x2_SRAM_3[1]/A_LWL<9> RM_IHPSG13_1P_COLUMN_256_0[1]/RM_IHPSG13_1P_BITKIT_16x2_SRAM_3[0]/A_LWL<2>
+ RM_IHPSG13_1P_COLUMN_256_0[1]/RM_IHPSG13_1P_BITKIT_16x2_SRAM_3[3]/A_RWL<4> RM_IHPSG13_1P_COLUMN_256_0[1]/RM_IHPSG13_1P_BITKIT_16x2_SRAM_0[2]/A_LWL<11>
+ RM_IHPSG13_1P_COLUMN_256_0[1]/RM_IHPSG13_1P_BITKIT_16x2_SRAM_0[3]/A_LWL<11> RM_IHPSG13_1P_COLUMN_256_0[1]/RM_IHPSG13_1P_BITKIT_16x2_SRAM_1[2]/A_LWL<2>
+ RM_IHPSG13_1P_COLUMN_256_0[1]/RM_IHPSG13_1P_BITKIT_16x2_SRAM_1[2]/A_RWL<14> RM_IHPSG13_1P_COLUMN_256_0[1]/RM_IHPSG13_1P_BITKIT_16x2_SRAM_2[1]/A_LWL<11>
+ RM_IHPSG13_1P_COLUMN_256_0[1]/RM_IHPSG13_1P_BITKIT_16x2_SRAM_0[1]/A_RWL<10> RM_IHPSG13_1P_COLUMN_256_0[1]/RM_IHPSG13_1P_BITKIT_16x2_SRAM_0[2]/A_LWL<3>
+ RM_IHPSG13_1P_COLUMN_256_0[1]/RM_IHPSG13_1P_BITKIT_16x2_SRAM_0[2]/A_LWL<14> RM_IHPSG13_1P_COLUMN_256_0[1]/RM_IHPSG13_1P_BITKIT_16x2_SRAM_3[2]/A_RWL<6>
+ RM_IHPSG13_1P_COLUMN_256_0[1]/RM_IHPSG13_1P_BITKIT_16x2_SRAM_1[3]/A_RWL<11> RM_IHPSG13_1P_COLUMN_256_0[1]/RM_IHPSG13_1P_BITKIT_16x2_SRAM_2[1]/A_LWL<14>
+ RM_IHPSG13_1P_COLUMN_256_0[1]/RM_IHPSG13_1P_BITKIT_16x2_SRAM_2[2]/A_RWL<7> RM_IHPSG13_1P_COLUMN_256_0[1]/RM_IHPSG13_1P_BITKIT_16x2_SRAM_0[3]/A_RWL<0>
+ RM_IHPSG13_1P_COLUMN_256_0[1]/RM_IHPSG13_1P_BITKIT_16x2_SRAM_1[0]/A_LWL<0> RM_IHPSG13_1P_COLUMN_256_0[1]/RM_IHPSG13_1P_BITKIT_16x2_SRAM_1[2]/A_RWL<8>
+ RM_IHPSG13_1P_COLUMN_256_0[1]/RM_IHPSG13_1P_BITKIT_16x2_SRAM_3[2]/A_LWL<1> RM_IHPSG13_1P_COLUMN_256_0[1]/RM_IHPSG13_1P_BITKIT_16x2_SRAM_0[2]/A_LWL<15>
+ RM_IHPSG13_1P_COLUMN_256_0[1]/RM_IHPSG13_1P_BITKIT_16x2_SRAM_1[3]/A_LWL<12> RM_IHPSG13_1P_COLUMN_256_0[1]/RM_IHPSG13_1P_BITKIT_16x2_SRAM_3[1]/A_LWL<7>
+ RM_IHPSG13_1P_COLUMN_256_0[1]/RM_IHPSG13_1P_BITKIT_16x2_SRAM_0[2]/A_RWL<9> RM_IHPSG13_1P_COLUMN_256_0[1]/RM_IHPSG13_1P_BITKIT_16x2_SRAM_0[0]/A_RWL<14>
+ RM_IHPSG13_1P_COLUMN_256_0[1]/RM_IHPSG13_1P_BITKIT_16x2_SRAM_2[2]/A_LWL<2> RM_IHPSG13_1P_COLUMN_256_0[1]/RM_IHPSG13_1P_BITKIT_16x2_SRAM_1[2]/A_RWL<13>
+ RM_IHPSG13_1P_COLUMN_256_0[1]/RM_IHPSG13_1P_BITKIT_16x2_SRAM_1[0]/A_LWL<9> RM_IHPSG13_1P_COLUMN_256_0[1]/RM_IHPSG13_1P_BITKIT_16x2_SRAM_0[3]/A_LWL<12>
+ RM_IHPSG13_1P_COLUMN_256_0[1]/RM_IHPSG13_1P_BITKIT_16x2_SRAM_1[2]/A_LWL<3> RM_IHPSG13_1P_COLUMN_256_0[1]/RM_IHPSG13_1P_BITKIT_16x2_SRAM_3[1]/A_RWL<13>
+ RM_IHPSG13_1P_COLUMN_256_0[1]/RM_IHPSG13_1P_BITKIT_16x2_SRAM_3[1]/A_LWL<5> RM_IHPSG13_1P_COLUMN_256_0[1]/RM_IHPSG13_1P_BITKIT_16x2_SRAM_0[0]/A_RWL<10>
+ RM_IHPSG13_1P_COLUMN_256_0[1]/RM_IHPSG13_1P_BITKIT_16x2_SRAM_0[3]/A_RWL<8> RM_IHPSG13_1P_COLUMN_256_0[1]/RM_IHPSG13_1P_BITKIT_16x2_SRAM_1[2]/A_RWL<15>
+ RM_IHPSG13_1P_COLUMN_256_0[1]/RM_IHPSG13_1P_BITKIT_16x2_SRAM_3[0]/A_LWL<8> RM_IHPSG13_1P_COLUMN_256_0[1]/RM_IHPSG13_1P_BITKIT_16x2_SRAM_0[1]/A_RWL<11>
+ RM_IHPSG13_1P_COLUMN_256_0[1]/RM_IHPSG13_1P_BITKIT_16x2_SRAM_3[3]/A_RWL<3> RM_IHPSG13_1P_COLUMN_256_0[1]/RM_IHPSG13_1P_BITKIT_16x2_SRAM_0[2]/A_LWL<4>
+ RM_IHPSG13_1P_COLUMN_256_0[1]/RM_IHPSG13_1P_BITKIT_16x2_SRAM_3[2]/A_RWL<7> RM_IHPSG13_1P_COLUMN_256_0[1]/RM_IHPSG13_1P_BITKIT_16x2_SRAM_1[3]/A_RWL<12>
+ RM_IHPSG13_1P_COLUMN_256_0[1]/RM_IHPSG13_1P_BITKIT_16x2_SRAM_1[0]/A_RWL<7> RM_IHPSG13_1P_COLUMN_256_0[1]/RM_IHPSG13_1P_BITKIT_16x2_SRAM_1[3]/A_RWL<0>
+ RM_IHPSG13_1P_COLUMN_256_0[1]/RM_IHPSG13_1P_BITKIT_16x2_SRAM_2[2]/A_RWL<8> RM_IHPSG13_1P_COLUMN_256_0[1]/RM_IHPSG13_1P_BITKIT_16x2_SRAM_2[3]/A_RWL<6>
+ RM_IHPSG13_1P_COLUMN_256_0[1]/RM_IHPSG13_1P_BITKIT_16x2_SRAM_2[2]/A_RWL<1> RM_IHPSG13_1P_COLUMN_256_0[1]/RM_IHPSG13_1P_BITKIT_16x2_SRAM_0[3]/A_RWL<1>
+ RM_IHPSG13_1P_COLUMN_256_0[1]/RM_IHPSG13_1P_BITKIT_16x2_SRAM_3[2]/A_LWL<2> RM_IHPSG13_1P_COLUMN_256_0[1]/RM_IHPSG13_1P_BITKIT_16x2_SRAM_1[2]/A_RWL<9>
+ RM_IHPSG13_1P_COLUMN_256_0[1]/RM_IHPSG13_1P_BITKIT_16x2_SRAM_1[0]/A_LWL<2> RM_IHPSG13_1P_COLUMN_256_0[1]/RM_IHPSG13_1P_BITKIT_16x2_SRAM_2[2]/A_LWL<3>
+ RM_IHPSG13_1P_COLUMN_256_0[1]/RM_IHPSG13_1P_BITKIT_16x2_SRAM_0[0]/A_RWL<15> RM_IHPSG13_1P_COLUMN_256_0[1]/RM_IHPSG13_1P_BITKIT_16x2_SRAM_0[1]/A_LWL<11>
+ RM_IHPSG13_1P_COLUMN_256_0[1]/RM_IHPSG13_1P_BITKIT_16x2_SRAM_3[2]/A_RWL<4> RM_IHPSG13_1P_COLUMN_256_0[1]/RM_IHPSG13_1P_BITKIT_16x2_SRAM_0[3]/A_LWL<13>
+ RM_IHPSG13_1P_COLUMN_256_0[1]/RM_IHPSG13_1P_BITKIT_16x2_SRAM_1[2]/A_LWL<4> RM_IHPSG13_1P_COLUMN_256_0[1]/RM_IHPSG13_1P_BITKIT_16x2_SRAM_2[0]/A_LWL<11>
+ RM_IHPSG13_1P_COLUMN_256_0[1]/RM_IHPSG13_1P_BITKIT_16x2_SRAM_0[1]/A_RWL<12> RM_IHPSG13_1P_COLUMN_256_0[1]/RM_IHPSG13_1P_BITKIT_16x2_SRAM_3[3]/A_LWL<10>
+ RM_IHPSG13_1P_COLUMN_256_0[1]/RM_IHPSG13_1P_BITKIT_16x2_SRAM_2[0]/A_LWL<1> RM_IHPSG13_1P_COLUMN_256_0[1]/RM_IHPSG13_1P_BITKIT_16x2_SRAM_0[1]/A_LWL<8>
+ RM_IHPSG13_1P_COLUMN_256_0[1]/RM_IHPSG13_1P_BITKIT_16x2_SRAM_0[1]/A_LWL<14> RM_IHPSG13_1P_COLUMN_256_0[1]/RM_IHPSG13_1P_BITKIT_16x2_SRAM_0[2]/A_LWL<5>
+ RM_IHPSG13_1P_COLUMN_256_0[1]/RM_IHPSG13_1P_BITKIT_16x2_SRAM_2[3]/A_RWL<0> RM_IHPSG13_1P_COLUMN_256_0[1]/RM_IHPSG13_1P_BITKIT_16x2_SRAM_2[3]/A_LWL<13>
+ RM_IHPSG13_1P_COLUMN_256_0[1]/RM_IHPSG13_1P_BITKIT_16x2_SRAM_3[2]/A_RWL<8> RM_IHPSG13_1P_COLUMN_256_0[1]/RM_IHPSG13_1P_BITKIT_16x2_SRAM_1[3]/A_RWL<13>
+ RM_IHPSG13_1P_COLUMN_256_0[1]/RM_IHPSG13_1P_BITKIT_16x2_SRAM_2[0]/A_LWL<14> RM_IHPSG13_1P_COLUMN_256_0[1]/RM_IHPSG13_1P_BITKIT_16x2_SRAM_1[3]/A_RWL<1>
+ RM_IHPSG13_1P_COLUMN_256_0[1]/RM_IHPSG13_1P_BITKIT_16x2_SRAM_2[2]/A_RWL<9> RM_IHPSG13_1P_COLUMN_256_0[1]/RM_IHPSG13_1P_BITKIT_16x2_SRAM_1[1]/A_LWL<7>
+ RM_IHPSG13_1P_COLUMN_256_0[1]/RM_IHPSG13_1P_BITKIT_16x2_SRAM_2[2]/A_RWL<14> RM_IHPSG13_1P_COLUMN_256_0[1]/RM_IHPSG13_1P_BITKIT_16x2_SRAM_0[3]/A_RWL<2>
+ RM_IHPSG13_1P_COLUMN_256_0[1]/RM_IHPSG13_1P_BITKIT_16x2_SRAM_3[2]/A_LWL<3> RM_IHPSG13_1P_COLUMN_256_0[1]/RM_IHPSG13_1P_BITKIT_16x2_SRAM_3[0]/A_LWL<7>
+ RM_IHPSG13_1P_COLUMN_256_0[1]/RM_IHPSG13_1P_BITKIT_16x2_SRAM_2[2]/A_LWL<4> RM_IHPSG13_1P_COLUMN_256_0[1]/RM_IHPSG13_1P_BITKIT_16x2_SRAM_1[1]/A_RWL<13>
+ RM_IHPSG13_1P_COLUMN_256_0[1]/RM_IHPSG13_1P_BITKIT_16x2_SRAM_0[3]/A_LWL<14> RM_IHPSG13_1P_COLUMN_256_0[1]/RM_IHPSG13_1P_BITKIT_16x2_SRAM_3[0]/A_RWL<13>
+ RM_IHPSG13_1P_COLUMN_256_0[1]/RM_IHPSG13_1P_BITKIT_16x2_SRAM_1[2]/A_LWL<5> RM_IHPSG13_1P_COLUMN_256_0[1]/RM_IHPSG13_1P_BITKIT_16x2_SRAM_3[3]/A_RWL<0>
+ RM_IHPSG13_1P_COLUMN_256_0[1]/RM_IHPSG13_1P_BITKIT_16x2_SRAM_0[2]/A_RWL<8> RM_IHPSG13_1P_COLUMN_256_0[1]/RM_IHPSG13_1P_BITKIT_16x2_SRAM_0[1]/A_RWL<13>
+ RM_IHPSG13_1P_COLUMN_256_0[1]/RM_IHPSG13_1P_BITKIT_16x2_SRAM_3[0]/A_LWL<10> RM_IHPSG13_1P_COLUMN_256_0[1]/RM_IHPSG13_1P_BITKIT_16x2_SRAM_2[1]/A_RWL<8>
+ RM_IHPSG13_1P_COLUMN_256_0[1]/RM_IHPSG13_1P_BITKIT_16x2_SRAM_0[2]/A_LWL<6> RM_IHPSG13_1P_COLUMN_256_0[1]/RM_IHPSG13_1P_BITKIT_16x2_SRAM_2[3]/A_RWL<1>
+ RM_IHPSG13_1P_COLUMN_256_0[1]/RM_IHPSG13_1P_BITKIT_16x2_SRAM_3[2]/A_RWL<9> RM_IHPSG13_1P_COLUMN_256_0[1]/RM_IHPSG13_1P_BITKIT_16x2_SRAM_0[3]/A_RWL<6>
+ RM_IHPSG13_1P_COLUMN_256_0[1]/RM_IHPSG13_1P_BITKIT_16x2_SRAM_1[3]/A_RWL<14> RM_IHPSG13_1P_COLUMN_256_0[1]/RM_IHPSG13_1P_BITKIT_16x2_SRAM_0[2]/A_RWL<1>
+ RM_IHPSG13_1P_COLUMN_256_0[1]/RM_IHPSG13_1P_BITKIT_16x2_SRAM_1[1]/A_LWL<0> RM_IHPSG13_1P_COLUMN_256_0[1]/RM_IHPSG13_1P_BITKIT_16x2_SRAM_0[2]/A_RWL<10>
+ RM_IHPSG13_1P_COLUMN_256_0[1]/RM_IHPSG13_1P_BITKIT_16x2_SRAM_1[3]/A_RWL<2> RM_IHPSG13_1P_COLUMN_256_0[1]/RM_IHPSG13_1P_BITKIT_16x2_SRAM_2[2]/A_RWL<6>
+ RM_IHPSG13_1P_COLUMN_256_0[1]/RM_IHPSG13_1P_BITKIT_16x2_SRAM_2[1]/A_RWL<1> RM_IHPSG13_1P_COLUMN_256_0[1]/RM_IHPSG13_1P_BITKIT_16x2_SRAM_0[3]/A_RWL<3>
+ RM_IHPSG13_1P_COLUMN_256_0[1]/RM_IHPSG13_1P_BITKIT_16x2_SRAM_3[2]/A_LWL<4> RM_IHPSG13_1P_COLUMN_256_0[1]/RM_IHPSG13_1P_BITKIT_16x2_SRAM_1[1]/A_LWL<9>
+ RM_IHPSG13_1P_COLUMN_256_0[1]/RM_IHPSG13_1P_BITKIT_16x2_SRAM_1[2]/A_RWL<4> RM_IHPSG13_1P_COLUMN_256_0[1]/RM_IHPSG13_1P_BITKIT_16x2_SRAM_1[0]/A_RWL<3>
+ RM_IHPSG13_1P_COLUMN_256_0[1]/RM_IHPSG13_1P_BITKIT_16x2_SRAM_2[2]/A_LWL<5> RM_IHPSG13_1P_COLUMN_256_0[1]/RM_IHPSG13_1P_BITKIT_16x2_SRAM_3[1]/A_LWL<8>
+ RM_IHPSG13_1P_COLUMN_256_0[1]/RM_IHPSG13_1P_BITKIT_16x2_SRAM_0[0]/A_LWL<11> RM_IHPSG13_1P_COLUMN_256_0[1]/RM_IHPSG13_1P_BITKIT_16x2_SRAM_3[1]/A_RWL<4>
+ RM_IHPSG13_1P_COLUMN_256_0[1]/RM_IHPSG13_1P_BITKIT_16x2_SRAM_0[3]/A_LWL<15> RM_IHPSG13_1P_COLUMN_256_0[1]/RM_IHPSG13_1P_BITKIT_16x2_SRAM_1[3]/A_LWL<10>
+ RM_IHPSG13_1P_COLUMN_256_0[1]/RM_IHPSG13_1P_BITKIT_16x2_SRAM_1[2]/A_LWL<6> RM_IHPSG13_1P_COLUMN_256_0[1]/RM_IHPSG13_1P_BITKIT_16x2_SRAM_3[3]/A_RWL<1>
+ RM_IHPSG13_1P_COLUMN_256_0[1]/RM_IHPSG13_1P_BITKIT_16x2_SRAM_0[1]/A_RWL<14> RM_IHPSG13_1P_COLUMN_256_0[1]/RM_IHPSG13_1P_BITKIT_16x2_SRAM_3[2]/A_LWL<10>
+ RM_IHPSG13_1P_COLUMN_256_0[1]/RM_IHPSG13_1P_BITKIT_16x2_SRAM_3[0]/A_LWL<11> RM_IHPSG13_1P_COLUMN_256_0[1]/RM_IHPSG13_1P_BITKIT_16x2_SRAM_0[0]/A_LWL<14>
+ RM_IHPSG13_1P_COLUMN_256_0[1]/RM_IHPSG13_1P_BITKIT_16x2_SRAM_0[2]/A_LWL<7> RM_IHPSG13_1P_COLUMN_256_0[1]/RM_IHPSG13_1P_BITKIT_16x2_SRAM_2[3]/A_RWL<2>
+ RM_IHPSG13_1P_COLUMN_256_0[1]/RM_IHPSG13_1P_BITKIT_16x2_SRAM_2[3]/A_RWL<11> RM_IHPSG13_1P_COLUMN_256_0[1]/RM_IHPSG13_1P_BITKIT_16x2_SRAM_1[3]/A_RWL<15>
+ RM_IHPSG13_1P_COLUMN_256_0[1]/RM_IHPSG13_1P_BITKIT_16x2_SRAM_0[2]/A_RWL<11> RM_IHPSG13_1P_COLUMN_256_0[1]/RM_IHPSG13_1P_BITKIT_16x2_SRAM_1[3]/A_RWL<3>
+ RM_IHPSG13_1P_COLUMN_256_0[1]/RM_IHPSG13_1P_BITKIT_16x2_SRAM_1[0]/A_LWL<7> RM_IHPSG13_1P_COLUMN_256_0[1]/RM_IHPSG13_1P_BITKIT_16x2_SRAM_0[3]/A_RWL<4>
+ RM_IHPSG13_1P_COLUMN_256_0[1]/RM_IHPSG13_1P_BITKIT_16x2_SRAM_2[3]/A_LWL<6> RM_IHPSG13_1P_COLUMN_256_0[1]/RM_IHPSG13_1P_BITKIT_16x2_SRAM_3[2]/A_LWL<5>
+ RM_IHPSG13_1P_COLUMN_256_0[1]/RM_IHPSG13_1P_BITKIT_16x2_SRAM_0[0]/A_LWL<13> RM_IHPSG13_1P_COLUMN_256_0[1]/RM_IHPSG13_1P_BITKIT_16x2_SRAM_2[2]/A_LWL<6>
+ RM_IHPSG13_1P_COLUMN_256_0[1]/RM_IHPSG13_1P_BITKIT_16x2_SRAM_1[0]/A_RWL<13> RM_IHPSG13_1P_COLUMN_256_0[1]/RM_IHPSG13_1P_BITKIT_16x2_SRAM_2[1]/A_LWL<1>
+ RM_IHPSG13_1P_COLUMN_256_0[1]/RM_IHPSG13_1P_BITKIT_16x2_SRAM_0[3]/A_LWL<5> RM_IHPSG13_1P_COLUMN_256_0[1]/RM_IHPSG13_1P_BITKIT_16x2_SRAM_2[0]/A_LWL<12>
+ RM_IHPSG13_1P_COLUMN_256_0[1]/RM_IHPSG13_1P_BITKIT_16x2_SRAM_3[3]/A_LWL<3> RM_IHPSG13_1P_COLUMN_256_0[1]/RM_IHPSG13_1P_BITKIT_16x2_SRAM_1[2]/A_LWL<7>
+ RM_IHPSG13_1P_COLUMN_256_0[1]/RM_IHPSG13_1P_BITKIT_16x2_SRAM_3[3]/A_RWL<2> RM_IHPSG13_1P_COLUMN_256_0[1]/RM_IHPSG13_1P_BITKIT_16x2_SRAM_0[1]/A_RWL<8>
+ RM_IHPSG13_1P_COLUMN_256_0[1]/RM_IHPSG13_1P_BITKIT_16x2_SRAM_2[3]/A_LWL<4> RM_IHPSG13_1P_COLUMN_256_0[1]/RM_IHPSG13_1P_BITKIT_16x2_SRAM_0[1]/A_RWL<15>
+ RM_IHPSG13_1P_COLUMN_256_0[1]/RM_IHPSG13_1P_BITKIT_16x2_SRAM_3[0]/A_LWL<12> RM_IHPSG13_1P_COLUMN_256_0[1]/RM_IHPSG13_1P_BITKIT_16x2_SRAM_2[0]/A_RWL<8>
+ RM_IHPSG13_1P_COLUMN_256_0[1]/RM_IHPSG13_1P_BITKIT_16x2_SRAM_0[2]/A_LWL<8> RM_IHPSG13_1P_COLUMN_256_0[1]/RM_IHPSG13_1P_BITKIT_16x2_SRAM_2[3]/A_RWL<3>
+ RM_IHPSG13_1P_COLUMN_256_0[1]/RM_IHPSG13_1P_BITKIT_16x2_SRAM_2[0]/A_RWL<2> RM_IHPSG13_1P_COLUMN_256_0[1]/RM_IHPSG13_1P_BITKIT_16x2_SRAM_3[3]/A_RWL<9>
+ RM_IHPSG13_1P_COLUMN_256_0[1]/RM_IHPSG13_1P_BITKIT_16x2_SRAM_0[2]/A_RWL<6> RM_IHPSG13_1P_COLUMN_256_0[1]/RM_IHPSG13_1P_BITKIT_16x2_SRAM_0[1]/A_RWL<1>
+ RM_IHPSG13_1P_COLUMN_256_0[1]/RM_IHPSG13_1P_BITKIT_16x2_SRAM_2[3]/A_RWL<14> RM_IHPSG13_1P_COLUMN_256_0[1]/RM_IHPSG13_1P_BITKIT_16x2_SRAM_0[2]/A_RWL<12>
+ RM_IHPSG13_1P_COLUMN_256_0[1]/RM_IHPSG13_1P_BITKIT_16x2_SRAM_1[3]/A_RWL<4> RM_IHPSG13_1P_COLUMN_256_0[1]/RM_IHPSG13_1P_BITKIT_16x2_SRAM_2[1]/A_RWL<6>
+ RM_IHPSG13_1P_COLUMN_256_0[1]/RM_IHPSG13_1P_BITKIT_16x2_SRAM_2[0]/A_RWL<1> RM_IHPSG13_1P_COLUMN_256_0[7]/RM_IHPSG13_1P_BITKIT_16x2_SRAM_3[3]/VSS
+ RM_IHPSG13_1P_COLUMN_256_0[7]/RM_IHPSG13_1P_BITKIT_16x2_SRAM_3[3]/VDD RM_IHPSG13_1P_COLUMN_256_0[1]/RM_IHPSG13_1P_BITKIT_16x2_SRAM_0[3]/A_RWL<5>
+ RM_IHPSG13_1P_COLUMN_256_0[1]/RM_IHPSG13_1P_BITKIT_16x2_SRAM_3[2]/A_LWL<6> RM_IHPSG13_1P_COLUMN_256
XRM_IHPSG13_1P_COLUMN_256_0[2] RM_IHPSG13_1P_COLUMN_256_0[2]/RM_IHPSG13_1P_BITKIT_16x2_SRAM_0[0]/A_BLT_BOT<0>
+ RM_IHPSG13_1P_COLUMN_256_0[2]/RM_IHPSG13_1P_BITKIT_16x2_SRAM_3[1]/A_LWL<10> RM_IHPSG13_1P_COLUMN_256_0[2]/RM_IHPSG13_1P_BITKIT_16x2_SRAM_3[0]/A_LWL<13>
+ RM_IHPSG13_1P_COLUMN_256_0[2]/RM_IHPSG13_1P_BITKIT_16x2_SRAM_0[0]/A_BLT_BOT<1> RM_IHPSG13_1P_COLUMN_256_0[2]/RM_IHPSG13_1P_BITKIT_16x2_SRAM_1[2]/A_LWL<9>
+ RM_IHPSG13_1P_COLUMN_256_0[2]/RM_IHPSG13_1P_BITKIT_16x2_SRAM_0[0]/A_BLC_BOT<0> RM_IHPSG13_1P_COLUMN_256_0[2]/RM_IHPSG13_1P_BITKIT_16x2_SRAM_3[2]/A_LWL<8>
+ RM_IHPSG13_1P_COLUMN_256_0[2]/RM_IHPSG13_1P_BITKIT_16x2_SRAM_0[3]/A_RWL<11> RM_IHPSG13_1P_COLUMN_256_0[2]/RM_IHPSG13_1P_BITKIT_16x2_SRAM_2[3]/A_RWL<5>
+ RM_IHPSG13_1P_COLUMN_256_0[2]/RM_IHPSG13_1P_BITKIT_16x2_SRAM_0[0]/A_BLC_BOT<1> RM_IHPSG13_1P_COLUMN_256_0[2]/RM_IHPSG13_1P_BITKIT_16x2_SRAM_1[3]/A_LWL<0>
+ RM_IHPSG13_1P_COLUMN_256_0[2]/RM_IHPSG13_1P_BITKIT_16x2_SRAM_3[1]/A_LWL<13> RM_IHPSG13_1P_COLUMN_256_0[2]/RM_IHPSG13_1P_BITKIT_16x2_SRAM_1[3]/A_LWL<3>
+ RM_IHPSG13_1P_COLUMN_256_0[2]/RM_IHPSG13_1P_BITKIT_16x2_SRAM_1[3]/A_RWL<9> RM_IHPSG13_1P_COLUMN_256_0[2]/RM_IHPSG13_1P_BITKIT_16x2_SRAM_2[3]/A_LWL<1>
+ RM_IHPSG13_1P_COLUMN_256_0[2]/RM_IHPSG13_1P_BITKIT_16x2_SRAM_0[0]/A_RWL<1> RM_IHPSG13_1P_COLUMN_256_0[2]/RM_IHPSG13_1P_BITKIT_16x2_SRAM_0[3]/A_LWL<6>
+ RM_IHPSG13_1P_COLUMN_256_0[2]/RM_IHPSG13_1P_BITKIT_16x2_SRAM_2[3]/A_RWL<7> RM_IHPSG13_1P_COLUMN_256_0[2]/RM_IHPSG13_1P_BITKIT_16x2_SRAM_3[2]/A_LWL<13>
+ RM_IHPSG13_1P_COLUMN_256_0[2]/RM_IHPSG13_1P_BITKIT_16x2_SRAM_2[3]/A_LWL<2> RM_IHPSG13_1P_COLUMN_256_0[2]/RM_IHPSG13_1P_BITKIT_16x2_SRAM_3[3]/A_LWL<5>
+ RM_IHPSG13_1P_COLUMN_256_0[2]/RM_IHPSG13_1P_BITKIT_16x2_SRAM_0[2]/A_RWL<14> RM_IHPSG13_1P_COLUMN_256_0[2]/RM_IHPSG13_1P_BITKIT_16x2_SRAM_0[3]/A_LWL<8>
+ RM_IHPSG13_1P_COLUMN_256_0[2]/RM_IHPSG13_1P_BITKIT_16x2_SRAM_3[3]/A_LWL<11> RM_IHPSG13_1P_COLUMN_256_0[2]/RM_IHPSG13_1P_BITKIT_16x2_SRAM_3[0]/A_RWL<12>
+ RM_IHPSG13_1P_COLUMN_256_0[2]/RM_IHPSG13_1P_BITKIT_16x2_SRAM_3[1]/A_RWL<10> RM_IHPSG13_1P_COLUMN_256_0[2]/RM_IHPSG13_1P_BITKIT_16x2_SRAM_0[3]/A_RWL<7>
+ RM_IHPSG13_1P_COLUMN_256_0[2]/RM_IHPSG13_1P_BITKIT_16x2_SRAM_0[3]/A_LWL<2> RM_IHPSG13_1P_COLUMN_256_0[2]/RM_IHPSG13_1P_BITKIT_16x2_SRAM_3[0]/A_RWL<14>
+ RM_IHPSG13_1P_COLUMN_256_0[2]/RM_IHPSG13_1P_BITKIT_16x2_SRAM_1[0]/A_RWL<4> RM_IHPSG13_1P_COLUMN_256_0[2]/RM_IHPSG13_1P_BITKIT_16x2_SRAM_3[2]/A_LWL<11>
+ RM_IHPSG13_1P_COLUMN_256_0[2]/RM_IHPSG13_1P_BITKIT_16x2_SRAM_3[2]/A_LWL<14> RM_IHPSG13_1P_COLUMN_256_0[2]/RM_IHPSG13_1P_BITKIT_16x2_SRAM_2[0]/A_LWL<15>
+ RM_IHPSG13_1P_COLUMN_256_0[2]/RM_IHPSG13_1P_BITKIT_16x2_SRAM_0[0]/A_RWL<5> RM_IHPSG13_1P_COLUMN_256_0[2]/RM_IHPSG13_1P_BITKIT_16x2_SRAM_2[3]/A_LWL<7>
+ RM_IHPSG13_1P_COLUMN_256_0[2]/RM_IHPSG13_1P_BITKIT_16x2_SRAM_1[3]/A_LWL<9> RM_IHPSG13_1P_COLUMN_256_0[2]/RM_IHPSG13_1P_BITKIT_16x2_SRAM_2[1]/A_LWL<12>
+ RM_IHPSG13_1P_COLUMN_256_0[2]/RM_IHPSG13_1P_BITKIT_16x2_SRAM_0[3]/A_LWL<4> RM_IHPSG13_1P_COLUMN_256_0[2]/RM_IHPSG13_1P_BITKIT_16x2_SRAM_3[3]/A_LWL<13>
+ RM_IHPSG13_1P_COLUMN_256_0[2]/RM_IHPSG13_1P_BITKIT_16x2_SRAM_3[1]/A_RWL<12> RM_IHPSG13_1P_COLUMN_256_0[2]/RM_IHPSG13_1P_BITKIT_16x2_SRAM_0[0]/A_RWL<2>
+ RM_IHPSG13_1P_COLUMN_256_0[2]/RM_IHPSG13_1P_BITKIT_16x2_SRAM_0[3]/A_RWL<14> RM_IHPSG13_1P_COLUMN_256_0[2]/RM_IHPSG13_1P_BITKIT_16x2_SRAM_3[0]/A_RWL<10>
+ RM_IHPSG13_1P_COLUMN_256_0[2]/RM_IHPSG13_1P_BITKIT_16x2_SRAM_2[0]/A_RWL<3> RM_IHPSG13_1P_COLUMN_256_0[2]/RM_IHPSG13_1P_BITKIT_16x2_SRAM_3[3]/A_RWL<8>
+ RM_IHPSG13_1P_COLUMN_256_0[2]/RM_IHPSG13_1P_BITKIT_16x2_SRAM_0[0]/A_RWL<6> RM_IHPSG13_1P_COLUMN_256_0[2]/RM_IHPSG13_1P_BITKIT_16x2_SRAM_3[3]/A_LWL<8>
+ RM_IHPSG13_1P_COLUMN_256_0[2]/RM_IHPSG13_1P_BITKIT_16x2_SRAM_2[0]/A_RWL<0> RM_IHPSG13_1P_COLUMN_256_0[2]/RM_IHPSG13_1P_BITKIT_16x2_SRAM_0[0]/A_LWL<1>
+ RM_IHPSG13_1P_COLUMN_256_0[2]/RM_IHPSG13_1P_BITKIT_16x2_SRAM_3[0]/A_RWL<4> RM_IHPSG13_1P_COLUMN_256_0[2]/RM_IHPSG13_1P_BITKIT_16x2_SRAM_2[0]/A_RWL<5>
+ RM_IHPSG13_1P_COLUMN_256_0[2]/RM_IHPSG13_1P_BITKIT_16x2_SRAM_3[3]/A_LWL<14> RM_IHPSG13_1P_COLUMN_256_0[2]/RM_IHPSG13_1P_BITKIT_16x2_SRAM_3[1]/A_LWL<11>
+ RM_IHPSG13_1P_COLUMN_256_0[2]/RM_IHPSG13_1P_BITKIT_16x2_SRAM_2[0]/A_LWL<0> RM_IHPSG13_1P_COLUMN_256_0[2]/RM_IHPSG13_1P_BITKIT_16x2_SRAM_3[2]/A_RWL<10>
+ RM_IHPSG13_1P_COLUMN_256_0[2]/RM_IHPSG13_1P_BITKIT_16x2_SRAM_1[3]/A_LWL<5> RM_IHPSG13_1P_COLUMN_256_0[2]/RM_IHPSG13_1P_BITKIT_16x2_SRAM_3[1]/A_LWL<14>
+ RM_IHPSG13_1P_COLUMN_256_0[2]/RM_IHPSG13_1P_BITKIT_16x2_SRAM_0[3]/A_LWL<7> RM_IHPSG13_1P_COLUMN_256_0[2]/RM_IHPSG13_1P_BITKIT_16x2_SRAM_1[2]/A_LWL<8>
+ RM_IHPSG13_1P_COLUMN_256_0[2]/RM_IHPSG13_1P_BITKIT_16x2_SRAM_3[3]/A_LWL<4> RM_IHPSG13_1P_COLUMN_256_0[2]/RM_IHPSG13_1P_BITKIT_16x2_SRAM_2[2]/A_LWL<7>
+ RM_IHPSG13_1P_COLUMN_256_0[2]/RM_IHPSG13_1P_BITKIT_16x2_SRAM_0[3]/A_RWL<13> RM_IHPSG13_1P_COLUMN_256_0[2]/RM_IHPSG13_1P_BITKIT_16x2_SRAM_1[0]/A_LWL<10>
+ RM_IHPSG13_1P_COLUMN_256_0[2]/RM_IHPSG13_1P_BITKIT_16x2_SRAM_3[0]/A_RWL<2> RM_IHPSG13_1P_COLUMN_256_0[2]/RM_IHPSG13_1P_BITKIT_16x2_SRAM_2[0]/A_RWL<6>
+ RM_IHPSG13_1P_COLUMN_256_0[2]/RM_IHPSG13_1P_BITKIT_16x2_SRAM_3[1]/A_RWL<14> RM_IHPSG13_1P_COLUMN_256_0[2]/RM_IHPSG13_1P_BITKIT_16x2_SRAM_1[3]/A_RWL<8>
+ RM_IHPSG13_1P_COLUMN_256_0[2]/RM_IHPSG13_1P_BITKIT_16x2_SRAM_0[0]/A_RWL<8> RM_IHPSG13_1P_COLUMN_256_0[2]/RM_IHPSG13_1P_BITKIT_16x2_SRAM_0[0]/A_RWL<0>
+ RM_IHPSG13_1P_COLUMN_256_0[2]/RM_IHPSG13_1P_BITKIT_16x2_SRAM_3[3]/A_RWL<6> RM_IHPSG13_1P_COLUMN_256_0[2]/RM_IHPSG13_1P_BITKIT_16x2_SRAM_2[1]/A_LWL<15>
+ RM_IHPSG13_1P_COLUMN_256_0[2]/RM_IHPSG13_1P_BITKIT_16x2_SRAM_2[3]/A_RWL<4> RM_IHPSG13_1P_COLUMN_256_0[2]/RM_IHPSG13_1P_BITKIT_16x2_SRAM_2[0]/A_RWL<7>
+ RM_IHPSG13_1P_COLUMN_256_0[2]/RM_IHPSG13_1P_BITKIT_16x2_SRAM_2[2]/A_LWL<9> RM_IHPSG13_1P_COLUMN_256_0[2]/RM_IHPSG13_1P_BITKIT_16x2_SRAM_2[2]/A_LWL<12>
+ RM_IHPSG13_1P_COLUMN_256_0[2]/RM_IHPSG13_1P_BITKIT_16x2_SRAM_0[1]/A_RWL<0> RM_IHPSG13_1P_COLUMN_256_0[2]/RM_IHPSG13_1P_BITKIT_16x2_SRAM_3[0]/A_LWL<1>
+ RM_IHPSG13_1P_COLUMN_256_0[2]/RM_IHPSG13_1P_BITKIT_16x2_SRAM_2[0]/A_RWL<11> RM_IHPSG13_1P_COLUMN_256_0[2]/RM_IHPSG13_1P_BITKIT_16x2_SRAM_2[0]/A_LWL<2>
+ RM_IHPSG13_1P_COLUMN_256_0[2]/RM_IHPSG13_1P_BITKIT_16x2_SRAM_3[2]/A_RWL<12> RM_IHPSG13_1P_COLUMN_256_0[2]/RM_IHPSG13_1P_BITKIT_16x2_SRAM_3[0]/A_LWL<14>
+ RM_IHPSG13_1P_COLUMN_256_0[2]/RM_IHPSG13_1P_BITKIT_16x2_SRAM_1[0]/A_LWL<3> RM_IHPSG13_1P_COLUMN_256_0[2]/RM_IHPSG13_1P_BITKIT_16x2_SRAM_0[0]/A_LWL<4>
+ RM_IHPSG13_1P_COLUMN_256_0[2]/RM_IHPSG13_1P_BITKIT_16x2_SRAM_0[2]/A_RWL<13> RM_IHPSG13_1P_COLUMN_256_0[2]/RM_IHPSG13_1P_BITKIT_16x2_SRAM_1[0]/A_RWL<9>
+ RM_IHPSG13_1P_COLUMN_256_0[2]/RM_IHPSG13_1P_BITKIT_16x2_SRAM_1[3]/A_LWL<8> RM_IHPSG13_1P_COLUMN_256_0[2]/RM_IHPSG13_1P_BITKIT_16x2_SRAM_3[1]/A_LWL<12>
+ RM_IHPSG13_1P_COLUMN_256_0[2]/RM_IHPSG13_1P_BITKIT_16x2_SRAM_0[0]/A_RWL<7> RM_IHPSG13_1P_COLUMN_256_0[2]/RM_IHPSG13_1P_BITKIT_16x2_SRAM_1[3]/A_RWL<6>
+ RM_IHPSG13_1P_COLUMN_256_0[2]/RM_IHPSG13_1P_BITKIT_16x2_SRAM_1[0]/A_LWL<4> RM_IHPSG13_1P_COLUMN_256_0[2]/RM_IHPSG13_1P_BITKIT_16x2_SRAM_0[0]/A_LWL<2>
+ RM_IHPSG13_1P_COLUMN_256_0[2]/RM_IHPSG13_1P_BITKIT_16x2_SRAM_3[0]/A_RWL<15> RM_IHPSG13_1P_COLUMN_256_0[2]/RM_IHPSG13_1P_BITKIT_16x2_SRAM_3[3]/A_RWL<10>
+ RM_IHPSG13_1P_COLUMN_256_0[2]/RM_IHPSG13_1P_BITKIT_16x2_SRAM_2[1]/A_RWL<0> RM_IHPSG13_1P_COLUMN_256_0[2]/RM_IHPSG13_1P_BITKIT_16x2_SRAM_1[0]/A_LWL<13>
+ RM_IHPSG13_1P_COLUMN_256_0[2]/RM_IHPSG13_1P_BITKIT_16x2_SRAM_1[0]/A_LWL<11> RM_IHPSG13_1P_COLUMN_256_0[2]/RM_IHPSG13_1P_BITKIT_16x2_SRAM_2[3]/A_LWL<10>
+ RM_IHPSG13_1P_COLUMN_256_0[2]/RM_IHPSG13_1P_BITKIT_16x2_SRAM_1[1]/A_LWL<10> RM_IHPSG13_1P_COLUMN_256_0[2]/RM_IHPSG13_1P_BITKIT_16x2_SRAM_0[1]/A_RWL<2>
+ RM_IHPSG13_1P_COLUMN_256_0[2]/RM_IHPSG13_1P_BITKIT_16x2_SRAM_3[0]/A_LWL<3> RM_IHPSG13_1P_COLUMN_256_0[2]/RM_IHPSG13_1P_BITKIT_16x2_SRAM_0[3]/A_LWL<1>
+ RM_IHPSG13_1P_COLUMN_256_0[2]/RM_IHPSG13_1P_BITKIT_16x2_SRAM_3[2]/A_RWL<14> RM_IHPSG13_1P_COLUMN_256_0[2]/RM_IHPSG13_1P_BITKIT_16x2_SRAM_2[3]/A_LWL<0>
+ RM_IHPSG13_1P_COLUMN_256_0[2]/RM_IHPSG13_1P_BITKIT_16x2_SRAM_1[0]/A_LWL<5> RM_IHPSG13_1P_COLUMN_256_0[2]/RM_IHPSG13_1P_BITKIT_16x2_SRAM_3[3]/A_RWL<11>
+ RM_IHPSG13_1P_COLUMN_256_0[2]/RM_IHPSG13_1P_BITKIT_16x2_SRAM_3[3]/A_LWL<6> RM_IHPSG13_1P_COLUMN_256_0[2]/RM_IHPSG13_1P_BITKIT_16x2_SRAM_0[0]/A_LWL<6>
+ RM_IHPSG13_1P_COLUMN_256_0[2]/RM_IHPSG13_1P_BITKIT_16x2_SRAM_3[0]/A_RWL<9> RM_IHPSG13_1P_COLUMN_256_0[2]/RM_IHPSG13_1P_BITKIT_16x2_SRAM_2[3]/A_LWL<9>
+ RM_IHPSG13_1P_COLUMN_256_0[2]/RM_IHPSG13_1P_BITKIT_16x2_SRAM_1[0]/A_LWL<14> RM_IHPSG13_1P_COLUMN_256_0[2]/RM_IHPSG13_1P_BITKIT_16x2_SRAM_2[0]/A_RWL<13>
+ RM_IHPSG13_1P_COLUMN_256_0[2]/RM_IHPSG13_1P_BITKIT_16x2_SRAM_2[2]/A_LWL<15> RM_IHPSG13_1P_COLUMN_256_0[2]/RM_IHPSG13_1P_BITKIT_16x2_SRAM_1[1]/A_LWL<11>
+ RM_IHPSG13_1P_COLUMN_256_0[2]/RM_IHPSG13_1P_BITKIT_16x2_SRAM_3[0]/A_LWL<4> RM_IHPSG13_1P_COLUMN_256_0[2]/RM_IHPSG13_1P_BITKIT_16x2_SRAM_3[0]/A_RWL<8>
+ RM_IHPSG13_1P_COLUMN_256_0[2]/RM_IHPSG13_1P_BITKIT_16x2_SRAM_2[3]/A_LWL<12> RM_IHPSG13_1P_COLUMN_256_0[2]/RM_IHPSG13_1P_BITKIT_16x2_SRAM_2[0]/A_LWL<5>
+ RM_IHPSG13_1P_COLUMN_256_0[2]/RM_IHPSG13_1P_BITKIT_16x2_SRAM_1[1]/A_RWL<1> RM_IHPSG13_1P_COLUMN_256_0[2]/RM_IHPSG13_1P_BITKIT_16x2_SRAM_2[1]/A_RWL<11>
+ RM_IHPSG13_1P_COLUMN_256_0[2]/RM_IHPSG13_1P_BITKIT_16x2_SRAM_3[1]/A_RWL<1> RM_IHPSG13_1P_COLUMN_256_0[2]/RM_IHPSG13_1P_BITKIT_16x2_SRAM_3[0]/A_RWL<1>
+ RM_IHPSG13_1P_COLUMN_256_0[2]/RM_IHPSG13_1P_BITKIT_16x2_SRAM_3[3]/A_RWL<12> RM_IHPSG13_1P_COLUMN_256_0[2]/RM_IHPSG13_1P_BITKIT_16x2_SRAM_2[1]/A_RWL<2>
+ RM_IHPSG13_1P_COLUMN_256_0[2]/RM_IHPSG13_1P_BITKIT_16x2_SRAM_1[1]/A_RWL<3> RM_IHPSG13_1P_COLUMN_256_0[2]/RM_IHPSG13_1P_BITKIT_16x2_SRAM_3[3]/A_LWL<1>
+ RM_IHPSG13_1P_COLUMN_256_0[2]/RM_IHPSG13_1P_BITKIT_16x2_SRAM_2[2]/A_LWL<10> RM_IHPSG13_1P_COLUMN_256_0[2]/RM_IHPSG13_1P_BITKIT_16x2_SRAM_3[2]/A_LWL<12>
+ RM_IHPSG13_1P_COLUMN_256_0[2]/RM_IHPSG13_1P_BITKIT_16x2_SRAM_2[0]/A_RWL<15> RM_IHPSG13_1P_COLUMN_256_0[2]/RM_IHPSG13_1P_BITKIT_16x2_SRAM_2[0]/A_LWL<6>
+ RM_IHPSG13_1P_COLUMN_256_0[2]/RM_IHPSG13_1P_BITKIT_16x2_SRAM_3[2]/A_RWL<11> RM_IHPSG13_1P_COLUMN_256_0[2]/RM_IHPSG13_1P_BITKIT_16x2_SRAM_3[1]/A_RWL<15>
+ RM_IHPSG13_1P_COLUMN_256_0[2]/RM_IHPSG13_1P_BITKIT_16x2_SRAM_0[0]/A_LWL<7> RM_IHPSG13_1P_COLUMN_256_0[2]/RM_IHPSG13_1P_BITKIT_16x2_SRAM_1[3]/A_LWL<6>
+ RM_IHPSG13_1P_COLUMN_256_0[2]/RM_IHPSG13_1P_BITKIT_16x2_SRAM_3[1]/A_RWL<2> RM_IHPSG13_1P_COLUMN_256_0[2]/RM_IHPSG13_1P_BITKIT_16x2_SRAM_2[1]/A_RWL<3>
+ RM_IHPSG13_1P_COLUMN_256_0[2]/RM_IHPSG13_1P_BITKIT_16x2_SRAM_2[3]/A_LWL<3> RM_IHPSG13_1P_COLUMN_256_0[2]/RM_IHPSG13_1P_BITKIT_16x2_SRAM_1[1]/A_RWL<4>
+ RM_IHPSG13_1P_COLUMN_256_0[2]/RM_IHPSG13_1P_BITKIT_16x2_SRAM_0[0]/A_LWL<0> RM_IHPSG13_1P_COLUMN_256_0[2]/RM_IHPSG13_1P_BITKIT_16x2_SRAM_1[1]/A_LWL<13>
+ RM_IHPSG13_1P_COLUMN_256_0[2]/RM_IHPSG13_1P_BITKIT_16x2_SRAM_1[0]/A_RWL<8> RM_IHPSG13_1P_COLUMN_256_0[2]/RM_IHPSG13_1P_BITKIT_16x2_SRAM_0[1]/A_RWL<5>
+ RM_IHPSG13_1P_COLUMN_256_0[2]/RM_IHPSG13_1P_BITKIT_16x2_SRAM_2[3]/A_RWL<9> RM_IHPSG13_1P_COLUMN_256_0[2]/RM_IHPSG13_1P_BITKIT_16x2_SRAM_2[0]/A_LWL<7>
+ RM_IHPSG13_1P_COLUMN_256_0[2]/RM_IHPSG13_1P_BITKIT_16x2_SRAM_1[2]/A_LWL<10> RM_IHPSG13_1P_COLUMN_256_0[2]/RM_IHPSG13_1P_BITKIT_16x2_SRAM_1[0]/A_RWL<1>
+ RM_IHPSG13_1P_COLUMN_256_0[2]/RM_IHPSG13_1P_BITKIT_16x2_SRAM_2[1]/A_RWL<13> RM_IHPSG13_1P_COLUMN_256_0[2]/RM_IHPSG13_1P_BITKIT_16x2_SRAM_3[0]/A_RWL<6>
+ RM_IHPSG13_1P_COLUMN_256_0[2]/RM_IHPSG13_1P_BITKIT_16x2_SRAM_1[0]/A_LWL<8> RM_IHPSG13_1P_COLUMN_256_0[2]/RM_IHPSG13_1P_BITKIT_16x2_SRAM_0[2]/A_RWL<15>
+ RM_IHPSG13_1P_COLUMN_256_0[2]/RM_IHPSG13_1P_BITKIT_16x2_SRAM_3[3]/A_LWL<15> RM_IHPSG13_1P_COLUMN_256_0[2]/RM_IHPSG13_1P_BITKIT_16x2_SRAM_0[1]/A_RWL<4>
+ RM_IHPSG13_1P_COLUMN_256_0[2]/RM_IHPSG13_1P_BITKIT_16x2_SRAM_3[3]/A_RWL<14> RM_IHPSG13_1P_COLUMN_256_0[2]/RM_IHPSG13_1P_BITKIT_16x2_SRAM_0[0]/A_LWL<9>
+ RM_IHPSG13_1P_COLUMN_256_0[2]/RM_IHPSG13_1P_BITKIT_16x2_SRAM_2[1]/A_RWL<4> RM_IHPSG13_1P_COLUMN_256_0[2]/RM_IHPSG13_1P_BITKIT_16x2_SRAM_2[0]/A_RWL<4>
+ RM_IHPSG13_1P_COLUMN_256_0[2]/RM_IHPSG13_1P_BITKIT_16x2_SRAM_3[3]/A_RWL<5> RM_IHPSG13_1P_COLUMN_256_0[2]/RM_IHPSG13_1P_BITKIT_16x2_SRAM_2[1]/A_LWL<10>
+ RM_IHPSG13_1P_COLUMN_256_0[2]/RM_IHPSG13_1P_BITKIT_16x2_SRAM_1[1]/A_LWL<14> RM_IHPSG13_1P_COLUMN_256_0[2]/RM_IHPSG13_1P_BITKIT_16x2_SRAM_0[1]/A_RWL<6>
+ RM_IHPSG13_1P_COLUMN_256_0[2]/RM_IHPSG13_1P_BITKIT_16x2_SRAM_2[3]/A_LWL<15> RM_IHPSG13_1P_COLUMN_256_0[2]/RM_IHPSG13_1P_BITKIT_16x2_SRAM_2[0]/A_LWL<8>
+ RM_IHPSG13_1P_COLUMN_256_0[2]/RM_IHPSG13_1P_BITKIT_16x2_SRAM_3[1]/A_RWL<11> RM_IHPSG13_1P_COLUMN_256_0[2]/RM_IHPSG13_1P_BITKIT_16x2_SRAM_1[2]/A_LWL<11>
+ RM_IHPSG13_1P_COLUMN_256_0[2]/RM_IHPSG13_1P_BITKIT_16x2_SRAM_0[1]/A_LWL<1> RM_IHPSG13_1P_COLUMN_256_0[2]/RM_IHPSG13_1P_BITKIT_16x2_SRAM_1[0]/A_RWL<10>
+ RM_IHPSG13_1P_COLUMN_256_0[2]/RM_IHPSG13_1P_BITKIT_16x2_SRAM_1[0]/A_LWL<1> RM_IHPSG13_1P_COLUMN_256_0[2]/RM_IHPSG13_1P_BITKIT_16x2_SRAM_0[3]/A_LWL<3>
+ RM_IHPSG13_1P_COLUMN_256_0[2]/RM_IHPSG13_1P_BITKIT_16x2_SRAM_2[1]/A_RWL<5> RM_IHPSG13_1P_COLUMN_256_0[2]/RM_IHPSG13_1P_BITKIT_16x2_SRAM_3[0]/A_LWL<0>
+ RM_IHPSG13_1P_COLUMN_256_0[2]/RM_IHPSG13_1P_BITKIT_16x2_SRAM_2[2]/A_RWL<11> RM_IHPSG13_1P_COLUMN_256_0[2]/RM_IHPSG13_1P_BITKIT_16x2_SRAM_3[3]/A_LWL<12>
+ RM_IHPSG13_1P_COLUMN_256_0[2]/RM_IHPSG13_1P_BITKIT_16x2_SRAM_1[1]/A_RWL<6> RM_IHPSG13_1P_COLUMN_256_0[2]/RM_IHPSG13_1P_BITKIT_16x2_SRAM_0[3]/A_RWL<9>
+ RM_IHPSG13_1P_COLUMN_256_0[2]/RM_IHPSG13_1P_BITKIT_16x2_SRAM_2[1]/A_LWL<0> RM_IHPSG13_1P_COLUMN_256_0[2]/RM_IHPSG13_1P_BITKIT_16x2_SRAM_0[1]/A_RWL<7>
+ RM_IHPSG13_1P_COLUMN_256_0[2]/RM_IHPSG13_1P_BITKIT_16x2_SRAM_3[2]/A_RWL<15> RM_IHPSG13_1P_COLUMN_256_0[2]/RM_IHPSG13_1P_BITKIT_16x2_SRAM_2[0]/A_LWL<9>
+ RM_IHPSG13_1P_COLUMN_256_0[2]/RM_IHPSG13_1P_BITKIT_16x2_SRAM_1[0]/A_RWL<6> RM_IHPSG13_1P_COLUMN_256_0[2]/RM_IHPSG13_1P_BITKIT_16x2_SRAM_2[1]/A_RWL<15>
+ RM_IHPSG13_1P_COLUMN_256_0[2]/RM_IHPSG13_1P_BITKIT_16x2_SRAM_0[1]/A_LWL<2> RM_IHPSG13_1P_COLUMN_256_0[2]/RM_IHPSG13_1P_BITKIT_16x2_SRAM_3[2]/A_LWL<15>
+ RM_IHPSG13_1P_COLUMN_256_0[2]/RM_IHPSG13_1P_BITKIT_16x2_SRAM_0[0]/A_RWL<4> RM_IHPSG13_1P_COLUMN_256_0[2]/RM_IHPSG13_1P_BITKIT_16x2_SRAM_1[3]/A_RWL<5>
+ RM_IHPSG13_1P_COLUMN_256_0[2]/RM_IHPSG13_1P_BITKIT_16x2_SRAM_0[1]/A_LWL<0> RM_IHPSG13_1P_COLUMN_256_0[2]/RM_IHPSG13_1P_BITKIT_16x2_SRAM_2[0]/A_LWL<10>
+ RM_IHPSG13_1P_COLUMN_256_0[2]/RM_IHPSG13_1P_BITKIT_16x2_SRAM_3[0]/A_LWL<9> RM_IHPSG13_1P_COLUMN_256_0[2]/RM_IHPSG13_1P_BITKIT_16x2_SRAM_0[0]/A_LWL<12>
+ RM_IHPSG13_1P_COLUMN_256_0[2]/RM_IHPSG13_1P_BITKIT_16x2_SRAM_0[0]/A_RWL<3> RM_IHPSG13_1P_COLUMN_256_0[2]/RM_IHPSG13_1P_BITKIT_16x2_SRAM_0[3]/A_RWL<15>
+ RM_IHPSG13_1P_COLUMN_256_0[2]/RM_IHPSG13_1P_BITKIT_16x2_SRAM_3[0]/A_RWL<11> RM_IHPSG13_1P_COLUMN_256_0[2]/RM_IHPSG13_1P_BITKIT_16x2_SRAM_1[2]/A_LWL<13>
+ RM_IHPSG13_1P_COLUMN_256_0[2]/RM_IHPSG13_1P_BITKIT_16x2_SRAM_1[0]/A_RWL<12> RM_IHPSG13_1P_COLUMN_256_0[2]/RM_IHPSG13_1P_BITKIT_16x2_SRAM_3[1]/A_RWL<6>
+ RM_IHPSG13_1P_COLUMN_256_0[2]/RM_IHPSG13_1P_BITKIT_16x2_SRAM_3[0]/A_LWL<6> RM_IHPSG13_1P_COLUMN_256_0[2]/RM_IHPSG13_1P_BITKIT_16x2_SRAM_2[1]/A_RWL<7>
+ RM_IHPSG13_1P_COLUMN_256_0[2]/RM_IHPSG13_1P_BITKIT_16x2_SRAM_2[2]/A_RWL<13> RM_IHPSG13_1P_COLUMN_256_0[2]/RM_IHPSG13_1P_BITKIT_16x2_SRAM_0[2]/A_RWL<0>
+ RM_IHPSG13_1P_COLUMN_256_0[2]/RM_IHPSG13_1P_BITKIT_16x2_SRAM_3[1]/A_LWL<1> RM_IHPSG13_1P_COLUMN_256_0[2]/RM_IHPSG13_1P_BITKIT_16x2_SRAM_1[1]/A_RWL<8>
+ RM_IHPSG13_1P_COLUMN_256_0[2]/RM_IHPSG13_1P_BITKIT_16x2_SRAM_2[1]/A_LWL<2> RM_IHPSG13_1P_COLUMN_256_0[2]/RM_IHPSG13_1P_BITKIT_16x2_SRAM_1[1]/A_LWL<3>
+ RM_IHPSG13_1P_COLUMN_256_0[2]/RM_IHPSG13_1P_BITKIT_16x2_SRAM_1[1]/A_LWL<1> RM_IHPSG13_1P_COLUMN_256_0[2]/RM_IHPSG13_1P_BITKIT_16x2_SRAM_1[2]/A_LWL<14>
+ RM_IHPSG13_1P_COLUMN_256_0[2]/RM_IHPSG13_1P_BITKIT_16x2_SRAM_1[0]/A_LWL<12> RM_IHPSG13_1P_COLUMN_256_0[2]/RM_IHPSG13_1P_BITKIT_16x2_SRAM_0[1]/A_LWL<10>
+ RM_IHPSG13_1P_COLUMN_256_0[2]/RM_IHPSG13_1P_BITKIT_16x2_SRAM_0[1]/A_LWL<4> RM_IHPSG13_1P_COLUMN_256_0[2]/RM_IHPSG13_1P_BITKIT_16x2_SRAM_1[3]/A_LWL<4>
+ RM_IHPSG13_1P_COLUMN_256_0[2]/RM_IHPSG13_1P_BITKIT_16x2_SRAM_3[1]/A_LWL<0> RM_IHPSG13_1P_COLUMN_256_0[2]/RM_IHPSG13_1P_BITKIT_16x2_SRAM_3[1]/A_LWL<15>
+ RM_IHPSG13_1P_COLUMN_256_0[2]/RM_IHPSG13_1P_BITKIT_16x2_SRAM_1[3]/A_LWL<11> RM_IHPSG13_1P_COLUMN_256_0[2]/RM_IHPSG13_1P_BITKIT_16x2_SRAM_1[0]/A_RWL<2>
+ RM_IHPSG13_1P_COLUMN_256_0[2]/RM_IHPSG13_1P_BITKIT_16x2_SRAM_1[1]/A_RWL<10> RM_IHPSG13_1P_COLUMN_256_0[2]/RM_IHPSG13_1P_BITKIT_16x2_SRAM_3[1]/A_RWL<5>
+ RM_IHPSG13_1P_COLUMN_256_0[2]/RM_IHPSG13_1P_BITKIT_16x2_SRAM_0[0]/A_LWL<10> RM_IHPSG13_1P_COLUMN_256_0[2]/RM_IHPSG13_1P_BITKIT_16x2_SRAM_0[3]/A_RWL<12>
+ RM_IHPSG13_1P_COLUMN_256_0[2]/RM_IHPSG13_1P_BITKIT_16x2_SRAM_3[0]/A_RWL<3> RM_IHPSG13_1P_COLUMN_256_0[2]/RM_IHPSG13_1P_BITKIT_16x2_SRAM_1[1]/A_RWL<9>
+ RM_IHPSG13_1P_COLUMN_256_0[2]/RM_IHPSG13_1P_BITKIT_16x2_SRAM_3[3]/A_RWL<15> RM_IHPSG13_1P_COLUMN_256_0[2]/RM_IHPSG13_1P_BITKIT_16x2_SRAM_2[2]/A_RWL<12>
+ RM_IHPSG13_1P_COLUMN_256_0[2]/RM_IHPSG13_1P_BITKIT_16x2_SRAM_2[1]/A_LWL<3> RM_IHPSG13_1P_COLUMN_256_0[2]/RM_IHPSG13_1P_BITKIT_16x2_SRAM_1[0]/A_RWL<11>
+ RM_IHPSG13_1P_COLUMN_256_0[2]/RM_IHPSG13_1P_BITKIT_16x2_SRAM_2[3]/A_RWL<10> RM_IHPSG13_1P_COLUMN_256_0[2]/RM_IHPSG13_1P_BITKIT_16x2_SRAM_1[1]/A_LWL<4>
+ RM_IHPSG13_1P_COLUMN_256_0[2]/RM_IHPSG13_1P_BITKIT_16x2_SRAM_1[2]/A_LWL<15> RM_IHPSG13_1P_COLUMN_256_0[2]/RM_IHPSG13_1P_BITKIT_16x2_SRAM_2[2]/A_RWL<0>
+ RM_IHPSG13_1P_COLUMN_256_0[2]/RM_IHPSG13_1P_BITKIT_16x2_SRAM_1[0]/A_LWL<6> RM_IHPSG13_1P_COLUMN_256_0[2]/RM_IHPSG13_1P_BITKIT_16x2_SRAM_1[0]/A_RWL<14>
+ RM_IHPSG13_1P_COLUMN_256_0[2]/RM_IHPSG13_1P_BITKIT_16x2_SRAM_3[1]/A_RWL<8> RM_IHPSG13_1P_COLUMN_256_0[2]/RM_IHPSG13_1P_BITKIT_16x2_SRAM_3[3]/A_RWL<7>
+ RM_IHPSG13_1P_COLUMN_256_0[2]/RM_IHPSG13_1P_BITKIT_16x2_SRAM_1[2]/A_RWL<1> RM_IHPSG13_1P_COLUMN_256_0[2]/RM_IHPSG13_1P_BITKIT_16x2_SRAM_0[1]/A_LWL<3>
+ RM_IHPSG13_1P_COLUMN_256_0[2]/RM_IHPSG13_1P_BITKIT_16x2_SRAM_2[1]/A_RWL<9> RM_IHPSG13_1P_COLUMN_256_0[2]/RM_IHPSG13_1P_BITKIT_16x2_SRAM_2[2]/A_RWL<15>
+ RM_IHPSG13_1P_COLUMN_256_0[2]/RM_IHPSG13_1P_BITKIT_16x2_SRAM_1[1]/A_RWL<11> RM_IHPSG13_1P_COLUMN_256_0[2]/RM_IHPSG13_1P_BITKIT_16x2_SRAM_2[0]/A_LWL<3>
+ RM_IHPSG13_1P_COLUMN_256_0[2]/RM_IHPSG13_1P_BITKIT_16x2_SRAM_0[2]/A_RWL<2> RM_IHPSG13_1P_COLUMN_256_0[2]/RM_IHPSG13_1P_BITKIT_16x2_SRAM_3[1]/A_LWL<3>
+ RM_IHPSG13_1P_COLUMN_256_0[2]/RM_IHPSG13_1P_BITKIT_16x2_SRAM_0[2]/A_LWL<9> RM_IHPSG13_1P_COLUMN_256_0[2]/RM_IHPSG13_1P_BITKIT_16x2_SRAM_2[0]/A_LWL<13>
+ RM_IHPSG13_1P_COLUMN_256_0[2]/RM_IHPSG13_1P_BITKIT_16x2_SRAM_3[3]/A_LWL<2> RM_IHPSG13_1P_COLUMN_256_0[2]/RM_IHPSG13_1P_BITKIT_16x2_SRAM_0[1]/A_RWL<3>
+ RM_IHPSG13_1P_COLUMN_256_0[2]/RM_IHPSG13_1P_BITKIT_16x2_SRAM_0[1]/A_RWL<9> RM_IHPSG13_1P_COLUMN_256_0[2]/RM_IHPSG13_1P_BITKIT_16x2_SRAM_2[3]/A_RWL<12>
+ RM_IHPSG13_1P_COLUMN_256_0[2]/RM_IHPSG13_1P_BITKIT_16x2_SRAM_2[3]/A_LWL<5> RM_IHPSG13_1P_COLUMN_256_0[2]/RM_IHPSG13_1P_BITKIT_16x2_SRAM_2[2]/A_LWL<8>
+ RM_IHPSG13_1P_COLUMN_256_0[2]/RM_IHPSG13_1P_BITKIT_16x2_SRAM_0[0]/A_LWL<15> RM_IHPSG13_1P_COLUMN_256_0[2]/RM_IHPSG13_1P_BITKIT_16x2_SRAM_2[0]/A_RWL<9>
+ RM_IHPSG13_1P_COLUMN_256_0[2]/RM_IHPSG13_1P_BITKIT_16x2_SRAM_1[1]/A_LWL<5> RM_IHPSG13_1P_COLUMN_256_0[2]/RM_IHPSG13_1P_BITKIT_16x2_SRAM_3[2]/A_RWL<0>
+ RM_IHPSG13_1P_COLUMN_256_0[2]/RM_IHPSG13_1P_BITKIT_16x2_SRAM_1[1]/A_LWL<15> RM_IHPSG13_1P_COLUMN_256_0[2]/RM_IHPSG13_1P_BITKIT_16x2_SRAM_0[1]/A_LWL<12>
+ RM_IHPSG13_1P_COLUMN_256_0[2]/RM_IHPSG13_1P_BITKIT_16x2_SRAM_0[1]/A_LWL<6> RM_IHPSG13_1P_COLUMN_256_0[2]/RM_IHPSG13_1P_BITKIT_16x2_SRAM_3[0]/A_LWL<15>
+ RM_IHPSG13_1P_COLUMN_256_0[2]/RM_IHPSG13_1P_BITKIT_16x2_SRAM_3[1]/A_RWL<9> RM_IHPSG13_1P_COLUMN_256_0[2]/RM_IHPSG13_1P_BITKIT_16x2_SRAM_1[3]/A_LWL<13>
+ RM_IHPSG13_1P_COLUMN_256_0[2]/RM_IHPSG13_1P_BITKIT_16x2_SRAM_1[1]/A_RWL<5> RM_IHPSG13_1P_COLUMN_256_0[2]/RM_IHPSG13_1P_BITKIT_16x2_SRAM_1[1]/A_RWL<12>
+ RM_IHPSG13_1P_COLUMN_256_0[2]/RM_IHPSG13_1P_BITKIT_16x2_SRAM_3[0]/A_RWL<5> RM_IHPSG13_1P_COLUMN_256_0[2]/RM_IHPSG13_1P_BITKIT_16x2_SRAM_3[1]/A_LWL<4>
+ RM_IHPSG13_1P_COLUMN_256_0[2]/RM_IHPSG13_1P_BITKIT_16x2_SRAM_2[3]/A_RWL<13> RM_IHPSG13_1P_COLUMN_256_0[2]/RM_IHPSG13_1P_BITKIT_16x2_SRAM_2[1]/A_RWL<12>
+ RM_IHPSG13_1P_COLUMN_256_0[2]/RM_IHPSG13_1P_BITKIT_16x2_SRAM_2[1]/A_LWL<5> RM_IHPSG13_1P_COLUMN_256_0[2]/RM_IHPSG13_1P_BITKIT_16x2_SRAM_0[3]/A_RWL<10>
+ RM_IHPSG13_1P_COLUMN_256_0[2]/RM_IHPSG13_1P_BITKIT_16x2_SRAM_1[1]/A_LWL<12> RM_IHPSG13_1P_COLUMN_256_0[2]/RM_IHPSG13_1P_BITKIT_16x2_SRAM_2[2]/A_RWL<10>
+ RM_IHPSG13_1P_COLUMN_256_0[2]/RM_IHPSG13_1P_BITKIT_16x2_SRAM_1[1]/A_LWL<6> RM_IHPSG13_1P_COLUMN_256_0[2]/RM_IHPSG13_1P_BITKIT_16x2_SRAM_3[2]/A_RWL<1>
+ RM_IHPSG13_1P_COLUMN_256_0[2]/RM_IHPSG13_1P_BITKIT_16x2_SRAM_0[1]/A_LWL<13> RM_IHPSG13_1P_COLUMN_256_0[2]/RM_IHPSG13_1P_BITKIT_16x2_SRAM_1[3]/A_RWL<7>
+ RM_IHPSG13_1P_COLUMN_256_0[2]/RM_IHPSG13_1P_BITKIT_16x2_SRAM_0[1]/A_LWL<7> RM_IHPSG13_1P_COLUMN_256_0[2]/RM_IHPSG13_1P_BITKIT_16x2_SRAM_2[2]/A_RWL<2>
+ RM_IHPSG13_1P_COLUMN_256_0[2]/RM_IHPSG13_1P_BITKIT_16x2_SRAM_1[1]/A_RWL<2> RM_IHPSG13_1P_COLUMN_256_0[2]/RM_IHPSG13_1P_BITKIT_16x2_SRAM_1[2]/A_RWL<0>
+ RM_IHPSG13_1P_COLUMN_256_0[2]/RM_IHPSG13_1P_BITKIT_16x2_SRAM_1[0]/A_RWL<15> RM_IHPSG13_1P_COLUMN_256_0[2]/RM_IHPSG13_1P_BITKIT_16x2_SRAM_3[2]/A_LWL<9>
+ RM_IHPSG13_1P_COLUMN_256_0[2]/RM_IHPSG13_1P_BITKIT_16x2_SRAM_1[3]/A_LWL<14> RM_IHPSG13_1P_COLUMN_256_0[2]/RM_IHPSG13_1P_BITKIT_16x2_SRAM_3[1]/A_RWL<0>
+ RM_IHPSG13_1P_COLUMN_256_0[2]/RM_IHPSG13_1P_BITKIT_16x2_SRAM_3[1]/A_RWL<3> RM_IHPSG13_1P_COLUMN_256_0[2]/RM_IHPSG13_1P_BITKIT_16x2_SRAM_0[0]/A_LWL<3>
+ RM_IHPSG13_1P_COLUMN_256_0[2]/RM_IHPSG13_1P_BITKIT_16x2_SRAM_1[2]/A_RWL<3> RM_IHPSG13_1P_COLUMN_256_0[2]/RM_IHPSG13_1P_BITKIT_16x2_SRAM_0[2]/A_LWL<10>
+ RM_IHPSG13_1P_COLUMN_256_0[2]/RM_IHPSG13_1P_BITKIT_16x2_SRAM_1[3]/A_LWL<2> RM_IHPSG13_1P_COLUMN_256_0[2]/RM_IHPSG13_1P_BITKIT_16x2_SRAM_0[2]/A_RWL<4>
+ RM_IHPSG13_1P_COLUMN_256_0[2]/RM_IHPSG13_1P_BITKIT_16x2_SRAM_0[0]/A_RWL<9> RM_IHPSG13_1P_COLUMN_256_0[2]/RM_IHPSG13_1P_BITKIT_16x2_SRAM_2[1]/A_LWL<6>
+ RM_IHPSG13_1P_COLUMN_256_0[2]/RM_IHPSG13_1P_BITKIT_16x2_SRAM_1[2]/A_RWL<10> RM_IHPSG13_1P_COLUMN_256_0[2]/RM_IHPSG13_1P_BITKIT_16x2_SRAM_2[3]/A_LWL<11>
+ RM_IHPSG13_1P_COLUMN_256_0[2]/RM_IHPSG13_1P_BITKIT_16x2_SRAM_3[2]/A_RWL<2> RM_IHPSG13_1P_COLUMN_256_0[2]/RM_IHPSG13_1P_BITKIT_16x2_SRAM_1[0]/A_LWL<15>
+ RM_IHPSG13_1P_COLUMN_256_0[2]/RM_IHPSG13_1P_BITKIT_16x2_SRAM_0[3]/A_LWL<0> RM_IHPSG13_1P_COLUMN_256_0[2]/RM_IHPSG13_1P_BITKIT_16x2_SRAM_2[3]/A_LWL<14>
+ RM_IHPSG13_1P_COLUMN_256_0[2]/RM_IHPSG13_1P_BITKIT_16x2_SRAM_2[2]/A_RWL<3> RM_IHPSG13_1P_COLUMN_256_0[2]/RM_IHPSG13_1P_BITKIT_16x2_SRAM_0[0]/A_LWL<5>
+ RM_IHPSG13_1P_COLUMN_256_0[2]/RM_IHPSG13_1P_BITKIT_16x2_SRAM_1[3]/A_LWL<15> RM_IHPSG13_1P_COLUMN_256_0[2]/RM_IHPSG13_1P_BITKIT_16x2_SRAM_1[0]/A_RWL<5>
+ RM_IHPSG13_1P_COLUMN_256_0[2]/RM_IHPSG13_1P_BITKIT_16x2_SRAM_2[1]/A_LWL<13> RM_IHPSG13_1P_COLUMN_256_0[2]/RM_IHPSG13_1P_BITKIT_16x2_SRAM_0[3]/A_LWL<9>
+ RM_IHPSG13_1P_COLUMN_256_0[2]/RM_IHPSG13_1P_BITKIT_16x2_SRAM_0[2]/A_RWL<3> RM_IHPSG13_1P_COLUMN_256_0[2]/RM_IHPSG13_1P_BITKIT_16x2_SRAM_3[3]/A_LWL<7>
+ RM_IHPSG13_1P_COLUMN_256_0[2]/RM_IHPSG13_1P_BITKIT_16x2_SRAM_2[0]/A_LWL<4> RM_IHPSG13_1P_COLUMN_256_0[2]/RM_IHPSG13_1P_BITKIT_16x2_SRAM_1[1]/A_RWL<14>
+ RM_IHPSG13_1P_COLUMN_256_0[2]/RM_IHPSG13_1P_BITKIT_16x2_SRAM_0[2]/A_RWL<5> RM_IHPSG13_1P_COLUMN_256_0[2]/RM_IHPSG13_1P_BITKIT_16x2_SRAM_2[3]/A_LWL<8>
+ RM_IHPSG13_1P_COLUMN_256_0[2]/RM_IHPSG13_1P_BITKIT_16x2_SRAM_3[1]/A_LWL<6> RM_IHPSG13_1P_COLUMN_256_0[2]/RM_IHPSG13_1P_BITKIT_16x2_SRAM_2[0]/A_RWL<12>
+ RM_IHPSG13_1P_COLUMN_256_0[2]/RM_IHPSG13_1P_BITKIT_16x2_SRAM_2[3]/A_RWL<15> RM_IHPSG13_1P_COLUMN_256_0[2]/RM_IHPSG13_1P_BITKIT_16x2_SRAM_1[2]/A_RWL<11>
+ RM_IHPSG13_1P_COLUMN_256_0[2]/RM_IHPSG13_1P_BITKIT_16x2_SRAM_2[1]/A_LWL<7> RM_IHPSG13_1P_COLUMN_256_0[2]/RM_IHPSG13_1P_BITKIT_16x2_SRAM_2[0]/A_RWL<14>
+ RM_IHPSG13_1P_COLUMN_256_0[2]/RM_IHPSG13_1P_BITKIT_16x2_SRAM_3[3]/A_RWL<13> RM_IHPSG13_1P_COLUMN_256_0[2]/RM_IHPSG13_1P_BITKIT_16x2_SRAM_0[2]/A_LWL<0>
+ RM_IHPSG13_1P_COLUMN_256_0[2]/RM_IHPSG13_1P_BITKIT_16x2_SRAM_2[1]/A_RWL<10> RM_IHPSG13_1P_COLUMN_256_0[2]/RM_IHPSG13_1P_BITKIT_16x2_SRAM_1[1]/A_LWL<8>
+ RM_IHPSG13_1P_COLUMN_256_0[2]/RM_IHPSG13_1P_BITKIT_16x2_SRAM_0[1]/A_LWL<15> RM_IHPSG13_1P_COLUMN_256_0[2]/RM_IHPSG13_1P_BITKIT_16x2_SRAM_0[1]/A_LWL<9>
+ RM_IHPSG13_1P_COLUMN_256_0[2]/RM_IHPSG13_1P_BITKIT_16x2_SRAM_2[2]/A_RWL<4> RM_IHPSG13_1P_COLUMN_256_0[2]/RM_IHPSG13_1P_BITKIT_16x2_SRAM_1[1]/A_RWL<0>
+ RM_IHPSG13_1P_COLUMN_256_0[2]/RM_IHPSG13_1P_BITKIT_16x2_SRAM_3[1]/A_RWL<7> RM_IHPSG13_1P_COLUMN_256_0[2]/RM_IHPSG13_1P_BITKIT_16x2_SRAM_3[0]/A_RWL<0>
+ RM_IHPSG13_1P_COLUMN_256_0[2]/RM_IHPSG13_1P_BITKIT_16x2_SRAM_1[2]/A_RWL<5> RM_IHPSG13_1P_COLUMN_256_0[2]/RM_IHPSG13_1P_BITKIT_16x2_SRAM_0[2]/A_LWL<12>
+ RM_IHPSG13_1P_COLUMN_256_0[2]/RM_IHPSG13_1P_BITKIT_16x2_SRAM_0[0]/A_RWL<11> RM_IHPSG13_1P_COLUMN_256_0[2]/RM_IHPSG13_1P_BITKIT_16x2_SRAM_1[3]/A_LWL<1>
+ RM_IHPSG13_1P_COLUMN_256_0[2]/RM_IHPSG13_1P_BITKIT_16x2_SRAM_3[1]/A_LWL<2> RM_IHPSG13_1P_COLUMN_256_0[2]/RM_IHPSG13_1P_BITKIT_16x2_SRAM_1[2]/A_LWL<12>
+ RM_IHPSG13_1P_COLUMN_256_0[2]/RM_IHPSG13_1P_BITKIT_16x2_SRAM_1[2]/A_LWL<0> RM_IHPSG13_1P_COLUMN_256_0[2]/RM_IHPSG13_1P_BITKIT_16x2_SRAM_3[3]/A_LWL<0>
+ RM_IHPSG13_1P_COLUMN_256_0[2]/RM_IHPSG13_1P_BITKIT_16x2_SRAM_1[2]/A_RWL<12> RM_IHPSG13_1P_COLUMN_256_0[2]/RM_IHPSG13_1P_BITKIT_16x2_SRAM_2[1]/A_LWL<8>
+ RM_IHPSG13_1P_COLUMN_256_0[2]/RM_IHPSG13_1P_BITKIT_16x2_SRAM_2[2]/A_LWL<11> RM_IHPSG13_1P_COLUMN_256_0[2]/RM_IHPSG13_1P_BITKIT_16x2_SRAM_0[2]/A_LWL<1>
+ RM_IHPSG13_1P_COLUMN_256_0[2]/RM_IHPSG13_1P_BITKIT_16x2_SRAM_1[2]/A_RWL<2> RM_IHPSG13_1P_COLUMN_256_0[2]/RM_IHPSG13_1P_BITKIT_16x2_SRAM_3[0]/A_LWL<5>
+ RM_IHPSG13_1P_COLUMN_256_0[2]/RM_IHPSG13_1P_BITKIT_16x2_SRAM_1[1]/A_RWL<15> RM_IHPSG13_1P_COLUMN_256_0[2]/RM_IHPSG13_1P_BITKIT_16x2_SRAM_3[3]/A_LWL<9>
+ RM_IHPSG13_1P_COLUMN_256_0[2]/RM_IHPSG13_1P_BITKIT_16x2_SRAM_2[2]/A_LWL<14> RM_IHPSG13_1P_COLUMN_256_0[2]/RM_IHPSG13_1P_BITKIT_16x2_SRAM_3[2]/A_RWL<3>
+ RM_IHPSG13_1P_COLUMN_256_0[2]/RM_IHPSG13_1P_BITKIT_16x2_SRAM_2[2]/A_RWL<5> RM_IHPSG13_1P_COLUMN_256_0[2]/RM_IHPSG13_1P_BITKIT_16x2_SRAM_1[3]/A_LWL<7>
+ RM_IHPSG13_1P_COLUMN_256_0[2]/RM_IHPSG13_1P_BITKIT_16x2_SRAM_1[2]/A_RWL<6> RM_IHPSG13_1P_COLUMN_256_0[2]/RM_IHPSG13_1P_BITKIT_16x2_SRAM_0[2]/A_LWL<13>
+ RM_IHPSG13_1P_COLUMN_256_0[2]/RM_IHPSG13_1P_BITKIT_16x2_SRAM_3[2]/A_LWL<7> RM_IHPSG13_1P_COLUMN_256_0[2]/RM_IHPSG13_1P_BITKIT_16x2_SRAM_2[2]/A_LWL<0>
+ RM_IHPSG13_1P_COLUMN_256_0[2]/RM_IHPSG13_1P_BITKIT_16x2_SRAM_0[0]/A_RWL<12> RM_IHPSG13_1P_COLUMN_256_0[2]/RM_IHPSG13_1P_BITKIT_16x2_SRAM_0[2]/A_RWL<7>
+ RM_IHPSG13_1P_COLUMN_256_0[2]/RM_IHPSG13_1P_BITKIT_16x2_SRAM_0[3]/A_LWL<10> RM_IHPSG13_1P_COLUMN_256_0[2]/RM_IHPSG13_1P_BITKIT_16x2_SRAM_1[2]/A_LWL<1>
+ RM_IHPSG13_1P_COLUMN_256_0[2]/RM_IHPSG13_1P_BITKIT_16x2_SRAM_3[2]/A_RWL<13> RM_IHPSG13_1P_COLUMN_256_0[2]/RM_IHPSG13_1P_BITKIT_16x2_SRAM_2[1]/A_LWL<9>
+ RM_IHPSG13_1P_COLUMN_256_0[2]/RM_IHPSG13_1P_BITKIT_16x2_SRAM_2[0]/A_RWL<10> RM_IHPSG13_1P_COLUMN_256_0[2]/RM_IHPSG13_1P_BITKIT_16x2_SRAM_0[2]/A_LWL<2>
+ RM_IHPSG13_1P_COLUMN_256_0[2]/RM_IHPSG13_1P_BITKIT_16x2_SRAM_2[3]/A_RWL<8> RM_IHPSG13_1P_COLUMN_256_0[2]/RM_IHPSG13_1P_BITKIT_16x2_SRAM_3[2]/A_RWL<5>
+ RM_IHPSG13_1P_COLUMN_256_0[2]/RM_IHPSG13_1P_BITKIT_16x2_SRAM_1[3]/A_RWL<10> RM_IHPSG13_1P_COLUMN_256_0[2]/RM_IHPSG13_1P_BITKIT_16x2_SRAM_0[1]/A_LWL<5>
+ RM_IHPSG13_1P_COLUMN_256_0[2]/RM_IHPSG13_1P_BITKIT_16x2_SRAM_0[0]/A_LWL<8> RM_IHPSG13_1P_COLUMN_256_0[2]/RM_IHPSG13_1P_BITKIT_16x2_SRAM_1[1]/A_RWL<7>
+ RM_IHPSG13_1P_COLUMN_256_0[2]/RM_IHPSG13_1P_BITKIT_16x2_SRAM_2[2]/A_LWL<13> RM_IHPSG13_1P_COLUMN_256_0[2]/RM_IHPSG13_1P_BITKIT_16x2_SRAM_1[0]/A_RWL<0>
+ RM_IHPSG13_1P_COLUMN_256_0[2]/RM_IHPSG13_1P_BITKIT_16x2_SRAM_2[1]/A_LWL<4> RM_IHPSG13_1P_COLUMN_256_0[2]/RM_IHPSG13_1P_BITKIT_16x2_SRAM_3[0]/A_RWL<7>
+ RM_IHPSG13_1P_COLUMN_256_0[2]/RM_IHPSG13_1P_BITKIT_16x2_SRAM_3[2]/A_LWL<0> RM_IHPSG13_1P_COLUMN_256_0[2]/RM_IHPSG13_1P_BITKIT_16x2_SRAM_1[2]/A_RWL<7>
+ RM_IHPSG13_1P_COLUMN_256_0[2]/RM_IHPSG13_1P_BITKIT_16x2_SRAM_1[1]/A_LWL<2> RM_IHPSG13_1P_COLUMN_256_0[2]/RM_IHPSG13_1P_BITKIT_16x2_SRAM_0[0]/A_RWL<13>
+ RM_IHPSG13_1P_COLUMN_256_0[2]/RM_IHPSG13_1P_BITKIT_16x2_SRAM_2[1]/A_RWL<14> RM_IHPSG13_1P_COLUMN_256_0[2]/RM_IHPSG13_1P_BITKIT_16x2_SRAM_2[2]/A_LWL<1>
+ RM_IHPSG13_1P_COLUMN_256_0[2]/RM_IHPSG13_1P_BITKIT_16x2_SRAM_3[1]/A_LWL<9> RM_IHPSG13_1P_COLUMN_256_0[2]/RM_IHPSG13_1P_BITKIT_16x2_SRAM_3[0]/A_LWL<2>
+ RM_IHPSG13_1P_COLUMN_256_0[2]/RM_IHPSG13_1P_BITKIT_16x2_SRAM_3[3]/A_RWL<4> RM_IHPSG13_1P_COLUMN_256_0[2]/RM_IHPSG13_1P_BITKIT_16x2_SRAM_0[2]/A_LWL<11>
+ RM_IHPSG13_1P_COLUMN_256_0[2]/RM_IHPSG13_1P_BITKIT_16x2_SRAM_0[3]/A_LWL<11> RM_IHPSG13_1P_COLUMN_256_0[2]/RM_IHPSG13_1P_BITKIT_16x2_SRAM_1[2]/A_LWL<2>
+ RM_IHPSG13_1P_COLUMN_256_0[2]/RM_IHPSG13_1P_BITKIT_16x2_SRAM_1[2]/A_RWL<14> RM_IHPSG13_1P_COLUMN_256_0[2]/RM_IHPSG13_1P_BITKIT_16x2_SRAM_2[1]/A_LWL<11>
+ RM_IHPSG13_1P_COLUMN_256_0[2]/RM_IHPSG13_1P_BITKIT_16x2_SRAM_0[1]/A_RWL<10> RM_IHPSG13_1P_COLUMN_256_0[2]/RM_IHPSG13_1P_BITKIT_16x2_SRAM_0[2]/A_LWL<3>
+ RM_IHPSG13_1P_COLUMN_256_0[2]/RM_IHPSG13_1P_BITKIT_16x2_SRAM_0[2]/A_LWL<14> RM_IHPSG13_1P_COLUMN_256_0[2]/RM_IHPSG13_1P_BITKIT_16x2_SRAM_3[2]/A_RWL<6>
+ RM_IHPSG13_1P_COLUMN_256_0[2]/RM_IHPSG13_1P_BITKIT_16x2_SRAM_1[3]/A_RWL<11> RM_IHPSG13_1P_COLUMN_256_0[2]/RM_IHPSG13_1P_BITKIT_16x2_SRAM_2[1]/A_LWL<14>
+ RM_IHPSG13_1P_COLUMN_256_0[2]/RM_IHPSG13_1P_BITKIT_16x2_SRAM_2[2]/A_RWL<7> RM_IHPSG13_1P_COLUMN_256_0[2]/RM_IHPSG13_1P_BITKIT_16x2_SRAM_0[3]/A_RWL<0>
+ RM_IHPSG13_1P_COLUMN_256_0[2]/RM_IHPSG13_1P_BITKIT_16x2_SRAM_1[0]/A_LWL<0> RM_IHPSG13_1P_COLUMN_256_0[2]/RM_IHPSG13_1P_BITKIT_16x2_SRAM_1[2]/A_RWL<8>
+ RM_IHPSG13_1P_COLUMN_256_0[2]/RM_IHPSG13_1P_BITKIT_16x2_SRAM_3[2]/A_LWL<1> RM_IHPSG13_1P_COLUMN_256_0[2]/RM_IHPSG13_1P_BITKIT_16x2_SRAM_0[2]/A_LWL<15>
+ RM_IHPSG13_1P_COLUMN_256_0[2]/RM_IHPSG13_1P_BITKIT_16x2_SRAM_1[3]/A_LWL<12> RM_IHPSG13_1P_COLUMN_256_0[2]/RM_IHPSG13_1P_BITKIT_16x2_SRAM_3[1]/A_LWL<7>
+ RM_IHPSG13_1P_COLUMN_256_0[2]/RM_IHPSG13_1P_BITKIT_16x2_SRAM_0[2]/A_RWL<9> RM_IHPSG13_1P_COLUMN_256_0[2]/RM_IHPSG13_1P_BITKIT_16x2_SRAM_0[0]/A_RWL<14>
+ RM_IHPSG13_1P_COLUMN_256_0[2]/RM_IHPSG13_1P_BITKIT_16x2_SRAM_2[2]/A_LWL<2> RM_IHPSG13_1P_COLUMN_256_0[2]/RM_IHPSG13_1P_BITKIT_16x2_SRAM_1[2]/A_RWL<13>
+ RM_IHPSG13_1P_COLUMN_256_0[2]/RM_IHPSG13_1P_BITKIT_16x2_SRAM_1[0]/A_LWL<9> RM_IHPSG13_1P_COLUMN_256_0[2]/RM_IHPSG13_1P_BITKIT_16x2_SRAM_0[3]/A_LWL<12>
+ RM_IHPSG13_1P_COLUMN_256_0[2]/RM_IHPSG13_1P_BITKIT_16x2_SRAM_1[2]/A_LWL<3> RM_IHPSG13_1P_COLUMN_256_0[2]/RM_IHPSG13_1P_BITKIT_16x2_SRAM_3[1]/A_RWL<13>
+ RM_IHPSG13_1P_COLUMN_256_0[2]/RM_IHPSG13_1P_BITKIT_16x2_SRAM_3[1]/A_LWL<5> RM_IHPSG13_1P_COLUMN_256_0[2]/RM_IHPSG13_1P_BITKIT_16x2_SRAM_0[0]/A_RWL<10>
+ RM_IHPSG13_1P_COLUMN_256_0[2]/RM_IHPSG13_1P_BITKIT_16x2_SRAM_0[3]/A_RWL<8> RM_IHPSG13_1P_COLUMN_256_0[2]/RM_IHPSG13_1P_BITKIT_16x2_SRAM_1[2]/A_RWL<15>
+ RM_IHPSG13_1P_COLUMN_256_0[2]/RM_IHPSG13_1P_BITKIT_16x2_SRAM_3[0]/A_LWL<8> RM_IHPSG13_1P_COLUMN_256_0[2]/RM_IHPSG13_1P_BITKIT_16x2_SRAM_0[1]/A_RWL<11>
+ RM_IHPSG13_1P_COLUMN_256_0[2]/RM_IHPSG13_1P_BITKIT_16x2_SRAM_3[3]/A_RWL<3> RM_IHPSG13_1P_COLUMN_256_0[2]/RM_IHPSG13_1P_BITKIT_16x2_SRAM_0[2]/A_LWL<4>
+ RM_IHPSG13_1P_COLUMN_256_0[2]/RM_IHPSG13_1P_BITKIT_16x2_SRAM_3[2]/A_RWL<7> RM_IHPSG13_1P_COLUMN_256_0[2]/RM_IHPSG13_1P_BITKIT_16x2_SRAM_1[3]/A_RWL<12>
+ RM_IHPSG13_1P_COLUMN_256_0[2]/RM_IHPSG13_1P_BITKIT_16x2_SRAM_1[0]/A_RWL<7> RM_IHPSG13_1P_COLUMN_256_0[2]/RM_IHPSG13_1P_BITKIT_16x2_SRAM_1[3]/A_RWL<0>
+ RM_IHPSG13_1P_COLUMN_256_0[2]/RM_IHPSG13_1P_BITKIT_16x2_SRAM_2[2]/A_RWL<8> RM_IHPSG13_1P_COLUMN_256_0[2]/RM_IHPSG13_1P_BITKIT_16x2_SRAM_2[3]/A_RWL<6>
+ RM_IHPSG13_1P_COLUMN_256_0[2]/RM_IHPSG13_1P_BITKIT_16x2_SRAM_2[2]/A_RWL<1> RM_IHPSG13_1P_COLUMN_256_0[2]/RM_IHPSG13_1P_BITKIT_16x2_SRAM_0[3]/A_RWL<1>
+ RM_IHPSG13_1P_COLUMN_256_0[2]/RM_IHPSG13_1P_BITKIT_16x2_SRAM_3[2]/A_LWL<2> RM_IHPSG13_1P_COLUMN_256_0[2]/RM_IHPSG13_1P_BITKIT_16x2_SRAM_1[2]/A_RWL<9>
+ RM_IHPSG13_1P_COLUMN_256_0[2]/RM_IHPSG13_1P_BITKIT_16x2_SRAM_1[0]/A_LWL<2> RM_IHPSG13_1P_COLUMN_256_0[2]/RM_IHPSG13_1P_BITKIT_16x2_SRAM_2[2]/A_LWL<3>
+ RM_IHPSG13_1P_COLUMN_256_0[2]/RM_IHPSG13_1P_BITKIT_16x2_SRAM_0[0]/A_RWL<15> RM_IHPSG13_1P_COLUMN_256_0[2]/RM_IHPSG13_1P_BITKIT_16x2_SRAM_0[1]/A_LWL<11>
+ RM_IHPSG13_1P_COLUMN_256_0[2]/RM_IHPSG13_1P_BITKIT_16x2_SRAM_3[2]/A_RWL<4> RM_IHPSG13_1P_COLUMN_256_0[2]/RM_IHPSG13_1P_BITKIT_16x2_SRAM_0[3]/A_LWL<13>
+ RM_IHPSG13_1P_COLUMN_256_0[2]/RM_IHPSG13_1P_BITKIT_16x2_SRAM_1[2]/A_LWL<4> RM_IHPSG13_1P_COLUMN_256_0[2]/RM_IHPSG13_1P_BITKIT_16x2_SRAM_2[0]/A_LWL<11>
+ RM_IHPSG13_1P_COLUMN_256_0[2]/RM_IHPSG13_1P_BITKIT_16x2_SRAM_0[1]/A_RWL<12> RM_IHPSG13_1P_COLUMN_256_0[2]/RM_IHPSG13_1P_BITKIT_16x2_SRAM_3[3]/A_LWL<10>
+ RM_IHPSG13_1P_COLUMN_256_0[2]/RM_IHPSG13_1P_BITKIT_16x2_SRAM_2[0]/A_LWL<1> RM_IHPSG13_1P_COLUMN_256_0[2]/RM_IHPSG13_1P_BITKIT_16x2_SRAM_0[1]/A_LWL<8>
+ RM_IHPSG13_1P_COLUMN_256_0[2]/RM_IHPSG13_1P_BITKIT_16x2_SRAM_0[1]/A_LWL<14> RM_IHPSG13_1P_COLUMN_256_0[2]/RM_IHPSG13_1P_BITKIT_16x2_SRAM_0[2]/A_LWL<5>
+ RM_IHPSG13_1P_COLUMN_256_0[2]/RM_IHPSG13_1P_BITKIT_16x2_SRAM_2[3]/A_RWL<0> RM_IHPSG13_1P_COLUMN_256_0[2]/RM_IHPSG13_1P_BITKIT_16x2_SRAM_2[3]/A_LWL<13>
+ RM_IHPSG13_1P_COLUMN_256_0[2]/RM_IHPSG13_1P_BITKIT_16x2_SRAM_3[2]/A_RWL<8> RM_IHPSG13_1P_COLUMN_256_0[2]/RM_IHPSG13_1P_BITKIT_16x2_SRAM_1[3]/A_RWL<13>
+ RM_IHPSG13_1P_COLUMN_256_0[2]/RM_IHPSG13_1P_BITKIT_16x2_SRAM_2[0]/A_LWL<14> RM_IHPSG13_1P_COLUMN_256_0[2]/RM_IHPSG13_1P_BITKIT_16x2_SRAM_1[3]/A_RWL<1>
+ RM_IHPSG13_1P_COLUMN_256_0[2]/RM_IHPSG13_1P_BITKIT_16x2_SRAM_2[2]/A_RWL<9> RM_IHPSG13_1P_COLUMN_256_0[2]/RM_IHPSG13_1P_BITKIT_16x2_SRAM_1[1]/A_LWL<7>
+ RM_IHPSG13_1P_COLUMN_256_0[2]/RM_IHPSG13_1P_BITKIT_16x2_SRAM_2[2]/A_RWL<14> RM_IHPSG13_1P_COLUMN_256_0[2]/RM_IHPSG13_1P_BITKIT_16x2_SRAM_0[3]/A_RWL<2>
+ RM_IHPSG13_1P_COLUMN_256_0[2]/RM_IHPSG13_1P_BITKIT_16x2_SRAM_3[2]/A_LWL<3> RM_IHPSG13_1P_COLUMN_256_0[2]/RM_IHPSG13_1P_BITKIT_16x2_SRAM_3[0]/A_LWL<7>
+ RM_IHPSG13_1P_COLUMN_256_0[2]/RM_IHPSG13_1P_BITKIT_16x2_SRAM_2[2]/A_LWL<4> RM_IHPSG13_1P_COLUMN_256_0[2]/RM_IHPSG13_1P_BITKIT_16x2_SRAM_1[1]/A_RWL<13>
+ RM_IHPSG13_1P_COLUMN_256_0[2]/RM_IHPSG13_1P_BITKIT_16x2_SRAM_0[3]/A_LWL<14> RM_IHPSG13_1P_COLUMN_256_0[2]/RM_IHPSG13_1P_BITKIT_16x2_SRAM_3[0]/A_RWL<13>
+ RM_IHPSG13_1P_COLUMN_256_0[2]/RM_IHPSG13_1P_BITKIT_16x2_SRAM_1[2]/A_LWL<5> RM_IHPSG13_1P_COLUMN_256_0[2]/RM_IHPSG13_1P_BITKIT_16x2_SRAM_3[3]/A_RWL<0>
+ RM_IHPSG13_1P_COLUMN_256_0[2]/RM_IHPSG13_1P_BITKIT_16x2_SRAM_0[2]/A_RWL<8> RM_IHPSG13_1P_COLUMN_256_0[2]/RM_IHPSG13_1P_BITKIT_16x2_SRAM_0[1]/A_RWL<13>
+ RM_IHPSG13_1P_COLUMN_256_0[2]/RM_IHPSG13_1P_BITKIT_16x2_SRAM_3[0]/A_LWL<10> RM_IHPSG13_1P_COLUMN_256_0[2]/RM_IHPSG13_1P_BITKIT_16x2_SRAM_2[1]/A_RWL<8>
+ RM_IHPSG13_1P_COLUMN_256_0[2]/RM_IHPSG13_1P_BITKIT_16x2_SRAM_0[2]/A_LWL<6> RM_IHPSG13_1P_COLUMN_256_0[2]/RM_IHPSG13_1P_BITKIT_16x2_SRAM_2[3]/A_RWL<1>
+ RM_IHPSG13_1P_COLUMN_256_0[2]/RM_IHPSG13_1P_BITKIT_16x2_SRAM_3[2]/A_RWL<9> RM_IHPSG13_1P_COLUMN_256_0[2]/RM_IHPSG13_1P_BITKIT_16x2_SRAM_0[3]/A_RWL<6>
+ RM_IHPSG13_1P_COLUMN_256_0[2]/RM_IHPSG13_1P_BITKIT_16x2_SRAM_1[3]/A_RWL<14> RM_IHPSG13_1P_COLUMN_256_0[2]/RM_IHPSG13_1P_BITKIT_16x2_SRAM_0[2]/A_RWL<1>
+ RM_IHPSG13_1P_COLUMN_256_0[2]/RM_IHPSG13_1P_BITKIT_16x2_SRAM_1[1]/A_LWL<0> RM_IHPSG13_1P_COLUMN_256_0[2]/RM_IHPSG13_1P_BITKIT_16x2_SRAM_0[2]/A_RWL<10>
+ RM_IHPSG13_1P_COLUMN_256_0[2]/RM_IHPSG13_1P_BITKIT_16x2_SRAM_1[3]/A_RWL<2> RM_IHPSG13_1P_COLUMN_256_0[2]/RM_IHPSG13_1P_BITKIT_16x2_SRAM_2[2]/A_RWL<6>
+ RM_IHPSG13_1P_COLUMN_256_0[2]/RM_IHPSG13_1P_BITKIT_16x2_SRAM_2[1]/A_RWL<1> RM_IHPSG13_1P_COLUMN_256_0[2]/RM_IHPSG13_1P_BITKIT_16x2_SRAM_0[3]/A_RWL<3>
+ RM_IHPSG13_1P_COLUMN_256_0[2]/RM_IHPSG13_1P_BITKIT_16x2_SRAM_3[2]/A_LWL<4> RM_IHPSG13_1P_COLUMN_256_0[2]/RM_IHPSG13_1P_BITKIT_16x2_SRAM_1[1]/A_LWL<9>
+ RM_IHPSG13_1P_COLUMN_256_0[2]/RM_IHPSG13_1P_BITKIT_16x2_SRAM_1[2]/A_RWL<4> RM_IHPSG13_1P_COLUMN_256_0[2]/RM_IHPSG13_1P_BITKIT_16x2_SRAM_1[0]/A_RWL<3>
+ RM_IHPSG13_1P_COLUMN_256_0[2]/RM_IHPSG13_1P_BITKIT_16x2_SRAM_2[2]/A_LWL<5> RM_IHPSG13_1P_COLUMN_256_0[2]/RM_IHPSG13_1P_BITKIT_16x2_SRAM_3[1]/A_LWL<8>
+ RM_IHPSG13_1P_COLUMN_256_0[2]/RM_IHPSG13_1P_BITKIT_16x2_SRAM_0[0]/A_LWL<11> RM_IHPSG13_1P_COLUMN_256_0[2]/RM_IHPSG13_1P_BITKIT_16x2_SRAM_3[1]/A_RWL<4>
+ RM_IHPSG13_1P_COLUMN_256_0[2]/RM_IHPSG13_1P_BITKIT_16x2_SRAM_0[3]/A_LWL<15> RM_IHPSG13_1P_COLUMN_256_0[2]/RM_IHPSG13_1P_BITKIT_16x2_SRAM_1[3]/A_LWL<10>
+ RM_IHPSG13_1P_COLUMN_256_0[2]/RM_IHPSG13_1P_BITKIT_16x2_SRAM_1[2]/A_LWL<6> RM_IHPSG13_1P_COLUMN_256_0[2]/RM_IHPSG13_1P_BITKIT_16x2_SRAM_3[3]/A_RWL<1>
+ RM_IHPSG13_1P_COLUMN_256_0[2]/RM_IHPSG13_1P_BITKIT_16x2_SRAM_0[1]/A_RWL<14> RM_IHPSG13_1P_COLUMN_256_0[2]/RM_IHPSG13_1P_BITKIT_16x2_SRAM_3[2]/A_LWL<10>
+ RM_IHPSG13_1P_COLUMN_256_0[2]/RM_IHPSG13_1P_BITKIT_16x2_SRAM_3[0]/A_LWL<11> RM_IHPSG13_1P_COLUMN_256_0[2]/RM_IHPSG13_1P_BITKIT_16x2_SRAM_0[0]/A_LWL<14>
+ RM_IHPSG13_1P_COLUMN_256_0[2]/RM_IHPSG13_1P_BITKIT_16x2_SRAM_0[2]/A_LWL<7> RM_IHPSG13_1P_COLUMN_256_0[2]/RM_IHPSG13_1P_BITKIT_16x2_SRAM_2[3]/A_RWL<2>
+ RM_IHPSG13_1P_COLUMN_256_0[2]/RM_IHPSG13_1P_BITKIT_16x2_SRAM_2[3]/A_RWL<11> RM_IHPSG13_1P_COLUMN_256_0[2]/RM_IHPSG13_1P_BITKIT_16x2_SRAM_1[3]/A_RWL<15>
+ RM_IHPSG13_1P_COLUMN_256_0[2]/RM_IHPSG13_1P_BITKIT_16x2_SRAM_0[2]/A_RWL<11> RM_IHPSG13_1P_COLUMN_256_0[2]/RM_IHPSG13_1P_BITKIT_16x2_SRAM_1[3]/A_RWL<3>
+ RM_IHPSG13_1P_COLUMN_256_0[2]/RM_IHPSG13_1P_BITKIT_16x2_SRAM_1[0]/A_LWL<7> RM_IHPSG13_1P_COLUMN_256_0[2]/RM_IHPSG13_1P_BITKIT_16x2_SRAM_0[3]/A_RWL<4>
+ RM_IHPSG13_1P_COLUMN_256_0[2]/RM_IHPSG13_1P_BITKIT_16x2_SRAM_2[3]/A_LWL<6> RM_IHPSG13_1P_COLUMN_256_0[2]/RM_IHPSG13_1P_BITKIT_16x2_SRAM_3[2]/A_LWL<5>
+ RM_IHPSG13_1P_COLUMN_256_0[2]/RM_IHPSG13_1P_BITKIT_16x2_SRAM_0[0]/A_LWL<13> RM_IHPSG13_1P_COLUMN_256_0[2]/RM_IHPSG13_1P_BITKIT_16x2_SRAM_2[2]/A_LWL<6>
+ RM_IHPSG13_1P_COLUMN_256_0[2]/RM_IHPSG13_1P_BITKIT_16x2_SRAM_1[0]/A_RWL<13> RM_IHPSG13_1P_COLUMN_256_0[2]/RM_IHPSG13_1P_BITKIT_16x2_SRAM_2[1]/A_LWL<1>
+ RM_IHPSG13_1P_COLUMN_256_0[2]/RM_IHPSG13_1P_BITKIT_16x2_SRAM_0[3]/A_LWL<5> RM_IHPSG13_1P_COLUMN_256_0[2]/RM_IHPSG13_1P_BITKIT_16x2_SRAM_2[0]/A_LWL<12>
+ RM_IHPSG13_1P_COLUMN_256_0[2]/RM_IHPSG13_1P_BITKIT_16x2_SRAM_3[3]/A_LWL<3> RM_IHPSG13_1P_COLUMN_256_0[2]/RM_IHPSG13_1P_BITKIT_16x2_SRAM_1[2]/A_LWL<7>
+ RM_IHPSG13_1P_COLUMN_256_0[2]/RM_IHPSG13_1P_BITKIT_16x2_SRAM_3[3]/A_RWL<2> RM_IHPSG13_1P_COLUMN_256_0[2]/RM_IHPSG13_1P_BITKIT_16x2_SRAM_0[1]/A_RWL<8>
+ RM_IHPSG13_1P_COLUMN_256_0[2]/RM_IHPSG13_1P_BITKIT_16x2_SRAM_2[3]/A_LWL<4> RM_IHPSG13_1P_COLUMN_256_0[2]/RM_IHPSG13_1P_BITKIT_16x2_SRAM_0[1]/A_RWL<15>
+ RM_IHPSG13_1P_COLUMN_256_0[2]/RM_IHPSG13_1P_BITKIT_16x2_SRAM_3[0]/A_LWL<12> RM_IHPSG13_1P_COLUMN_256_0[2]/RM_IHPSG13_1P_BITKIT_16x2_SRAM_2[0]/A_RWL<8>
+ RM_IHPSG13_1P_COLUMN_256_0[2]/RM_IHPSG13_1P_BITKIT_16x2_SRAM_0[2]/A_LWL<8> RM_IHPSG13_1P_COLUMN_256_0[2]/RM_IHPSG13_1P_BITKIT_16x2_SRAM_2[3]/A_RWL<3>
+ RM_IHPSG13_1P_COLUMN_256_0[2]/RM_IHPSG13_1P_BITKIT_16x2_SRAM_2[0]/A_RWL<2> RM_IHPSG13_1P_COLUMN_256_0[2]/RM_IHPSG13_1P_BITKIT_16x2_SRAM_3[3]/A_RWL<9>
+ RM_IHPSG13_1P_COLUMN_256_0[2]/RM_IHPSG13_1P_BITKIT_16x2_SRAM_0[2]/A_RWL<6> RM_IHPSG13_1P_COLUMN_256_0[2]/RM_IHPSG13_1P_BITKIT_16x2_SRAM_0[1]/A_RWL<1>
+ RM_IHPSG13_1P_COLUMN_256_0[2]/RM_IHPSG13_1P_BITKIT_16x2_SRAM_2[3]/A_RWL<14> RM_IHPSG13_1P_COLUMN_256_0[2]/RM_IHPSG13_1P_BITKIT_16x2_SRAM_0[2]/A_RWL<12>
+ RM_IHPSG13_1P_COLUMN_256_0[2]/RM_IHPSG13_1P_BITKIT_16x2_SRAM_1[3]/A_RWL<4> RM_IHPSG13_1P_COLUMN_256_0[2]/RM_IHPSG13_1P_BITKIT_16x2_SRAM_2[1]/A_RWL<6>
+ RM_IHPSG13_1P_COLUMN_256_0[2]/RM_IHPSG13_1P_BITKIT_16x2_SRAM_2[0]/A_RWL<1> RM_IHPSG13_1P_COLUMN_256_0[7]/RM_IHPSG13_1P_BITKIT_16x2_SRAM_3[3]/VSS
+ RM_IHPSG13_1P_COLUMN_256_0[7]/RM_IHPSG13_1P_BITKIT_16x2_SRAM_3[3]/VDD RM_IHPSG13_1P_COLUMN_256_0[2]/RM_IHPSG13_1P_BITKIT_16x2_SRAM_0[3]/A_RWL<5>
+ RM_IHPSG13_1P_COLUMN_256_0[2]/RM_IHPSG13_1P_BITKIT_16x2_SRAM_3[2]/A_LWL<6> RM_IHPSG13_1P_COLUMN_256
XRM_IHPSG13_1P_COLUMN_256_0[3] RM_IHPSG13_1P_COLUMN_256_0[3]/RM_IHPSG13_1P_BITKIT_16x2_SRAM_0[0]/A_BLT_BOT<0>
+ RM_IHPSG13_1P_COLUMN_256_0[3]/RM_IHPSG13_1P_BITKIT_16x2_SRAM_3[1]/A_LWL<10> RM_IHPSG13_1P_COLUMN_256_0[3]/RM_IHPSG13_1P_BITKIT_16x2_SRAM_3[0]/A_LWL<13>
+ RM_IHPSG13_1P_COLUMN_256_0[3]/RM_IHPSG13_1P_BITKIT_16x2_SRAM_0[0]/A_BLT_BOT<1> RM_IHPSG13_1P_COLUMN_256_0[3]/RM_IHPSG13_1P_BITKIT_16x2_SRAM_1[2]/A_LWL<9>
+ RM_IHPSG13_1P_COLUMN_256_0[3]/RM_IHPSG13_1P_BITKIT_16x2_SRAM_0[0]/A_BLC_BOT<0> RM_IHPSG13_1P_COLUMN_256_0[3]/RM_IHPSG13_1P_BITKIT_16x2_SRAM_3[2]/A_LWL<8>
+ RM_IHPSG13_1P_COLUMN_256_0[3]/RM_IHPSG13_1P_BITKIT_16x2_SRAM_0[3]/A_RWL<11> RM_IHPSG13_1P_COLUMN_256_0[3]/RM_IHPSG13_1P_BITKIT_16x2_SRAM_2[3]/A_RWL<5>
+ RM_IHPSG13_1P_COLUMN_256_0[3]/RM_IHPSG13_1P_BITKIT_16x2_SRAM_0[0]/A_BLC_BOT<1> RM_IHPSG13_1P_COLUMN_256_0[3]/RM_IHPSG13_1P_BITKIT_16x2_SRAM_1[3]/A_LWL<0>
+ RM_IHPSG13_1P_COLUMN_256_0[3]/RM_IHPSG13_1P_BITKIT_16x2_SRAM_3[1]/A_LWL<13> RM_IHPSG13_1P_COLUMN_256_0[3]/RM_IHPSG13_1P_BITKIT_16x2_SRAM_1[3]/A_LWL<3>
+ RM_IHPSG13_1P_COLUMN_256_0[3]/RM_IHPSG13_1P_BITKIT_16x2_SRAM_1[3]/A_RWL<9> RM_IHPSG13_1P_COLUMN_256_0[3]/RM_IHPSG13_1P_BITKIT_16x2_SRAM_2[3]/A_LWL<1>
+ RM_IHPSG13_1P_COLUMN_256_0[3]/RM_IHPSG13_1P_BITKIT_16x2_SRAM_0[0]/A_RWL<1> RM_IHPSG13_1P_COLUMN_256_0[3]/RM_IHPSG13_1P_BITKIT_16x2_SRAM_0[3]/A_LWL<6>
+ RM_IHPSG13_1P_COLUMN_256_0[3]/RM_IHPSG13_1P_BITKIT_16x2_SRAM_2[3]/A_RWL<7> RM_IHPSG13_1P_COLUMN_256_0[3]/RM_IHPSG13_1P_BITKIT_16x2_SRAM_3[2]/A_LWL<13>
+ RM_IHPSG13_1P_COLUMN_256_0[3]/RM_IHPSG13_1P_BITKIT_16x2_SRAM_2[3]/A_LWL<2> RM_IHPSG13_1P_COLUMN_256_0[3]/RM_IHPSG13_1P_BITKIT_16x2_SRAM_3[3]/A_LWL<5>
+ RM_IHPSG13_1P_COLUMN_256_0[3]/RM_IHPSG13_1P_BITKIT_16x2_SRAM_0[2]/A_RWL<14> RM_IHPSG13_1P_COLUMN_256_0[3]/RM_IHPSG13_1P_BITKIT_16x2_SRAM_0[3]/A_LWL<8>
+ RM_IHPSG13_1P_COLUMN_256_0[3]/RM_IHPSG13_1P_BITKIT_16x2_SRAM_3[3]/A_LWL<11> RM_IHPSG13_1P_COLUMN_256_0[3]/RM_IHPSG13_1P_BITKIT_16x2_SRAM_3[0]/A_RWL<12>
+ RM_IHPSG13_1P_COLUMN_256_0[3]/RM_IHPSG13_1P_BITKIT_16x2_SRAM_3[1]/A_RWL<10> RM_IHPSG13_1P_COLUMN_256_0[3]/RM_IHPSG13_1P_BITKIT_16x2_SRAM_0[3]/A_RWL<7>
+ RM_IHPSG13_1P_COLUMN_256_0[3]/RM_IHPSG13_1P_BITKIT_16x2_SRAM_0[3]/A_LWL<2> RM_IHPSG13_1P_COLUMN_256_0[3]/RM_IHPSG13_1P_BITKIT_16x2_SRAM_3[0]/A_RWL<14>
+ RM_IHPSG13_1P_COLUMN_256_0[3]/RM_IHPSG13_1P_BITKIT_16x2_SRAM_1[0]/A_RWL<4> RM_IHPSG13_1P_COLUMN_256_0[3]/RM_IHPSG13_1P_BITKIT_16x2_SRAM_3[2]/A_LWL<11>
+ RM_IHPSG13_1P_COLUMN_256_0[3]/RM_IHPSG13_1P_BITKIT_16x2_SRAM_3[2]/A_LWL<14> RM_IHPSG13_1P_COLUMN_256_0[3]/RM_IHPSG13_1P_BITKIT_16x2_SRAM_2[0]/A_LWL<15>
+ RM_IHPSG13_1P_COLUMN_256_0[3]/RM_IHPSG13_1P_BITKIT_16x2_SRAM_0[0]/A_RWL<5> RM_IHPSG13_1P_COLUMN_256_0[3]/RM_IHPSG13_1P_BITKIT_16x2_SRAM_2[3]/A_LWL<7>
+ RM_IHPSG13_1P_COLUMN_256_0[3]/RM_IHPSG13_1P_BITKIT_16x2_SRAM_1[3]/A_LWL<9> RM_IHPSG13_1P_COLUMN_256_0[3]/RM_IHPSG13_1P_BITKIT_16x2_SRAM_2[1]/A_LWL<12>
+ RM_IHPSG13_1P_COLUMN_256_0[3]/RM_IHPSG13_1P_BITKIT_16x2_SRAM_0[3]/A_LWL<4> RM_IHPSG13_1P_COLUMN_256_0[3]/RM_IHPSG13_1P_BITKIT_16x2_SRAM_3[3]/A_LWL<13>
+ RM_IHPSG13_1P_COLUMN_256_0[3]/RM_IHPSG13_1P_BITKIT_16x2_SRAM_3[1]/A_RWL<12> RM_IHPSG13_1P_COLUMN_256_0[3]/RM_IHPSG13_1P_BITKIT_16x2_SRAM_0[0]/A_RWL<2>
+ RM_IHPSG13_1P_COLUMN_256_0[3]/RM_IHPSG13_1P_BITKIT_16x2_SRAM_0[3]/A_RWL<14> RM_IHPSG13_1P_COLUMN_256_0[3]/RM_IHPSG13_1P_BITKIT_16x2_SRAM_3[0]/A_RWL<10>
+ RM_IHPSG13_1P_COLUMN_256_0[3]/RM_IHPSG13_1P_BITKIT_16x2_SRAM_2[0]/A_RWL<3> RM_IHPSG13_1P_COLUMN_256_0[3]/RM_IHPSG13_1P_BITKIT_16x2_SRAM_3[3]/A_RWL<8>
+ RM_IHPSG13_1P_COLUMN_256_0[3]/RM_IHPSG13_1P_BITKIT_16x2_SRAM_0[0]/A_RWL<6> RM_IHPSG13_1P_COLUMN_256_0[3]/RM_IHPSG13_1P_BITKIT_16x2_SRAM_3[3]/A_LWL<8>
+ RM_IHPSG13_1P_COLUMN_256_0[3]/RM_IHPSG13_1P_BITKIT_16x2_SRAM_2[0]/A_RWL<0> RM_IHPSG13_1P_COLUMN_256_0[3]/RM_IHPSG13_1P_BITKIT_16x2_SRAM_0[0]/A_LWL<1>
+ RM_IHPSG13_1P_COLUMN_256_0[3]/RM_IHPSG13_1P_BITKIT_16x2_SRAM_3[0]/A_RWL<4> RM_IHPSG13_1P_COLUMN_256_0[3]/RM_IHPSG13_1P_BITKIT_16x2_SRAM_2[0]/A_RWL<5>
+ RM_IHPSG13_1P_COLUMN_256_0[3]/RM_IHPSG13_1P_BITKIT_16x2_SRAM_3[3]/A_LWL<14> RM_IHPSG13_1P_COLUMN_256_0[3]/RM_IHPSG13_1P_BITKIT_16x2_SRAM_3[1]/A_LWL<11>
+ RM_IHPSG13_1P_COLUMN_256_0[3]/RM_IHPSG13_1P_BITKIT_16x2_SRAM_2[0]/A_LWL<0> RM_IHPSG13_1P_COLUMN_256_0[3]/RM_IHPSG13_1P_BITKIT_16x2_SRAM_3[2]/A_RWL<10>
+ RM_IHPSG13_1P_COLUMN_256_0[3]/RM_IHPSG13_1P_BITKIT_16x2_SRAM_1[3]/A_LWL<5> RM_IHPSG13_1P_COLUMN_256_0[3]/RM_IHPSG13_1P_BITKIT_16x2_SRAM_3[1]/A_LWL<14>
+ RM_IHPSG13_1P_COLUMN_256_0[3]/RM_IHPSG13_1P_BITKIT_16x2_SRAM_0[3]/A_LWL<7> RM_IHPSG13_1P_COLUMN_256_0[3]/RM_IHPSG13_1P_BITKIT_16x2_SRAM_1[2]/A_LWL<8>
+ RM_IHPSG13_1P_COLUMN_256_0[3]/RM_IHPSG13_1P_BITKIT_16x2_SRAM_3[3]/A_LWL<4> RM_IHPSG13_1P_COLUMN_256_0[3]/RM_IHPSG13_1P_BITKIT_16x2_SRAM_2[2]/A_LWL<7>
+ RM_IHPSG13_1P_COLUMN_256_0[3]/RM_IHPSG13_1P_BITKIT_16x2_SRAM_0[3]/A_RWL<13> RM_IHPSG13_1P_COLUMN_256_0[3]/RM_IHPSG13_1P_BITKIT_16x2_SRAM_1[0]/A_LWL<10>
+ RM_IHPSG13_1P_COLUMN_256_0[3]/RM_IHPSG13_1P_BITKIT_16x2_SRAM_3[0]/A_RWL<2> RM_IHPSG13_1P_COLUMN_256_0[3]/RM_IHPSG13_1P_BITKIT_16x2_SRAM_2[0]/A_RWL<6>
+ RM_IHPSG13_1P_COLUMN_256_0[3]/RM_IHPSG13_1P_BITKIT_16x2_SRAM_3[1]/A_RWL<14> RM_IHPSG13_1P_COLUMN_256_0[3]/RM_IHPSG13_1P_BITKIT_16x2_SRAM_1[3]/A_RWL<8>
+ RM_IHPSG13_1P_COLUMN_256_0[3]/RM_IHPSG13_1P_BITKIT_16x2_SRAM_0[0]/A_RWL<8> RM_IHPSG13_1P_COLUMN_256_0[3]/RM_IHPSG13_1P_BITKIT_16x2_SRAM_0[0]/A_RWL<0>
+ RM_IHPSG13_1P_COLUMN_256_0[3]/RM_IHPSG13_1P_BITKIT_16x2_SRAM_3[3]/A_RWL<6> RM_IHPSG13_1P_COLUMN_256_0[3]/RM_IHPSG13_1P_BITKIT_16x2_SRAM_2[1]/A_LWL<15>
+ RM_IHPSG13_1P_COLUMN_256_0[3]/RM_IHPSG13_1P_BITKIT_16x2_SRAM_2[3]/A_RWL<4> RM_IHPSG13_1P_COLUMN_256_0[3]/RM_IHPSG13_1P_BITKIT_16x2_SRAM_2[0]/A_RWL<7>
+ RM_IHPSG13_1P_COLUMN_256_0[3]/RM_IHPSG13_1P_BITKIT_16x2_SRAM_2[2]/A_LWL<9> RM_IHPSG13_1P_COLUMN_256_0[3]/RM_IHPSG13_1P_BITKIT_16x2_SRAM_2[2]/A_LWL<12>
+ RM_IHPSG13_1P_COLUMN_256_0[3]/RM_IHPSG13_1P_BITKIT_16x2_SRAM_0[1]/A_RWL<0> RM_IHPSG13_1P_COLUMN_256_0[3]/RM_IHPSG13_1P_BITKIT_16x2_SRAM_3[0]/A_LWL<1>
+ RM_IHPSG13_1P_COLUMN_256_0[3]/RM_IHPSG13_1P_BITKIT_16x2_SRAM_2[0]/A_RWL<11> RM_IHPSG13_1P_COLUMN_256_0[3]/RM_IHPSG13_1P_BITKIT_16x2_SRAM_2[0]/A_LWL<2>
+ RM_IHPSG13_1P_COLUMN_256_0[3]/RM_IHPSG13_1P_BITKIT_16x2_SRAM_3[2]/A_RWL<12> RM_IHPSG13_1P_COLUMN_256_0[3]/RM_IHPSG13_1P_BITKIT_16x2_SRAM_3[0]/A_LWL<14>
+ RM_IHPSG13_1P_COLUMN_256_0[3]/RM_IHPSG13_1P_BITKIT_16x2_SRAM_1[0]/A_LWL<3> RM_IHPSG13_1P_COLUMN_256_0[3]/RM_IHPSG13_1P_BITKIT_16x2_SRAM_0[0]/A_LWL<4>
+ RM_IHPSG13_1P_COLUMN_256_0[3]/RM_IHPSG13_1P_BITKIT_16x2_SRAM_0[2]/A_RWL<13> RM_IHPSG13_1P_COLUMN_256_0[3]/RM_IHPSG13_1P_BITKIT_16x2_SRAM_1[0]/A_RWL<9>
+ RM_IHPSG13_1P_COLUMN_256_0[3]/RM_IHPSG13_1P_BITKIT_16x2_SRAM_1[3]/A_LWL<8> RM_IHPSG13_1P_COLUMN_256_0[3]/RM_IHPSG13_1P_BITKIT_16x2_SRAM_3[1]/A_LWL<12>
+ RM_IHPSG13_1P_COLUMN_256_0[3]/RM_IHPSG13_1P_BITKIT_16x2_SRAM_0[0]/A_RWL<7> RM_IHPSG13_1P_COLUMN_256_0[3]/RM_IHPSG13_1P_BITKIT_16x2_SRAM_1[3]/A_RWL<6>
+ RM_IHPSG13_1P_COLUMN_256_0[3]/RM_IHPSG13_1P_BITKIT_16x2_SRAM_1[0]/A_LWL<4> RM_IHPSG13_1P_COLUMN_256_0[3]/RM_IHPSG13_1P_BITKIT_16x2_SRAM_0[0]/A_LWL<2>
+ RM_IHPSG13_1P_COLUMN_256_0[3]/RM_IHPSG13_1P_BITKIT_16x2_SRAM_3[0]/A_RWL<15> RM_IHPSG13_1P_COLUMN_256_0[3]/RM_IHPSG13_1P_BITKIT_16x2_SRAM_3[3]/A_RWL<10>
+ RM_IHPSG13_1P_COLUMN_256_0[3]/RM_IHPSG13_1P_BITKIT_16x2_SRAM_2[1]/A_RWL<0> RM_IHPSG13_1P_COLUMN_256_0[3]/RM_IHPSG13_1P_BITKIT_16x2_SRAM_1[0]/A_LWL<13>
+ RM_IHPSG13_1P_COLUMN_256_0[3]/RM_IHPSG13_1P_BITKIT_16x2_SRAM_1[0]/A_LWL<11> RM_IHPSG13_1P_COLUMN_256_0[3]/RM_IHPSG13_1P_BITKIT_16x2_SRAM_2[3]/A_LWL<10>
+ RM_IHPSG13_1P_COLUMN_256_0[3]/RM_IHPSG13_1P_BITKIT_16x2_SRAM_1[1]/A_LWL<10> RM_IHPSG13_1P_COLUMN_256_0[3]/RM_IHPSG13_1P_BITKIT_16x2_SRAM_0[1]/A_RWL<2>
+ RM_IHPSG13_1P_COLUMN_256_0[3]/RM_IHPSG13_1P_BITKIT_16x2_SRAM_3[0]/A_LWL<3> RM_IHPSG13_1P_COLUMN_256_0[3]/RM_IHPSG13_1P_BITKIT_16x2_SRAM_0[3]/A_LWL<1>
+ RM_IHPSG13_1P_COLUMN_256_0[3]/RM_IHPSG13_1P_BITKIT_16x2_SRAM_3[2]/A_RWL<14> RM_IHPSG13_1P_COLUMN_256_0[3]/RM_IHPSG13_1P_BITKIT_16x2_SRAM_2[3]/A_LWL<0>
+ RM_IHPSG13_1P_COLUMN_256_0[3]/RM_IHPSG13_1P_BITKIT_16x2_SRAM_1[0]/A_LWL<5> RM_IHPSG13_1P_COLUMN_256_0[3]/RM_IHPSG13_1P_BITKIT_16x2_SRAM_3[3]/A_RWL<11>
+ RM_IHPSG13_1P_COLUMN_256_0[3]/RM_IHPSG13_1P_BITKIT_16x2_SRAM_3[3]/A_LWL<6> RM_IHPSG13_1P_COLUMN_256_0[3]/RM_IHPSG13_1P_BITKIT_16x2_SRAM_0[0]/A_LWL<6>
+ RM_IHPSG13_1P_COLUMN_256_0[3]/RM_IHPSG13_1P_BITKIT_16x2_SRAM_3[0]/A_RWL<9> RM_IHPSG13_1P_COLUMN_256_0[3]/RM_IHPSG13_1P_BITKIT_16x2_SRAM_2[3]/A_LWL<9>
+ RM_IHPSG13_1P_COLUMN_256_0[3]/RM_IHPSG13_1P_BITKIT_16x2_SRAM_1[0]/A_LWL<14> RM_IHPSG13_1P_COLUMN_256_0[3]/RM_IHPSG13_1P_BITKIT_16x2_SRAM_2[0]/A_RWL<13>
+ RM_IHPSG13_1P_COLUMN_256_0[3]/RM_IHPSG13_1P_BITKIT_16x2_SRAM_2[2]/A_LWL<15> RM_IHPSG13_1P_COLUMN_256_0[3]/RM_IHPSG13_1P_BITKIT_16x2_SRAM_1[1]/A_LWL<11>
+ RM_IHPSG13_1P_COLUMN_256_0[3]/RM_IHPSG13_1P_BITKIT_16x2_SRAM_3[0]/A_LWL<4> RM_IHPSG13_1P_COLUMN_256_0[3]/RM_IHPSG13_1P_BITKIT_16x2_SRAM_3[0]/A_RWL<8>
+ RM_IHPSG13_1P_COLUMN_256_0[3]/RM_IHPSG13_1P_BITKIT_16x2_SRAM_2[3]/A_LWL<12> RM_IHPSG13_1P_COLUMN_256_0[3]/RM_IHPSG13_1P_BITKIT_16x2_SRAM_2[0]/A_LWL<5>
+ RM_IHPSG13_1P_COLUMN_256_0[3]/RM_IHPSG13_1P_BITKIT_16x2_SRAM_1[1]/A_RWL<1> RM_IHPSG13_1P_COLUMN_256_0[3]/RM_IHPSG13_1P_BITKIT_16x2_SRAM_2[1]/A_RWL<11>
+ RM_IHPSG13_1P_COLUMN_256_0[3]/RM_IHPSG13_1P_BITKIT_16x2_SRAM_3[1]/A_RWL<1> RM_IHPSG13_1P_COLUMN_256_0[3]/RM_IHPSG13_1P_BITKIT_16x2_SRAM_3[0]/A_RWL<1>
+ RM_IHPSG13_1P_COLUMN_256_0[3]/RM_IHPSG13_1P_BITKIT_16x2_SRAM_3[3]/A_RWL<12> RM_IHPSG13_1P_COLUMN_256_0[3]/RM_IHPSG13_1P_BITKIT_16x2_SRAM_2[1]/A_RWL<2>
+ RM_IHPSG13_1P_COLUMN_256_0[3]/RM_IHPSG13_1P_BITKIT_16x2_SRAM_1[1]/A_RWL<3> RM_IHPSG13_1P_COLUMN_256_0[3]/RM_IHPSG13_1P_BITKIT_16x2_SRAM_3[3]/A_LWL<1>
+ RM_IHPSG13_1P_COLUMN_256_0[3]/RM_IHPSG13_1P_BITKIT_16x2_SRAM_2[2]/A_LWL<10> RM_IHPSG13_1P_COLUMN_256_0[3]/RM_IHPSG13_1P_BITKIT_16x2_SRAM_3[2]/A_LWL<12>
+ RM_IHPSG13_1P_COLUMN_256_0[3]/RM_IHPSG13_1P_BITKIT_16x2_SRAM_2[0]/A_RWL<15> RM_IHPSG13_1P_COLUMN_256_0[3]/RM_IHPSG13_1P_BITKIT_16x2_SRAM_2[0]/A_LWL<6>
+ RM_IHPSG13_1P_COLUMN_256_0[3]/RM_IHPSG13_1P_BITKIT_16x2_SRAM_3[2]/A_RWL<11> RM_IHPSG13_1P_COLUMN_256_0[3]/RM_IHPSG13_1P_BITKIT_16x2_SRAM_3[1]/A_RWL<15>
+ RM_IHPSG13_1P_COLUMN_256_0[3]/RM_IHPSG13_1P_BITKIT_16x2_SRAM_0[0]/A_LWL<7> RM_IHPSG13_1P_COLUMN_256_0[3]/RM_IHPSG13_1P_BITKIT_16x2_SRAM_1[3]/A_LWL<6>
+ RM_IHPSG13_1P_COLUMN_256_0[3]/RM_IHPSG13_1P_BITKIT_16x2_SRAM_3[1]/A_RWL<2> RM_IHPSG13_1P_COLUMN_256_0[3]/RM_IHPSG13_1P_BITKIT_16x2_SRAM_2[1]/A_RWL<3>
+ RM_IHPSG13_1P_COLUMN_256_0[3]/RM_IHPSG13_1P_BITKIT_16x2_SRAM_2[3]/A_LWL<3> RM_IHPSG13_1P_COLUMN_256_0[3]/RM_IHPSG13_1P_BITKIT_16x2_SRAM_1[1]/A_RWL<4>
+ RM_IHPSG13_1P_COLUMN_256_0[3]/RM_IHPSG13_1P_BITKIT_16x2_SRAM_0[0]/A_LWL<0> RM_IHPSG13_1P_COLUMN_256_0[3]/RM_IHPSG13_1P_BITKIT_16x2_SRAM_1[1]/A_LWL<13>
+ RM_IHPSG13_1P_COLUMN_256_0[3]/RM_IHPSG13_1P_BITKIT_16x2_SRAM_1[0]/A_RWL<8> RM_IHPSG13_1P_COLUMN_256_0[3]/RM_IHPSG13_1P_BITKIT_16x2_SRAM_0[1]/A_RWL<5>
+ RM_IHPSG13_1P_COLUMN_256_0[3]/RM_IHPSG13_1P_BITKIT_16x2_SRAM_2[3]/A_RWL<9> RM_IHPSG13_1P_COLUMN_256_0[3]/RM_IHPSG13_1P_BITKIT_16x2_SRAM_2[0]/A_LWL<7>
+ RM_IHPSG13_1P_COLUMN_256_0[3]/RM_IHPSG13_1P_BITKIT_16x2_SRAM_1[2]/A_LWL<10> RM_IHPSG13_1P_COLUMN_256_0[3]/RM_IHPSG13_1P_BITKIT_16x2_SRAM_1[0]/A_RWL<1>
+ RM_IHPSG13_1P_COLUMN_256_0[3]/RM_IHPSG13_1P_BITKIT_16x2_SRAM_2[1]/A_RWL<13> RM_IHPSG13_1P_COLUMN_256_0[3]/RM_IHPSG13_1P_BITKIT_16x2_SRAM_3[0]/A_RWL<6>
+ RM_IHPSG13_1P_COLUMN_256_0[3]/RM_IHPSG13_1P_BITKIT_16x2_SRAM_1[0]/A_LWL<8> RM_IHPSG13_1P_COLUMN_256_0[3]/RM_IHPSG13_1P_BITKIT_16x2_SRAM_0[2]/A_RWL<15>
+ RM_IHPSG13_1P_COLUMN_256_0[3]/RM_IHPSG13_1P_BITKIT_16x2_SRAM_3[3]/A_LWL<15> RM_IHPSG13_1P_COLUMN_256_0[3]/RM_IHPSG13_1P_BITKIT_16x2_SRAM_0[1]/A_RWL<4>
+ RM_IHPSG13_1P_COLUMN_256_0[3]/RM_IHPSG13_1P_BITKIT_16x2_SRAM_3[3]/A_RWL<14> RM_IHPSG13_1P_COLUMN_256_0[3]/RM_IHPSG13_1P_BITKIT_16x2_SRAM_0[0]/A_LWL<9>
+ RM_IHPSG13_1P_COLUMN_256_0[3]/RM_IHPSG13_1P_BITKIT_16x2_SRAM_2[1]/A_RWL<4> RM_IHPSG13_1P_COLUMN_256_0[3]/RM_IHPSG13_1P_BITKIT_16x2_SRAM_2[0]/A_RWL<4>
+ RM_IHPSG13_1P_COLUMN_256_0[3]/RM_IHPSG13_1P_BITKIT_16x2_SRAM_3[3]/A_RWL<5> RM_IHPSG13_1P_COLUMN_256_0[3]/RM_IHPSG13_1P_BITKIT_16x2_SRAM_2[1]/A_LWL<10>
+ RM_IHPSG13_1P_COLUMN_256_0[3]/RM_IHPSG13_1P_BITKIT_16x2_SRAM_1[1]/A_LWL<14> RM_IHPSG13_1P_COLUMN_256_0[3]/RM_IHPSG13_1P_BITKIT_16x2_SRAM_0[1]/A_RWL<6>
+ RM_IHPSG13_1P_COLUMN_256_0[3]/RM_IHPSG13_1P_BITKIT_16x2_SRAM_2[3]/A_LWL<15> RM_IHPSG13_1P_COLUMN_256_0[3]/RM_IHPSG13_1P_BITKIT_16x2_SRAM_2[0]/A_LWL<8>
+ RM_IHPSG13_1P_COLUMN_256_0[3]/RM_IHPSG13_1P_BITKIT_16x2_SRAM_3[1]/A_RWL<11> RM_IHPSG13_1P_COLUMN_256_0[3]/RM_IHPSG13_1P_BITKIT_16x2_SRAM_1[2]/A_LWL<11>
+ RM_IHPSG13_1P_COLUMN_256_0[3]/RM_IHPSG13_1P_BITKIT_16x2_SRAM_0[1]/A_LWL<1> RM_IHPSG13_1P_COLUMN_256_0[3]/RM_IHPSG13_1P_BITKIT_16x2_SRAM_1[0]/A_RWL<10>
+ RM_IHPSG13_1P_COLUMN_256_0[3]/RM_IHPSG13_1P_BITKIT_16x2_SRAM_1[0]/A_LWL<1> RM_IHPSG13_1P_COLUMN_256_0[3]/RM_IHPSG13_1P_BITKIT_16x2_SRAM_0[3]/A_LWL<3>
+ RM_IHPSG13_1P_COLUMN_256_0[3]/RM_IHPSG13_1P_BITKIT_16x2_SRAM_2[1]/A_RWL<5> RM_IHPSG13_1P_COLUMN_256_0[3]/RM_IHPSG13_1P_BITKIT_16x2_SRAM_3[0]/A_LWL<0>
+ RM_IHPSG13_1P_COLUMN_256_0[3]/RM_IHPSG13_1P_BITKIT_16x2_SRAM_2[2]/A_RWL<11> RM_IHPSG13_1P_COLUMN_256_0[3]/RM_IHPSG13_1P_BITKIT_16x2_SRAM_3[3]/A_LWL<12>
+ RM_IHPSG13_1P_COLUMN_256_0[3]/RM_IHPSG13_1P_BITKIT_16x2_SRAM_1[1]/A_RWL<6> RM_IHPSG13_1P_COLUMN_256_0[3]/RM_IHPSG13_1P_BITKIT_16x2_SRAM_0[3]/A_RWL<9>
+ RM_IHPSG13_1P_COLUMN_256_0[3]/RM_IHPSG13_1P_BITKIT_16x2_SRAM_2[1]/A_LWL<0> RM_IHPSG13_1P_COLUMN_256_0[3]/RM_IHPSG13_1P_BITKIT_16x2_SRAM_0[1]/A_RWL<7>
+ RM_IHPSG13_1P_COLUMN_256_0[3]/RM_IHPSG13_1P_BITKIT_16x2_SRAM_3[2]/A_RWL<15> RM_IHPSG13_1P_COLUMN_256_0[3]/RM_IHPSG13_1P_BITKIT_16x2_SRAM_2[0]/A_LWL<9>
+ RM_IHPSG13_1P_COLUMN_256_0[3]/RM_IHPSG13_1P_BITKIT_16x2_SRAM_1[0]/A_RWL<6> RM_IHPSG13_1P_COLUMN_256_0[3]/RM_IHPSG13_1P_BITKIT_16x2_SRAM_2[1]/A_RWL<15>
+ RM_IHPSG13_1P_COLUMN_256_0[3]/RM_IHPSG13_1P_BITKIT_16x2_SRAM_0[1]/A_LWL<2> RM_IHPSG13_1P_COLUMN_256_0[3]/RM_IHPSG13_1P_BITKIT_16x2_SRAM_3[2]/A_LWL<15>
+ RM_IHPSG13_1P_COLUMN_256_0[3]/RM_IHPSG13_1P_BITKIT_16x2_SRAM_0[0]/A_RWL<4> RM_IHPSG13_1P_COLUMN_256_0[3]/RM_IHPSG13_1P_BITKIT_16x2_SRAM_1[3]/A_RWL<5>
+ RM_IHPSG13_1P_COLUMN_256_0[3]/RM_IHPSG13_1P_BITKIT_16x2_SRAM_0[1]/A_LWL<0> RM_IHPSG13_1P_COLUMN_256_0[3]/RM_IHPSG13_1P_BITKIT_16x2_SRAM_2[0]/A_LWL<10>
+ RM_IHPSG13_1P_COLUMN_256_0[3]/RM_IHPSG13_1P_BITKIT_16x2_SRAM_3[0]/A_LWL<9> RM_IHPSG13_1P_COLUMN_256_0[3]/RM_IHPSG13_1P_BITKIT_16x2_SRAM_0[0]/A_LWL<12>
+ RM_IHPSG13_1P_COLUMN_256_0[3]/RM_IHPSG13_1P_BITKIT_16x2_SRAM_0[0]/A_RWL<3> RM_IHPSG13_1P_COLUMN_256_0[3]/RM_IHPSG13_1P_BITKIT_16x2_SRAM_0[3]/A_RWL<15>
+ RM_IHPSG13_1P_COLUMN_256_0[3]/RM_IHPSG13_1P_BITKIT_16x2_SRAM_3[0]/A_RWL<11> RM_IHPSG13_1P_COLUMN_256_0[3]/RM_IHPSG13_1P_BITKIT_16x2_SRAM_1[2]/A_LWL<13>
+ RM_IHPSG13_1P_COLUMN_256_0[3]/RM_IHPSG13_1P_BITKIT_16x2_SRAM_1[0]/A_RWL<12> RM_IHPSG13_1P_COLUMN_256_0[3]/RM_IHPSG13_1P_BITKIT_16x2_SRAM_3[1]/A_RWL<6>
+ RM_IHPSG13_1P_COLUMN_256_0[3]/RM_IHPSG13_1P_BITKIT_16x2_SRAM_3[0]/A_LWL<6> RM_IHPSG13_1P_COLUMN_256_0[3]/RM_IHPSG13_1P_BITKIT_16x2_SRAM_2[1]/A_RWL<7>
+ RM_IHPSG13_1P_COLUMN_256_0[3]/RM_IHPSG13_1P_BITKIT_16x2_SRAM_2[2]/A_RWL<13> RM_IHPSG13_1P_COLUMN_256_0[3]/RM_IHPSG13_1P_BITKIT_16x2_SRAM_0[2]/A_RWL<0>
+ RM_IHPSG13_1P_COLUMN_256_0[3]/RM_IHPSG13_1P_BITKIT_16x2_SRAM_3[1]/A_LWL<1> RM_IHPSG13_1P_COLUMN_256_0[3]/RM_IHPSG13_1P_BITKIT_16x2_SRAM_1[1]/A_RWL<8>
+ RM_IHPSG13_1P_COLUMN_256_0[3]/RM_IHPSG13_1P_BITKIT_16x2_SRAM_2[1]/A_LWL<2> RM_IHPSG13_1P_COLUMN_256_0[3]/RM_IHPSG13_1P_BITKIT_16x2_SRAM_1[1]/A_LWL<3>
+ RM_IHPSG13_1P_COLUMN_256_0[3]/RM_IHPSG13_1P_BITKIT_16x2_SRAM_1[1]/A_LWL<1> RM_IHPSG13_1P_COLUMN_256_0[3]/RM_IHPSG13_1P_BITKIT_16x2_SRAM_1[2]/A_LWL<14>
+ RM_IHPSG13_1P_COLUMN_256_0[3]/RM_IHPSG13_1P_BITKIT_16x2_SRAM_1[0]/A_LWL<12> RM_IHPSG13_1P_COLUMN_256_0[3]/RM_IHPSG13_1P_BITKIT_16x2_SRAM_0[1]/A_LWL<10>
+ RM_IHPSG13_1P_COLUMN_256_0[3]/RM_IHPSG13_1P_BITKIT_16x2_SRAM_0[1]/A_LWL<4> RM_IHPSG13_1P_COLUMN_256_0[3]/RM_IHPSG13_1P_BITKIT_16x2_SRAM_1[3]/A_LWL<4>
+ RM_IHPSG13_1P_COLUMN_256_0[3]/RM_IHPSG13_1P_BITKIT_16x2_SRAM_3[1]/A_LWL<0> RM_IHPSG13_1P_COLUMN_256_0[3]/RM_IHPSG13_1P_BITKIT_16x2_SRAM_3[1]/A_LWL<15>
+ RM_IHPSG13_1P_COLUMN_256_0[3]/RM_IHPSG13_1P_BITKIT_16x2_SRAM_1[3]/A_LWL<11> RM_IHPSG13_1P_COLUMN_256_0[3]/RM_IHPSG13_1P_BITKIT_16x2_SRAM_1[0]/A_RWL<2>
+ RM_IHPSG13_1P_COLUMN_256_0[3]/RM_IHPSG13_1P_BITKIT_16x2_SRAM_1[1]/A_RWL<10> RM_IHPSG13_1P_COLUMN_256_0[3]/RM_IHPSG13_1P_BITKIT_16x2_SRAM_3[1]/A_RWL<5>
+ RM_IHPSG13_1P_COLUMN_256_0[3]/RM_IHPSG13_1P_BITKIT_16x2_SRAM_0[0]/A_LWL<10> RM_IHPSG13_1P_COLUMN_256_0[3]/RM_IHPSG13_1P_BITKIT_16x2_SRAM_0[3]/A_RWL<12>
+ RM_IHPSG13_1P_COLUMN_256_0[3]/RM_IHPSG13_1P_BITKIT_16x2_SRAM_3[0]/A_RWL<3> RM_IHPSG13_1P_COLUMN_256_0[3]/RM_IHPSG13_1P_BITKIT_16x2_SRAM_1[1]/A_RWL<9>
+ RM_IHPSG13_1P_COLUMN_256_0[3]/RM_IHPSG13_1P_BITKIT_16x2_SRAM_3[3]/A_RWL<15> RM_IHPSG13_1P_COLUMN_256_0[3]/RM_IHPSG13_1P_BITKIT_16x2_SRAM_2[2]/A_RWL<12>
+ RM_IHPSG13_1P_COLUMN_256_0[3]/RM_IHPSG13_1P_BITKIT_16x2_SRAM_2[1]/A_LWL<3> RM_IHPSG13_1P_COLUMN_256_0[3]/RM_IHPSG13_1P_BITKIT_16x2_SRAM_1[0]/A_RWL<11>
+ RM_IHPSG13_1P_COLUMN_256_0[3]/RM_IHPSG13_1P_BITKIT_16x2_SRAM_2[3]/A_RWL<10> RM_IHPSG13_1P_COLUMN_256_0[3]/RM_IHPSG13_1P_BITKIT_16x2_SRAM_1[1]/A_LWL<4>
+ RM_IHPSG13_1P_COLUMN_256_0[3]/RM_IHPSG13_1P_BITKIT_16x2_SRAM_1[2]/A_LWL<15> RM_IHPSG13_1P_COLUMN_256_0[3]/RM_IHPSG13_1P_BITKIT_16x2_SRAM_2[2]/A_RWL<0>
+ RM_IHPSG13_1P_COLUMN_256_0[3]/RM_IHPSG13_1P_BITKIT_16x2_SRAM_1[0]/A_LWL<6> RM_IHPSG13_1P_COLUMN_256_0[3]/RM_IHPSG13_1P_BITKIT_16x2_SRAM_1[0]/A_RWL<14>
+ RM_IHPSG13_1P_COLUMN_256_0[3]/RM_IHPSG13_1P_BITKIT_16x2_SRAM_3[1]/A_RWL<8> RM_IHPSG13_1P_COLUMN_256_0[3]/RM_IHPSG13_1P_BITKIT_16x2_SRAM_3[3]/A_RWL<7>
+ RM_IHPSG13_1P_COLUMN_256_0[3]/RM_IHPSG13_1P_BITKIT_16x2_SRAM_1[2]/A_RWL<1> RM_IHPSG13_1P_COLUMN_256_0[3]/RM_IHPSG13_1P_BITKIT_16x2_SRAM_0[1]/A_LWL<3>
+ RM_IHPSG13_1P_COLUMN_256_0[3]/RM_IHPSG13_1P_BITKIT_16x2_SRAM_2[1]/A_RWL<9> RM_IHPSG13_1P_COLUMN_256_0[3]/RM_IHPSG13_1P_BITKIT_16x2_SRAM_2[2]/A_RWL<15>
+ RM_IHPSG13_1P_COLUMN_256_0[3]/RM_IHPSG13_1P_BITKIT_16x2_SRAM_1[1]/A_RWL<11> RM_IHPSG13_1P_COLUMN_256_0[3]/RM_IHPSG13_1P_BITKIT_16x2_SRAM_2[0]/A_LWL<3>
+ RM_IHPSG13_1P_COLUMN_256_0[3]/RM_IHPSG13_1P_BITKIT_16x2_SRAM_0[2]/A_RWL<2> RM_IHPSG13_1P_COLUMN_256_0[3]/RM_IHPSG13_1P_BITKIT_16x2_SRAM_3[1]/A_LWL<3>
+ RM_IHPSG13_1P_COLUMN_256_0[3]/RM_IHPSG13_1P_BITKIT_16x2_SRAM_0[2]/A_LWL<9> RM_IHPSG13_1P_COLUMN_256_0[3]/RM_IHPSG13_1P_BITKIT_16x2_SRAM_2[0]/A_LWL<13>
+ RM_IHPSG13_1P_COLUMN_256_0[3]/RM_IHPSG13_1P_BITKIT_16x2_SRAM_3[3]/A_LWL<2> RM_IHPSG13_1P_COLUMN_256_0[3]/RM_IHPSG13_1P_BITKIT_16x2_SRAM_0[1]/A_RWL<3>
+ RM_IHPSG13_1P_COLUMN_256_0[3]/RM_IHPSG13_1P_BITKIT_16x2_SRAM_0[1]/A_RWL<9> RM_IHPSG13_1P_COLUMN_256_0[3]/RM_IHPSG13_1P_BITKIT_16x2_SRAM_2[3]/A_RWL<12>
+ RM_IHPSG13_1P_COLUMN_256_0[3]/RM_IHPSG13_1P_BITKIT_16x2_SRAM_2[3]/A_LWL<5> RM_IHPSG13_1P_COLUMN_256_0[3]/RM_IHPSG13_1P_BITKIT_16x2_SRAM_2[2]/A_LWL<8>
+ RM_IHPSG13_1P_COLUMN_256_0[3]/RM_IHPSG13_1P_BITKIT_16x2_SRAM_0[0]/A_LWL<15> RM_IHPSG13_1P_COLUMN_256_0[3]/RM_IHPSG13_1P_BITKIT_16x2_SRAM_2[0]/A_RWL<9>
+ RM_IHPSG13_1P_COLUMN_256_0[3]/RM_IHPSG13_1P_BITKIT_16x2_SRAM_1[1]/A_LWL<5> RM_IHPSG13_1P_COLUMN_256_0[3]/RM_IHPSG13_1P_BITKIT_16x2_SRAM_3[2]/A_RWL<0>
+ RM_IHPSG13_1P_COLUMN_256_0[3]/RM_IHPSG13_1P_BITKIT_16x2_SRAM_1[1]/A_LWL<15> RM_IHPSG13_1P_COLUMN_256_0[3]/RM_IHPSG13_1P_BITKIT_16x2_SRAM_0[1]/A_LWL<12>
+ RM_IHPSG13_1P_COLUMN_256_0[3]/RM_IHPSG13_1P_BITKIT_16x2_SRAM_0[1]/A_LWL<6> RM_IHPSG13_1P_COLUMN_256_0[3]/RM_IHPSG13_1P_BITKIT_16x2_SRAM_3[0]/A_LWL<15>
+ RM_IHPSG13_1P_COLUMN_256_0[3]/RM_IHPSG13_1P_BITKIT_16x2_SRAM_3[1]/A_RWL<9> RM_IHPSG13_1P_COLUMN_256_0[3]/RM_IHPSG13_1P_BITKIT_16x2_SRAM_1[3]/A_LWL<13>
+ RM_IHPSG13_1P_COLUMN_256_0[3]/RM_IHPSG13_1P_BITKIT_16x2_SRAM_1[1]/A_RWL<5> RM_IHPSG13_1P_COLUMN_256_0[3]/RM_IHPSG13_1P_BITKIT_16x2_SRAM_1[1]/A_RWL<12>
+ RM_IHPSG13_1P_COLUMN_256_0[3]/RM_IHPSG13_1P_BITKIT_16x2_SRAM_3[0]/A_RWL<5> RM_IHPSG13_1P_COLUMN_256_0[3]/RM_IHPSG13_1P_BITKIT_16x2_SRAM_3[1]/A_LWL<4>
+ RM_IHPSG13_1P_COLUMN_256_0[3]/RM_IHPSG13_1P_BITKIT_16x2_SRAM_2[3]/A_RWL<13> RM_IHPSG13_1P_COLUMN_256_0[3]/RM_IHPSG13_1P_BITKIT_16x2_SRAM_2[1]/A_RWL<12>
+ RM_IHPSG13_1P_COLUMN_256_0[3]/RM_IHPSG13_1P_BITKIT_16x2_SRAM_2[1]/A_LWL<5> RM_IHPSG13_1P_COLUMN_256_0[3]/RM_IHPSG13_1P_BITKIT_16x2_SRAM_0[3]/A_RWL<10>
+ RM_IHPSG13_1P_COLUMN_256_0[3]/RM_IHPSG13_1P_BITKIT_16x2_SRAM_1[1]/A_LWL<12> RM_IHPSG13_1P_COLUMN_256_0[3]/RM_IHPSG13_1P_BITKIT_16x2_SRAM_2[2]/A_RWL<10>
+ RM_IHPSG13_1P_COLUMN_256_0[3]/RM_IHPSG13_1P_BITKIT_16x2_SRAM_1[1]/A_LWL<6> RM_IHPSG13_1P_COLUMN_256_0[3]/RM_IHPSG13_1P_BITKIT_16x2_SRAM_3[2]/A_RWL<1>
+ RM_IHPSG13_1P_COLUMN_256_0[3]/RM_IHPSG13_1P_BITKIT_16x2_SRAM_0[1]/A_LWL<13> RM_IHPSG13_1P_COLUMN_256_0[3]/RM_IHPSG13_1P_BITKIT_16x2_SRAM_1[3]/A_RWL<7>
+ RM_IHPSG13_1P_COLUMN_256_0[3]/RM_IHPSG13_1P_BITKIT_16x2_SRAM_0[1]/A_LWL<7> RM_IHPSG13_1P_COLUMN_256_0[3]/RM_IHPSG13_1P_BITKIT_16x2_SRAM_2[2]/A_RWL<2>
+ RM_IHPSG13_1P_COLUMN_256_0[3]/RM_IHPSG13_1P_BITKIT_16x2_SRAM_1[1]/A_RWL<2> RM_IHPSG13_1P_COLUMN_256_0[3]/RM_IHPSG13_1P_BITKIT_16x2_SRAM_1[2]/A_RWL<0>
+ RM_IHPSG13_1P_COLUMN_256_0[3]/RM_IHPSG13_1P_BITKIT_16x2_SRAM_1[0]/A_RWL<15> RM_IHPSG13_1P_COLUMN_256_0[3]/RM_IHPSG13_1P_BITKIT_16x2_SRAM_3[2]/A_LWL<9>
+ RM_IHPSG13_1P_COLUMN_256_0[3]/RM_IHPSG13_1P_BITKIT_16x2_SRAM_1[3]/A_LWL<14> RM_IHPSG13_1P_COLUMN_256_0[3]/RM_IHPSG13_1P_BITKIT_16x2_SRAM_3[1]/A_RWL<0>
+ RM_IHPSG13_1P_COLUMN_256_0[3]/RM_IHPSG13_1P_BITKIT_16x2_SRAM_3[1]/A_RWL<3> RM_IHPSG13_1P_COLUMN_256_0[3]/RM_IHPSG13_1P_BITKIT_16x2_SRAM_0[0]/A_LWL<3>
+ RM_IHPSG13_1P_COLUMN_256_0[3]/RM_IHPSG13_1P_BITKIT_16x2_SRAM_1[2]/A_RWL<3> RM_IHPSG13_1P_COLUMN_256_0[3]/RM_IHPSG13_1P_BITKIT_16x2_SRAM_0[2]/A_LWL<10>
+ RM_IHPSG13_1P_COLUMN_256_0[3]/RM_IHPSG13_1P_BITKIT_16x2_SRAM_1[3]/A_LWL<2> RM_IHPSG13_1P_COLUMN_256_0[3]/RM_IHPSG13_1P_BITKIT_16x2_SRAM_0[2]/A_RWL<4>
+ RM_IHPSG13_1P_COLUMN_256_0[3]/RM_IHPSG13_1P_BITKIT_16x2_SRAM_0[0]/A_RWL<9> RM_IHPSG13_1P_COLUMN_256_0[3]/RM_IHPSG13_1P_BITKIT_16x2_SRAM_2[1]/A_LWL<6>
+ RM_IHPSG13_1P_COLUMN_256_0[3]/RM_IHPSG13_1P_BITKIT_16x2_SRAM_1[2]/A_RWL<10> RM_IHPSG13_1P_COLUMN_256_0[3]/RM_IHPSG13_1P_BITKIT_16x2_SRAM_2[3]/A_LWL<11>
+ RM_IHPSG13_1P_COLUMN_256_0[3]/RM_IHPSG13_1P_BITKIT_16x2_SRAM_3[2]/A_RWL<2> RM_IHPSG13_1P_COLUMN_256_0[3]/RM_IHPSG13_1P_BITKIT_16x2_SRAM_1[0]/A_LWL<15>
+ RM_IHPSG13_1P_COLUMN_256_0[3]/RM_IHPSG13_1P_BITKIT_16x2_SRAM_0[3]/A_LWL<0> RM_IHPSG13_1P_COLUMN_256_0[3]/RM_IHPSG13_1P_BITKIT_16x2_SRAM_2[3]/A_LWL<14>
+ RM_IHPSG13_1P_COLUMN_256_0[3]/RM_IHPSG13_1P_BITKIT_16x2_SRAM_2[2]/A_RWL<3> RM_IHPSG13_1P_COLUMN_256_0[3]/RM_IHPSG13_1P_BITKIT_16x2_SRAM_0[0]/A_LWL<5>
+ RM_IHPSG13_1P_COLUMN_256_0[3]/RM_IHPSG13_1P_BITKIT_16x2_SRAM_1[3]/A_LWL<15> RM_IHPSG13_1P_COLUMN_256_0[3]/RM_IHPSG13_1P_BITKIT_16x2_SRAM_1[0]/A_RWL<5>
+ RM_IHPSG13_1P_COLUMN_256_0[3]/RM_IHPSG13_1P_BITKIT_16x2_SRAM_2[1]/A_LWL<13> RM_IHPSG13_1P_COLUMN_256_0[3]/RM_IHPSG13_1P_BITKIT_16x2_SRAM_0[3]/A_LWL<9>
+ RM_IHPSG13_1P_COLUMN_256_0[3]/RM_IHPSG13_1P_BITKIT_16x2_SRAM_0[2]/A_RWL<3> RM_IHPSG13_1P_COLUMN_256_0[3]/RM_IHPSG13_1P_BITKIT_16x2_SRAM_3[3]/A_LWL<7>
+ RM_IHPSG13_1P_COLUMN_256_0[3]/RM_IHPSG13_1P_BITKIT_16x2_SRAM_2[0]/A_LWL<4> RM_IHPSG13_1P_COLUMN_256_0[3]/RM_IHPSG13_1P_BITKIT_16x2_SRAM_1[1]/A_RWL<14>
+ RM_IHPSG13_1P_COLUMN_256_0[3]/RM_IHPSG13_1P_BITKIT_16x2_SRAM_0[2]/A_RWL<5> RM_IHPSG13_1P_COLUMN_256_0[3]/RM_IHPSG13_1P_BITKIT_16x2_SRAM_2[3]/A_LWL<8>
+ RM_IHPSG13_1P_COLUMN_256_0[3]/RM_IHPSG13_1P_BITKIT_16x2_SRAM_3[1]/A_LWL<6> RM_IHPSG13_1P_COLUMN_256_0[3]/RM_IHPSG13_1P_BITKIT_16x2_SRAM_2[0]/A_RWL<12>
+ RM_IHPSG13_1P_COLUMN_256_0[3]/RM_IHPSG13_1P_BITKIT_16x2_SRAM_2[3]/A_RWL<15> RM_IHPSG13_1P_COLUMN_256_0[3]/RM_IHPSG13_1P_BITKIT_16x2_SRAM_1[2]/A_RWL<11>
+ RM_IHPSG13_1P_COLUMN_256_0[3]/RM_IHPSG13_1P_BITKIT_16x2_SRAM_2[1]/A_LWL<7> RM_IHPSG13_1P_COLUMN_256_0[3]/RM_IHPSG13_1P_BITKIT_16x2_SRAM_2[0]/A_RWL<14>
+ RM_IHPSG13_1P_COLUMN_256_0[3]/RM_IHPSG13_1P_BITKIT_16x2_SRAM_3[3]/A_RWL<13> RM_IHPSG13_1P_COLUMN_256_0[3]/RM_IHPSG13_1P_BITKIT_16x2_SRAM_0[2]/A_LWL<0>
+ RM_IHPSG13_1P_COLUMN_256_0[3]/RM_IHPSG13_1P_BITKIT_16x2_SRAM_2[1]/A_RWL<10> RM_IHPSG13_1P_COLUMN_256_0[3]/RM_IHPSG13_1P_BITKIT_16x2_SRAM_1[1]/A_LWL<8>
+ RM_IHPSG13_1P_COLUMN_256_0[3]/RM_IHPSG13_1P_BITKIT_16x2_SRAM_0[1]/A_LWL<15> RM_IHPSG13_1P_COLUMN_256_0[3]/RM_IHPSG13_1P_BITKIT_16x2_SRAM_0[1]/A_LWL<9>
+ RM_IHPSG13_1P_COLUMN_256_0[3]/RM_IHPSG13_1P_BITKIT_16x2_SRAM_2[2]/A_RWL<4> RM_IHPSG13_1P_COLUMN_256_0[3]/RM_IHPSG13_1P_BITKIT_16x2_SRAM_1[1]/A_RWL<0>
+ RM_IHPSG13_1P_COLUMN_256_0[3]/RM_IHPSG13_1P_BITKIT_16x2_SRAM_3[1]/A_RWL<7> RM_IHPSG13_1P_COLUMN_256_0[3]/RM_IHPSG13_1P_BITKIT_16x2_SRAM_3[0]/A_RWL<0>
+ RM_IHPSG13_1P_COLUMN_256_0[3]/RM_IHPSG13_1P_BITKIT_16x2_SRAM_1[2]/A_RWL<5> RM_IHPSG13_1P_COLUMN_256_0[3]/RM_IHPSG13_1P_BITKIT_16x2_SRAM_0[2]/A_LWL<12>
+ RM_IHPSG13_1P_COLUMN_256_0[3]/RM_IHPSG13_1P_BITKIT_16x2_SRAM_0[0]/A_RWL<11> RM_IHPSG13_1P_COLUMN_256_0[3]/RM_IHPSG13_1P_BITKIT_16x2_SRAM_1[3]/A_LWL<1>
+ RM_IHPSG13_1P_COLUMN_256_0[3]/RM_IHPSG13_1P_BITKIT_16x2_SRAM_3[1]/A_LWL<2> RM_IHPSG13_1P_COLUMN_256_0[3]/RM_IHPSG13_1P_BITKIT_16x2_SRAM_1[2]/A_LWL<12>
+ RM_IHPSG13_1P_COLUMN_256_0[3]/RM_IHPSG13_1P_BITKIT_16x2_SRAM_1[2]/A_LWL<0> RM_IHPSG13_1P_COLUMN_256_0[3]/RM_IHPSG13_1P_BITKIT_16x2_SRAM_3[3]/A_LWL<0>
+ RM_IHPSG13_1P_COLUMN_256_0[3]/RM_IHPSG13_1P_BITKIT_16x2_SRAM_1[2]/A_RWL<12> RM_IHPSG13_1P_COLUMN_256_0[3]/RM_IHPSG13_1P_BITKIT_16x2_SRAM_2[1]/A_LWL<8>
+ RM_IHPSG13_1P_COLUMN_256_0[3]/RM_IHPSG13_1P_BITKIT_16x2_SRAM_2[2]/A_LWL<11> RM_IHPSG13_1P_COLUMN_256_0[3]/RM_IHPSG13_1P_BITKIT_16x2_SRAM_0[2]/A_LWL<1>
+ RM_IHPSG13_1P_COLUMN_256_0[3]/RM_IHPSG13_1P_BITKIT_16x2_SRAM_1[2]/A_RWL<2> RM_IHPSG13_1P_COLUMN_256_0[3]/RM_IHPSG13_1P_BITKIT_16x2_SRAM_3[0]/A_LWL<5>
+ RM_IHPSG13_1P_COLUMN_256_0[3]/RM_IHPSG13_1P_BITKIT_16x2_SRAM_1[1]/A_RWL<15> RM_IHPSG13_1P_COLUMN_256_0[3]/RM_IHPSG13_1P_BITKIT_16x2_SRAM_3[3]/A_LWL<9>
+ RM_IHPSG13_1P_COLUMN_256_0[3]/RM_IHPSG13_1P_BITKIT_16x2_SRAM_2[2]/A_LWL<14> RM_IHPSG13_1P_COLUMN_256_0[3]/RM_IHPSG13_1P_BITKIT_16x2_SRAM_3[2]/A_RWL<3>
+ RM_IHPSG13_1P_COLUMN_256_0[3]/RM_IHPSG13_1P_BITKIT_16x2_SRAM_2[2]/A_RWL<5> RM_IHPSG13_1P_COLUMN_256_0[3]/RM_IHPSG13_1P_BITKIT_16x2_SRAM_1[3]/A_LWL<7>
+ RM_IHPSG13_1P_COLUMN_256_0[3]/RM_IHPSG13_1P_BITKIT_16x2_SRAM_1[2]/A_RWL<6> RM_IHPSG13_1P_COLUMN_256_0[3]/RM_IHPSG13_1P_BITKIT_16x2_SRAM_0[2]/A_LWL<13>
+ RM_IHPSG13_1P_COLUMN_256_0[3]/RM_IHPSG13_1P_BITKIT_16x2_SRAM_3[2]/A_LWL<7> RM_IHPSG13_1P_COLUMN_256_0[3]/RM_IHPSG13_1P_BITKIT_16x2_SRAM_2[2]/A_LWL<0>
+ RM_IHPSG13_1P_COLUMN_256_0[3]/RM_IHPSG13_1P_BITKIT_16x2_SRAM_0[0]/A_RWL<12> RM_IHPSG13_1P_COLUMN_256_0[3]/RM_IHPSG13_1P_BITKIT_16x2_SRAM_0[2]/A_RWL<7>
+ RM_IHPSG13_1P_COLUMN_256_0[3]/RM_IHPSG13_1P_BITKIT_16x2_SRAM_0[3]/A_LWL<10> RM_IHPSG13_1P_COLUMN_256_0[3]/RM_IHPSG13_1P_BITKIT_16x2_SRAM_1[2]/A_LWL<1>
+ RM_IHPSG13_1P_COLUMN_256_0[3]/RM_IHPSG13_1P_BITKIT_16x2_SRAM_3[2]/A_RWL<13> RM_IHPSG13_1P_COLUMN_256_0[3]/RM_IHPSG13_1P_BITKIT_16x2_SRAM_2[1]/A_LWL<9>
+ RM_IHPSG13_1P_COLUMN_256_0[3]/RM_IHPSG13_1P_BITKIT_16x2_SRAM_2[0]/A_RWL<10> RM_IHPSG13_1P_COLUMN_256_0[3]/RM_IHPSG13_1P_BITKIT_16x2_SRAM_0[2]/A_LWL<2>
+ RM_IHPSG13_1P_COLUMN_256_0[3]/RM_IHPSG13_1P_BITKIT_16x2_SRAM_2[3]/A_RWL<8> RM_IHPSG13_1P_COLUMN_256_0[3]/RM_IHPSG13_1P_BITKIT_16x2_SRAM_3[2]/A_RWL<5>
+ RM_IHPSG13_1P_COLUMN_256_0[3]/RM_IHPSG13_1P_BITKIT_16x2_SRAM_1[3]/A_RWL<10> RM_IHPSG13_1P_COLUMN_256_0[3]/RM_IHPSG13_1P_BITKIT_16x2_SRAM_0[1]/A_LWL<5>
+ RM_IHPSG13_1P_COLUMN_256_0[3]/RM_IHPSG13_1P_BITKIT_16x2_SRAM_0[0]/A_LWL<8> RM_IHPSG13_1P_COLUMN_256_0[3]/RM_IHPSG13_1P_BITKIT_16x2_SRAM_1[1]/A_RWL<7>
+ RM_IHPSG13_1P_COLUMN_256_0[3]/RM_IHPSG13_1P_BITKIT_16x2_SRAM_2[2]/A_LWL<13> RM_IHPSG13_1P_COLUMN_256_0[3]/RM_IHPSG13_1P_BITKIT_16x2_SRAM_1[0]/A_RWL<0>
+ RM_IHPSG13_1P_COLUMN_256_0[3]/RM_IHPSG13_1P_BITKIT_16x2_SRAM_2[1]/A_LWL<4> RM_IHPSG13_1P_COLUMN_256_0[3]/RM_IHPSG13_1P_BITKIT_16x2_SRAM_3[0]/A_RWL<7>
+ RM_IHPSG13_1P_COLUMN_256_0[3]/RM_IHPSG13_1P_BITKIT_16x2_SRAM_3[2]/A_LWL<0> RM_IHPSG13_1P_COLUMN_256_0[3]/RM_IHPSG13_1P_BITKIT_16x2_SRAM_1[2]/A_RWL<7>
+ RM_IHPSG13_1P_COLUMN_256_0[3]/RM_IHPSG13_1P_BITKIT_16x2_SRAM_1[1]/A_LWL<2> RM_IHPSG13_1P_COLUMN_256_0[3]/RM_IHPSG13_1P_BITKIT_16x2_SRAM_0[0]/A_RWL<13>
+ RM_IHPSG13_1P_COLUMN_256_0[3]/RM_IHPSG13_1P_BITKIT_16x2_SRAM_2[1]/A_RWL<14> RM_IHPSG13_1P_COLUMN_256_0[3]/RM_IHPSG13_1P_BITKIT_16x2_SRAM_2[2]/A_LWL<1>
+ RM_IHPSG13_1P_COLUMN_256_0[3]/RM_IHPSG13_1P_BITKIT_16x2_SRAM_3[1]/A_LWL<9> RM_IHPSG13_1P_COLUMN_256_0[3]/RM_IHPSG13_1P_BITKIT_16x2_SRAM_3[0]/A_LWL<2>
+ RM_IHPSG13_1P_COLUMN_256_0[3]/RM_IHPSG13_1P_BITKIT_16x2_SRAM_3[3]/A_RWL<4> RM_IHPSG13_1P_COLUMN_256_0[3]/RM_IHPSG13_1P_BITKIT_16x2_SRAM_0[2]/A_LWL<11>
+ RM_IHPSG13_1P_COLUMN_256_0[3]/RM_IHPSG13_1P_BITKIT_16x2_SRAM_0[3]/A_LWL<11> RM_IHPSG13_1P_COLUMN_256_0[3]/RM_IHPSG13_1P_BITKIT_16x2_SRAM_1[2]/A_LWL<2>
+ RM_IHPSG13_1P_COLUMN_256_0[3]/RM_IHPSG13_1P_BITKIT_16x2_SRAM_1[2]/A_RWL<14> RM_IHPSG13_1P_COLUMN_256_0[3]/RM_IHPSG13_1P_BITKIT_16x2_SRAM_2[1]/A_LWL<11>
+ RM_IHPSG13_1P_COLUMN_256_0[3]/RM_IHPSG13_1P_BITKIT_16x2_SRAM_0[1]/A_RWL<10> RM_IHPSG13_1P_COLUMN_256_0[3]/RM_IHPSG13_1P_BITKIT_16x2_SRAM_0[2]/A_LWL<3>
+ RM_IHPSG13_1P_COLUMN_256_0[3]/RM_IHPSG13_1P_BITKIT_16x2_SRAM_0[2]/A_LWL<14> RM_IHPSG13_1P_COLUMN_256_0[3]/RM_IHPSG13_1P_BITKIT_16x2_SRAM_3[2]/A_RWL<6>
+ RM_IHPSG13_1P_COLUMN_256_0[3]/RM_IHPSG13_1P_BITKIT_16x2_SRAM_1[3]/A_RWL<11> RM_IHPSG13_1P_COLUMN_256_0[3]/RM_IHPSG13_1P_BITKIT_16x2_SRAM_2[1]/A_LWL<14>
+ RM_IHPSG13_1P_COLUMN_256_0[3]/RM_IHPSG13_1P_BITKIT_16x2_SRAM_2[2]/A_RWL<7> RM_IHPSG13_1P_COLUMN_256_0[3]/RM_IHPSG13_1P_BITKIT_16x2_SRAM_0[3]/A_RWL<0>
+ RM_IHPSG13_1P_COLUMN_256_0[3]/RM_IHPSG13_1P_BITKIT_16x2_SRAM_1[0]/A_LWL<0> RM_IHPSG13_1P_COLUMN_256_0[3]/RM_IHPSG13_1P_BITKIT_16x2_SRAM_1[2]/A_RWL<8>
+ RM_IHPSG13_1P_COLUMN_256_0[3]/RM_IHPSG13_1P_BITKIT_16x2_SRAM_3[2]/A_LWL<1> RM_IHPSG13_1P_COLUMN_256_0[3]/RM_IHPSG13_1P_BITKIT_16x2_SRAM_0[2]/A_LWL<15>
+ RM_IHPSG13_1P_COLUMN_256_0[3]/RM_IHPSG13_1P_BITKIT_16x2_SRAM_1[3]/A_LWL<12> RM_IHPSG13_1P_COLUMN_256_0[3]/RM_IHPSG13_1P_BITKIT_16x2_SRAM_3[1]/A_LWL<7>
+ RM_IHPSG13_1P_COLUMN_256_0[3]/RM_IHPSG13_1P_BITKIT_16x2_SRAM_0[2]/A_RWL<9> RM_IHPSG13_1P_COLUMN_256_0[3]/RM_IHPSG13_1P_BITKIT_16x2_SRAM_0[0]/A_RWL<14>
+ RM_IHPSG13_1P_COLUMN_256_0[3]/RM_IHPSG13_1P_BITKIT_16x2_SRAM_2[2]/A_LWL<2> RM_IHPSG13_1P_COLUMN_256_0[3]/RM_IHPSG13_1P_BITKIT_16x2_SRAM_1[2]/A_RWL<13>
+ RM_IHPSG13_1P_COLUMN_256_0[3]/RM_IHPSG13_1P_BITKIT_16x2_SRAM_1[0]/A_LWL<9> RM_IHPSG13_1P_COLUMN_256_0[3]/RM_IHPSG13_1P_BITKIT_16x2_SRAM_0[3]/A_LWL<12>
+ RM_IHPSG13_1P_COLUMN_256_0[3]/RM_IHPSG13_1P_BITKIT_16x2_SRAM_1[2]/A_LWL<3> RM_IHPSG13_1P_COLUMN_256_0[3]/RM_IHPSG13_1P_BITKIT_16x2_SRAM_3[1]/A_RWL<13>
+ RM_IHPSG13_1P_COLUMN_256_0[3]/RM_IHPSG13_1P_BITKIT_16x2_SRAM_3[1]/A_LWL<5> RM_IHPSG13_1P_COLUMN_256_0[3]/RM_IHPSG13_1P_BITKIT_16x2_SRAM_0[0]/A_RWL<10>
+ RM_IHPSG13_1P_COLUMN_256_0[3]/RM_IHPSG13_1P_BITKIT_16x2_SRAM_0[3]/A_RWL<8> RM_IHPSG13_1P_COLUMN_256_0[3]/RM_IHPSG13_1P_BITKIT_16x2_SRAM_1[2]/A_RWL<15>
+ RM_IHPSG13_1P_COLUMN_256_0[3]/RM_IHPSG13_1P_BITKIT_16x2_SRAM_3[0]/A_LWL<8> RM_IHPSG13_1P_COLUMN_256_0[3]/RM_IHPSG13_1P_BITKIT_16x2_SRAM_0[1]/A_RWL<11>
+ RM_IHPSG13_1P_COLUMN_256_0[3]/RM_IHPSG13_1P_BITKIT_16x2_SRAM_3[3]/A_RWL<3> RM_IHPSG13_1P_COLUMN_256_0[3]/RM_IHPSG13_1P_BITKIT_16x2_SRAM_0[2]/A_LWL<4>
+ RM_IHPSG13_1P_COLUMN_256_0[3]/RM_IHPSG13_1P_BITKIT_16x2_SRAM_3[2]/A_RWL<7> RM_IHPSG13_1P_COLUMN_256_0[3]/RM_IHPSG13_1P_BITKIT_16x2_SRAM_1[3]/A_RWL<12>
+ RM_IHPSG13_1P_COLUMN_256_0[3]/RM_IHPSG13_1P_BITKIT_16x2_SRAM_1[0]/A_RWL<7> RM_IHPSG13_1P_COLUMN_256_0[3]/RM_IHPSG13_1P_BITKIT_16x2_SRAM_1[3]/A_RWL<0>
+ RM_IHPSG13_1P_COLUMN_256_0[3]/RM_IHPSG13_1P_BITKIT_16x2_SRAM_2[2]/A_RWL<8> RM_IHPSG13_1P_COLUMN_256_0[3]/RM_IHPSG13_1P_BITKIT_16x2_SRAM_2[3]/A_RWL<6>
+ RM_IHPSG13_1P_COLUMN_256_0[3]/RM_IHPSG13_1P_BITKIT_16x2_SRAM_2[2]/A_RWL<1> RM_IHPSG13_1P_COLUMN_256_0[3]/RM_IHPSG13_1P_BITKIT_16x2_SRAM_0[3]/A_RWL<1>
+ RM_IHPSG13_1P_COLUMN_256_0[3]/RM_IHPSG13_1P_BITKIT_16x2_SRAM_3[2]/A_LWL<2> RM_IHPSG13_1P_COLUMN_256_0[3]/RM_IHPSG13_1P_BITKIT_16x2_SRAM_1[2]/A_RWL<9>
+ RM_IHPSG13_1P_COLUMN_256_0[3]/RM_IHPSG13_1P_BITKIT_16x2_SRAM_1[0]/A_LWL<2> RM_IHPSG13_1P_COLUMN_256_0[3]/RM_IHPSG13_1P_BITKIT_16x2_SRAM_2[2]/A_LWL<3>
+ RM_IHPSG13_1P_COLUMN_256_0[3]/RM_IHPSG13_1P_BITKIT_16x2_SRAM_0[0]/A_RWL<15> RM_IHPSG13_1P_COLUMN_256_0[3]/RM_IHPSG13_1P_BITKIT_16x2_SRAM_0[1]/A_LWL<11>
+ RM_IHPSG13_1P_COLUMN_256_0[3]/RM_IHPSG13_1P_BITKIT_16x2_SRAM_3[2]/A_RWL<4> RM_IHPSG13_1P_COLUMN_256_0[3]/RM_IHPSG13_1P_BITKIT_16x2_SRAM_0[3]/A_LWL<13>
+ RM_IHPSG13_1P_COLUMN_256_0[3]/RM_IHPSG13_1P_BITKIT_16x2_SRAM_1[2]/A_LWL<4> RM_IHPSG13_1P_COLUMN_256_0[3]/RM_IHPSG13_1P_BITKIT_16x2_SRAM_2[0]/A_LWL<11>
+ RM_IHPSG13_1P_COLUMN_256_0[3]/RM_IHPSG13_1P_BITKIT_16x2_SRAM_0[1]/A_RWL<12> RM_IHPSG13_1P_COLUMN_256_0[3]/RM_IHPSG13_1P_BITKIT_16x2_SRAM_3[3]/A_LWL<10>
+ RM_IHPSG13_1P_COLUMN_256_0[3]/RM_IHPSG13_1P_BITKIT_16x2_SRAM_2[0]/A_LWL<1> RM_IHPSG13_1P_COLUMN_256_0[3]/RM_IHPSG13_1P_BITKIT_16x2_SRAM_0[1]/A_LWL<8>
+ RM_IHPSG13_1P_COLUMN_256_0[3]/RM_IHPSG13_1P_BITKIT_16x2_SRAM_0[1]/A_LWL<14> RM_IHPSG13_1P_COLUMN_256_0[3]/RM_IHPSG13_1P_BITKIT_16x2_SRAM_0[2]/A_LWL<5>
+ RM_IHPSG13_1P_COLUMN_256_0[3]/RM_IHPSG13_1P_BITKIT_16x2_SRAM_2[3]/A_RWL<0> RM_IHPSG13_1P_COLUMN_256_0[3]/RM_IHPSG13_1P_BITKIT_16x2_SRAM_2[3]/A_LWL<13>
+ RM_IHPSG13_1P_COLUMN_256_0[3]/RM_IHPSG13_1P_BITKIT_16x2_SRAM_3[2]/A_RWL<8> RM_IHPSG13_1P_COLUMN_256_0[3]/RM_IHPSG13_1P_BITKIT_16x2_SRAM_1[3]/A_RWL<13>
+ RM_IHPSG13_1P_COLUMN_256_0[3]/RM_IHPSG13_1P_BITKIT_16x2_SRAM_2[0]/A_LWL<14> RM_IHPSG13_1P_COLUMN_256_0[3]/RM_IHPSG13_1P_BITKIT_16x2_SRAM_1[3]/A_RWL<1>
+ RM_IHPSG13_1P_COLUMN_256_0[3]/RM_IHPSG13_1P_BITKIT_16x2_SRAM_2[2]/A_RWL<9> RM_IHPSG13_1P_COLUMN_256_0[3]/RM_IHPSG13_1P_BITKIT_16x2_SRAM_1[1]/A_LWL<7>
+ RM_IHPSG13_1P_COLUMN_256_0[3]/RM_IHPSG13_1P_BITKIT_16x2_SRAM_2[2]/A_RWL<14> RM_IHPSG13_1P_COLUMN_256_0[3]/RM_IHPSG13_1P_BITKIT_16x2_SRAM_0[3]/A_RWL<2>
+ RM_IHPSG13_1P_COLUMN_256_0[3]/RM_IHPSG13_1P_BITKIT_16x2_SRAM_3[2]/A_LWL<3> RM_IHPSG13_1P_COLUMN_256_0[3]/RM_IHPSG13_1P_BITKIT_16x2_SRAM_3[0]/A_LWL<7>
+ RM_IHPSG13_1P_COLUMN_256_0[3]/RM_IHPSG13_1P_BITKIT_16x2_SRAM_2[2]/A_LWL<4> RM_IHPSG13_1P_COLUMN_256_0[3]/RM_IHPSG13_1P_BITKIT_16x2_SRAM_1[1]/A_RWL<13>
+ RM_IHPSG13_1P_COLUMN_256_0[3]/RM_IHPSG13_1P_BITKIT_16x2_SRAM_0[3]/A_LWL<14> RM_IHPSG13_1P_COLUMN_256_0[3]/RM_IHPSG13_1P_BITKIT_16x2_SRAM_3[0]/A_RWL<13>
+ RM_IHPSG13_1P_COLUMN_256_0[3]/RM_IHPSG13_1P_BITKIT_16x2_SRAM_1[2]/A_LWL<5> RM_IHPSG13_1P_COLUMN_256_0[3]/RM_IHPSG13_1P_BITKIT_16x2_SRAM_3[3]/A_RWL<0>
+ RM_IHPSG13_1P_COLUMN_256_0[3]/RM_IHPSG13_1P_BITKIT_16x2_SRAM_0[2]/A_RWL<8> RM_IHPSG13_1P_COLUMN_256_0[3]/RM_IHPSG13_1P_BITKIT_16x2_SRAM_0[1]/A_RWL<13>
+ RM_IHPSG13_1P_COLUMN_256_0[3]/RM_IHPSG13_1P_BITKIT_16x2_SRAM_3[0]/A_LWL<10> RM_IHPSG13_1P_COLUMN_256_0[3]/RM_IHPSG13_1P_BITKIT_16x2_SRAM_2[1]/A_RWL<8>
+ RM_IHPSG13_1P_COLUMN_256_0[3]/RM_IHPSG13_1P_BITKIT_16x2_SRAM_0[2]/A_LWL<6> RM_IHPSG13_1P_COLUMN_256_0[3]/RM_IHPSG13_1P_BITKIT_16x2_SRAM_2[3]/A_RWL<1>
+ RM_IHPSG13_1P_COLUMN_256_0[3]/RM_IHPSG13_1P_BITKIT_16x2_SRAM_3[2]/A_RWL<9> RM_IHPSG13_1P_COLUMN_256_0[3]/RM_IHPSG13_1P_BITKIT_16x2_SRAM_0[3]/A_RWL<6>
+ RM_IHPSG13_1P_COLUMN_256_0[3]/RM_IHPSG13_1P_BITKIT_16x2_SRAM_1[3]/A_RWL<14> RM_IHPSG13_1P_COLUMN_256_0[3]/RM_IHPSG13_1P_BITKIT_16x2_SRAM_0[2]/A_RWL<1>
+ RM_IHPSG13_1P_COLUMN_256_0[3]/RM_IHPSG13_1P_BITKIT_16x2_SRAM_1[1]/A_LWL<0> RM_IHPSG13_1P_COLUMN_256_0[3]/RM_IHPSG13_1P_BITKIT_16x2_SRAM_0[2]/A_RWL<10>
+ RM_IHPSG13_1P_COLUMN_256_0[3]/RM_IHPSG13_1P_BITKIT_16x2_SRAM_1[3]/A_RWL<2> RM_IHPSG13_1P_COLUMN_256_0[3]/RM_IHPSG13_1P_BITKIT_16x2_SRAM_2[2]/A_RWL<6>
+ RM_IHPSG13_1P_COLUMN_256_0[3]/RM_IHPSG13_1P_BITKIT_16x2_SRAM_2[1]/A_RWL<1> RM_IHPSG13_1P_COLUMN_256_0[3]/RM_IHPSG13_1P_BITKIT_16x2_SRAM_0[3]/A_RWL<3>
+ RM_IHPSG13_1P_COLUMN_256_0[3]/RM_IHPSG13_1P_BITKIT_16x2_SRAM_3[2]/A_LWL<4> RM_IHPSG13_1P_COLUMN_256_0[3]/RM_IHPSG13_1P_BITKIT_16x2_SRAM_1[1]/A_LWL<9>
+ RM_IHPSG13_1P_COLUMN_256_0[3]/RM_IHPSG13_1P_BITKIT_16x2_SRAM_1[2]/A_RWL<4> RM_IHPSG13_1P_COLUMN_256_0[3]/RM_IHPSG13_1P_BITKIT_16x2_SRAM_1[0]/A_RWL<3>
+ RM_IHPSG13_1P_COLUMN_256_0[3]/RM_IHPSG13_1P_BITKIT_16x2_SRAM_2[2]/A_LWL<5> RM_IHPSG13_1P_COLUMN_256_0[3]/RM_IHPSG13_1P_BITKIT_16x2_SRAM_3[1]/A_LWL<8>
+ RM_IHPSG13_1P_COLUMN_256_0[3]/RM_IHPSG13_1P_BITKIT_16x2_SRAM_0[0]/A_LWL<11> RM_IHPSG13_1P_COLUMN_256_0[3]/RM_IHPSG13_1P_BITKIT_16x2_SRAM_3[1]/A_RWL<4>
+ RM_IHPSG13_1P_COLUMN_256_0[3]/RM_IHPSG13_1P_BITKIT_16x2_SRAM_0[3]/A_LWL<15> RM_IHPSG13_1P_COLUMN_256_0[3]/RM_IHPSG13_1P_BITKIT_16x2_SRAM_1[3]/A_LWL<10>
+ RM_IHPSG13_1P_COLUMN_256_0[3]/RM_IHPSG13_1P_BITKIT_16x2_SRAM_1[2]/A_LWL<6> RM_IHPSG13_1P_COLUMN_256_0[3]/RM_IHPSG13_1P_BITKIT_16x2_SRAM_3[3]/A_RWL<1>
+ RM_IHPSG13_1P_COLUMN_256_0[3]/RM_IHPSG13_1P_BITKIT_16x2_SRAM_0[1]/A_RWL<14> RM_IHPSG13_1P_COLUMN_256_0[3]/RM_IHPSG13_1P_BITKIT_16x2_SRAM_3[2]/A_LWL<10>
+ RM_IHPSG13_1P_COLUMN_256_0[3]/RM_IHPSG13_1P_BITKIT_16x2_SRAM_3[0]/A_LWL<11> RM_IHPSG13_1P_COLUMN_256_0[3]/RM_IHPSG13_1P_BITKIT_16x2_SRAM_0[0]/A_LWL<14>
+ RM_IHPSG13_1P_COLUMN_256_0[3]/RM_IHPSG13_1P_BITKIT_16x2_SRAM_0[2]/A_LWL<7> RM_IHPSG13_1P_COLUMN_256_0[3]/RM_IHPSG13_1P_BITKIT_16x2_SRAM_2[3]/A_RWL<2>
+ RM_IHPSG13_1P_COLUMN_256_0[3]/RM_IHPSG13_1P_BITKIT_16x2_SRAM_2[3]/A_RWL<11> RM_IHPSG13_1P_COLUMN_256_0[3]/RM_IHPSG13_1P_BITKIT_16x2_SRAM_1[3]/A_RWL<15>
+ RM_IHPSG13_1P_COLUMN_256_0[3]/RM_IHPSG13_1P_BITKIT_16x2_SRAM_0[2]/A_RWL<11> RM_IHPSG13_1P_COLUMN_256_0[3]/RM_IHPSG13_1P_BITKIT_16x2_SRAM_1[3]/A_RWL<3>
+ RM_IHPSG13_1P_COLUMN_256_0[3]/RM_IHPSG13_1P_BITKIT_16x2_SRAM_1[0]/A_LWL<7> RM_IHPSG13_1P_COLUMN_256_0[3]/RM_IHPSG13_1P_BITKIT_16x2_SRAM_0[3]/A_RWL<4>
+ RM_IHPSG13_1P_COLUMN_256_0[3]/RM_IHPSG13_1P_BITKIT_16x2_SRAM_2[3]/A_LWL<6> RM_IHPSG13_1P_COLUMN_256_0[3]/RM_IHPSG13_1P_BITKIT_16x2_SRAM_3[2]/A_LWL<5>
+ RM_IHPSG13_1P_COLUMN_256_0[3]/RM_IHPSG13_1P_BITKIT_16x2_SRAM_0[0]/A_LWL<13> RM_IHPSG13_1P_COLUMN_256_0[3]/RM_IHPSG13_1P_BITKIT_16x2_SRAM_2[2]/A_LWL<6>
+ RM_IHPSG13_1P_COLUMN_256_0[3]/RM_IHPSG13_1P_BITKIT_16x2_SRAM_1[0]/A_RWL<13> RM_IHPSG13_1P_COLUMN_256_0[3]/RM_IHPSG13_1P_BITKIT_16x2_SRAM_2[1]/A_LWL<1>
+ RM_IHPSG13_1P_COLUMN_256_0[3]/RM_IHPSG13_1P_BITKIT_16x2_SRAM_0[3]/A_LWL<5> RM_IHPSG13_1P_COLUMN_256_0[3]/RM_IHPSG13_1P_BITKIT_16x2_SRAM_2[0]/A_LWL<12>
+ RM_IHPSG13_1P_COLUMN_256_0[3]/RM_IHPSG13_1P_BITKIT_16x2_SRAM_3[3]/A_LWL<3> RM_IHPSG13_1P_COLUMN_256_0[3]/RM_IHPSG13_1P_BITKIT_16x2_SRAM_1[2]/A_LWL<7>
+ RM_IHPSG13_1P_COLUMN_256_0[3]/RM_IHPSG13_1P_BITKIT_16x2_SRAM_3[3]/A_RWL<2> RM_IHPSG13_1P_COLUMN_256_0[3]/RM_IHPSG13_1P_BITKIT_16x2_SRAM_0[1]/A_RWL<8>
+ RM_IHPSG13_1P_COLUMN_256_0[3]/RM_IHPSG13_1P_BITKIT_16x2_SRAM_2[3]/A_LWL<4> RM_IHPSG13_1P_COLUMN_256_0[3]/RM_IHPSG13_1P_BITKIT_16x2_SRAM_0[1]/A_RWL<15>
+ RM_IHPSG13_1P_COLUMN_256_0[3]/RM_IHPSG13_1P_BITKIT_16x2_SRAM_3[0]/A_LWL<12> RM_IHPSG13_1P_COLUMN_256_0[3]/RM_IHPSG13_1P_BITKIT_16x2_SRAM_2[0]/A_RWL<8>
+ RM_IHPSG13_1P_COLUMN_256_0[3]/RM_IHPSG13_1P_BITKIT_16x2_SRAM_0[2]/A_LWL<8> RM_IHPSG13_1P_COLUMN_256_0[3]/RM_IHPSG13_1P_BITKIT_16x2_SRAM_2[3]/A_RWL<3>
+ RM_IHPSG13_1P_COLUMN_256_0[3]/RM_IHPSG13_1P_BITKIT_16x2_SRAM_2[0]/A_RWL<2> RM_IHPSG13_1P_COLUMN_256_0[3]/RM_IHPSG13_1P_BITKIT_16x2_SRAM_3[3]/A_RWL<9>
+ RM_IHPSG13_1P_COLUMN_256_0[3]/RM_IHPSG13_1P_BITKIT_16x2_SRAM_0[2]/A_RWL<6> RM_IHPSG13_1P_COLUMN_256_0[3]/RM_IHPSG13_1P_BITKIT_16x2_SRAM_0[1]/A_RWL<1>
+ RM_IHPSG13_1P_COLUMN_256_0[3]/RM_IHPSG13_1P_BITKIT_16x2_SRAM_2[3]/A_RWL<14> RM_IHPSG13_1P_COLUMN_256_0[3]/RM_IHPSG13_1P_BITKIT_16x2_SRAM_0[2]/A_RWL<12>
+ RM_IHPSG13_1P_COLUMN_256_0[3]/RM_IHPSG13_1P_BITKIT_16x2_SRAM_1[3]/A_RWL<4> RM_IHPSG13_1P_COLUMN_256_0[3]/RM_IHPSG13_1P_BITKIT_16x2_SRAM_2[1]/A_RWL<6>
+ RM_IHPSG13_1P_COLUMN_256_0[3]/RM_IHPSG13_1P_BITKIT_16x2_SRAM_2[0]/A_RWL<1> RM_IHPSG13_1P_COLUMN_256_0[7]/RM_IHPSG13_1P_BITKIT_16x2_SRAM_3[3]/VSS
+ RM_IHPSG13_1P_COLUMN_256_0[7]/RM_IHPSG13_1P_BITKIT_16x2_SRAM_3[3]/VDD RM_IHPSG13_1P_COLUMN_256_0[3]/RM_IHPSG13_1P_BITKIT_16x2_SRAM_0[3]/A_RWL<5>
+ RM_IHPSG13_1P_COLUMN_256_0[3]/RM_IHPSG13_1P_BITKIT_16x2_SRAM_3[2]/A_LWL<6> RM_IHPSG13_1P_COLUMN_256
XRM_IHPSG13_1P_COLUMN_256_0[4] RM_IHPSG13_1P_COLUMN_256_0[4]/RM_IHPSG13_1P_BITKIT_16x2_SRAM_0[0]/A_BLT_BOT<0>
+ RM_IHPSG13_1P_COLUMN_256_0[4]/RM_IHPSG13_1P_BITKIT_16x2_SRAM_3[1]/A_LWL<10> RM_IHPSG13_1P_COLUMN_256_0[4]/RM_IHPSG13_1P_BITKIT_16x2_SRAM_3[0]/A_LWL<13>
+ RM_IHPSG13_1P_COLUMN_256_0[4]/RM_IHPSG13_1P_BITKIT_16x2_SRAM_0[0]/A_BLT_BOT<1> RM_IHPSG13_1P_COLUMN_256_0[4]/RM_IHPSG13_1P_BITKIT_16x2_SRAM_1[2]/A_LWL<9>
+ RM_IHPSG13_1P_COLUMN_256_0[4]/RM_IHPSG13_1P_BITKIT_16x2_SRAM_0[0]/A_BLC_BOT<0> RM_IHPSG13_1P_COLUMN_256_0[4]/RM_IHPSG13_1P_BITKIT_16x2_SRAM_3[2]/A_LWL<8>
+ RM_IHPSG13_1P_COLUMN_256_0[4]/RM_IHPSG13_1P_BITKIT_16x2_SRAM_0[3]/A_RWL<11> RM_IHPSG13_1P_COLUMN_256_0[4]/RM_IHPSG13_1P_BITKIT_16x2_SRAM_2[3]/A_RWL<5>
+ RM_IHPSG13_1P_COLUMN_256_0[4]/RM_IHPSG13_1P_BITKIT_16x2_SRAM_0[0]/A_BLC_BOT<1> RM_IHPSG13_1P_COLUMN_256_0[4]/RM_IHPSG13_1P_BITKIT_16x2_SRAM_1[3]/A_LWL<0>
+ RM_IHPSG13_1P_COLUMN_256_0[4]/RM_IHPSG13_1P_BITKIT_16x2_SRAM_3[1]/A_LWL<13> RM_IHPSG13_1P_COLUMN_256_0[4]/RM_IHPSG13_1P_BITKIT_16x2_SRAM_1[3]/A_LWL<3>
+ RM_IHPSG13_1P_COLUMN_256_0[4]/RM_IHPSG13_1P_BITKIT_16x2_SRAM_1[3]/A_RWL<9> RM_IHPSG13_1P_COLUMN_256_0[4]/RM_IHPSG13_1P_BITKIT_16x2_SRAM_2[3]/A_LWL<1>
+ RM_IHPSG13_1P_COLUMN_256_0[4]/RM_IHPSG13_1P_BITKIT_16x2_SRAM_0[0]/A_RWL<1> RM_IHPSG13_1P_COLUMN_256_0[4]/RM_IHPSG13_1P_BITKIT_16x2_SRAM_0[3]/A_LWL<6>
+ RM_IHPSG13_1P_COLUMN_256_0[4]/RM_IHPSG13_1P_BITKIT_16x2_SRAM_2[3]/A_RWL<7> RM_IHPSG13_1P_COLUMN_256_0[4]/RM_IHPSG13_1P_BITKIT_16x2_SRAM_3[2]/A_LWL<13>
+ RM_IHPSG13_1P_COLUMN_256_0[4]/RM_IHPSG13_1P_BITKIT_16x2_SRAM_2[3]/A_LWL<2> RM_IHPSG13_1P_COLUMN_256_0[4]/RM_IHPSG13_1P_BITKIT_16x2_SRAM_3[3]/A_LWL<5>
+ RM_IHPSG13_1P_COLUMN_256_0[4]/RM_IHPSG13_1P_BITKIT_16x2_SRAM_0[2]/A_RWL<14> RM_IHPSG13_1P_COLUMN_256_0[4]/RM_IHPSG13_1P_BITKIT_16x2_SRAM_0[3]/A_LWL<8>
+ RM_IHPSG13_1P_COLUMN_256_0[4]/RM_IHPSG13_1P_BITKIT_16x2_SRAM_3[3]/A_LWL<11> RM_IHPSG13_1P_COLUMN_256_0[4]/RM_IHPSG13_1P_BITKIT_16x2_SRAM_3[0]/A_RWL<12>
+ RM_IHPSG13_1P_COLUMN_256_0[4]/RM_IHPSG13_1P_BITKIT_16x2_SRAM_3[1]/A_RWL<10> RM_IHPSG13_1P_COLUMN_256_0[4]/RM_IHPSG13_1P_BITKIT_16x2_SRAM_0[3]/A_RWL<7>
+ RM_IHPSG13_1P_COLUMN_256_0[4]/RM_IHPSG13_1P_BITKIT_16x2_SRAM_0[3]/A_LWL<2> RM_IHPSG13_1P_COLUMN_256_0[4]/RM_IHPSG13_1P_BITKIT_16x2_SRAM_3[0]/A_RWL<14>
+ RM_IHPSG13_1P_COLUMN_256_0[4]/RM_IHPSG13_1P_BITKIT_16x2_SRAM_1[0]/A_RWL<4> RM_IHPSG13_1P_COLUMN_256_0[4]/RM_IHPSG13_1P_BITKIT_16x2_SRAM_3[2]/A_LWL<11>
+ RM_IHPSG13_1P_COLUMN_256_0[4]/RM_IHPSG13_1P_BITKIT_16x2_SRAM_3[2]/A_LWL<14> RM_IHPSG13_1P_COLUMN_256_0[4]/RM_IHPSG13_1P_BITKIT_16x2_SRAM_2[0]/A_LWL<15>
+ RM_IHPSG13_1P_COLUMN_256_0[4]/RM_IHPSG13_1P_BITKIT_16x2_SRAM_0[0]/A_RWL<5> RM_IHPSG13_1P_COLUMN_256_0[4]/RM_IHPSG13_1P_BITKIT_16x2_SRAM_2[3]/A_LWL<7>
+ RM_IHPSG13_1P_COLUMN_256_0[4]/RM_IHPSG13_1P_BITKIT_16x2_SRAM_1[3]/A_LWL<9> RM_IHPSG13_1P_COLUMN_256_0[4]/RM_IHPSG13_1P_BITKIT_16x2_SRAM_2[1]/A_LWL<12>
+ RM_IHPSG13_1P_COLUMN_256_0[4]/RM_IHPSG13_1P_BITKIT_16x2_SRAM_0[3]/A_LWL<4> RM_IHPSG13_1P_COLUMN_256_0[4]/RM_IHPSG13_1P_BITKIT_16x2_SRAM_3[3]/A_LWL<13>
+ RM_IHPSG13_1P_COLUMN_256_0[4]/RM_IHPSG13_1P_BITKIT_16x2_SRAM_3[1]/A_RWL<12> RM_IHPSG13_1P_COLUMN_256_0[4]/RM_IHPSG13_1P_BITKIT_16x2_SRAM_0[0]/A_RWL<2>
+ RM_IHPSG13_1P_COLUMN_256_0[4]/RM_IHPSG13_1P_BITKIT_16x2_SRAM_0[3]/A_RWL<14> RM_IHPSG13_1P_COLUMN_256_0[4]/RM_IHPSG13_1P_BITKIT_16x2_SRAM_3[0]/A_RWL<10>
+ RM_IHPSG13_1P_COLUMN_256_0[4]/RM_IHPSG13_1P_BITKIT_16x2_SRAM_2[0]/A_RWL<3> RM_IHPSG13_1P_COLUMN_256_0[4]/RM_IHPSG13_1P_BITKIT_16x2_SRAM_3[3]/A_RWL<8>
+ RM_IHPSG13_1P_COLUMN_256_0[4]/RM_IHPSG13_1P_BITKIT_16x2_SRAM_0[0]/A_RWL<6> RM_IHPSG13_1P_COLUMN_256_0[4]/RM_IHPSG13_1P_BITKIT_16x2_SRAM_3[3]/A_LWL<8>
+ RM_IHPSG13_1P_COLUMN_256_0[4]/RM_IHPSG13_1P_BITKIT_16x2_SRAM_2[0]/A_RWL<0> RM_IHPSG13_1P_COLUMN_256_0[4]/RM_IHPSG13_1P_BITKIT_16x2_SRAM_0[0]/A_LWL<1>
+ RM_IHPSG13_1P_COLUMN_256_0[4]/RM_IHPSG13_1P_BITKIT_16x2_SRAM_3[0]/A_RWL<4> RM_IHPSG13_1P_COLUMN_256_0[4]/RM_IHPSG13_1P_BITKIT_16x2_SRAM_2[0]/A_RWL<5>
+ RM_IHPSG13_1P_COLUMN_256_0[4]/RM_IHPSG13_1P_BITKIT_16x2_SRAM_3[3]/A_LWL<14> RM_IHPSG13_1P_COLUMN_256_0[4]/RM_IHPSG13_1P_BITKIT_16x2_SRAM_3[1]/A_LWL<11>
+ RM_IHPSG13_1P_COLUMN_256_0[4]/RM_IHPSG13_1P_BITKIT_16x2_SRAM_2[0]/A_LWL<0> RM_IHPSG13_1P_COLUMN_256_0[4]/RM_IHPSG13_1P_BITKIT_16x2_SRAM_3[2]/A_RWL<10>
+ RM_IHPSG13_1P_COLUMN_256_0[4]/RM_IHPSG13_1P_BITKIT_16x2_SRAM_1[3]/A_LWL<5> RM_IHPSG13_1P_COLUMN_256_0[4]/RM_IHPSG13_1P_BITKIT_16x2_SRAM_3[1]/A_LWL<14>
+ RM_IHPSG13_1P_COLUMN_256_0[4]/RM_IHPSG13_1P_BITKIT_16x2_SRAM_0[3]/A_LWL<7> RM_IHPSG13_1P_COLUMN_256_0[4]/RM_IHPSG13_1P_BITKIT_16x2_SRAM_1[2]/A_LWL<8>
+ RM_IHPSG13_1P_COLUMN_256_0[4]/RM_IHPSG13_1P_BITKIT_16x2_SRAM_3[3]/A_LWL<4> RM_IHPSG13_1P_COLUMN_256_0[4]/RM_IHPSG13_1P_BITKIT_16x2_SRAM_2[2]/A_LWL<7>
+ RM_IHPSG13_1P_COLUMN_256_0[4]/RM_IHPSG13_1P_BITKIT_16x2_SRAM_0[3]/A_RWL<13> RM_IHPSG13_1P_COLUMN_256_0[4]/RM_IHPSG13_1P_BITKIT_16x2_SRAM_1[0]/A_LWL<10>
+ RM_IHPSG13_1P_COLUMN_256_0[4]/RM_IHPSG13_1P_BITKIT_16x2_SRAM_3[0]/A_RWL<2> RM_IHPSG13_1P_COLUMN_256_0[4]/RM_IHPSG13_1P_BITKIT_16x2_SRAM_2[0]/A_RWL<6>
+ RM_IHPSG13_1P_COLUMN_256_0[4]/RM_IHPSG13_1P_BITKIT_16x2_SRAM_3[1]/A_RWL<14> RM_IHPSG13_1P_COLUMN_256_0[4]/RM_IHPSG13_1P_BITKIT_16x2_SRAM_1[3]/A_RWL<8>
+ RM_IHPSG13_1P_COLUMN_256_0[4]/RM_IHPSG13_1P_BITKIT_16x2_SRAM_0[0]/A_RWL<8> RM_IHPSG13_1P_COLUMN_256_0[4]/RM_IHPSG13_1P_BITKIT_16x2_SRAM_0[0]/A_RWL<0>
+ RM_IHPSG13_1P_COLUMN_256_0[4]/RM_IHPSG13_1P_BITKIT_16x2_SRAM_3[3]/A_RWL<6> RM_IHPSG13_1P_COLUMN_256_0[4]/RM_IHPSG13_1P_BITKIT_16x2_SRAM_2[1]/A_LWL<15>
+ RM_IHPSG13_1P_COLUMN_256_0[4]/RM_IHPSG13_1P_BITKIT_16x2_SRAM_2[3]/A_RWL<4> RM_IHPSG13_1P_COLUMN_256_0[4]/RM_IHPSG13_1P_BITKIT_16x2_SRAM_2[0]/A_RWL<7>
+ RM_IHPSG13_1P_COLUMN_256_0[4]/RM_IHPSG13_1P_BITKIT_16x2_SRAM_2[2]/A_LWL<9> RM_IHPSG13_1P_COLUMN_256_0[4]/RM_IHPSG13_1P_BITKIT_16x2_SRAM_2[2]/A_LWL<12>
+ RM_IHPSG13_1P_COLUMN_256_0[4]/RM_IHPSG13_1P_BITKIT_16x2_SRAM_0[1]/A_RWL<0> RM_IHPSG13_1P_COLUMN_256_0[4]/RM_IHPSG13_1P_BITKIT_16x2_SRAM_3[0]/A_LWL<1>
+ RM_IHPSG13_1P_COLUMN_256_0[4]/RM_IHPSG13_1P_BITKIT_16x2_SRAM_2[0]/A_RWL<11> RM_IHPSG13_1P_COLUMN_256_0[4]/RM_IHPSG13_1P_BITKIT_16x2_SRAM_2[0]/A_LWL<2>
+ RM_IHPSG13_1P_COLUMN_256_0[4]/RM_IHPSG13_1P_BITKIT_16x2_SRAM_3[2]/A_RWL<12> RM_IHPSG13_1P_COLUMN_256_0[4]/RM_IHPSG13_1P_BITKIT_16x2_SRAM_3[0]/A_LWL<14>
+ RM_IHPSG13_1P_COLUMN_256_0[4]/RM_IHPSG13_1P_BITKIT_16x2_SRAM_1[0]/A_LWL<3> RM_IHPSG13_1P_COLUMN_256_0[4]/RM_IHPSG13_1P_BITKIT_16x2_SRAM_0[0]/A_LWL<4>
+ RM_IHPSG13_1P_COLUMN_256_0[4]/RM_IHPSG13_1P_BITKIT_16x2_SRAM_0[2]/A_RWL<13> RM_IHPSG13_1P_COLUMN_256_0[4]/RM_IHPSG13_1P_BITKIT_16x2_SRAM_1[0]/A_RWL<9>
+ RM_IHPSG13_1P_COLUMN_256_0[4]/RM_IHPSG13_1P_BITKIT_16x2_SRAM_1[3]/A_LWL<8> RM_IHPSG13_1P_COLUMN_256_0[4]/RM_IHPSG13_1P_BITKIT_16x2_SRAM_3[1]/A_LWL<12>
+ RM_IHPSG13_1P_COLUMN_256_0[4]/RM_IHPSG13_1P_BITKIT_16x2_SRAM_0[0]/A_RWL<7> RM_IHPSG13_1P_COLUMN_256_0[4]/RM_IHPSG13_1P_BITKIT_16x2_SRAM_1[3]/A_RWL<6>
+ RM_IHPSG13_1P_COLUMN_256_0[4]/RM_IHPSG13_1P_BITKIT_16x2_SRAM_1[0]/A_LWL<4> RM_IHPSG13_1P_COLUMN_256_0[4]/RM_IHPSG13_1P_BITKIT_16x2_SRAM_0[0]/A_LWL<2>
+ RM_IHPSG13_1P_COLUMN_256_0[4]/RM_IHPSG13_1P_BITKIT_16x2_SRAM_3[0]/A_RWL<15> RM_IHPSG13_1P_COLUMN_256_0[4]/RM_IHPSG13_1P_BITKIT_16x2_SRAM_3[3]/A_RWL<10>
+ RM_IHPSG13_1P_COLUMN_256_0[4]/RM_IHPSG13_1P_BITKIT_16x2_SRAM_2[1]/A_RWL<0> RM_IHPSG13_1P_COLUMN_256_0[4]/RM_IHPSG13_1P_BITKIT_16x2_SRAM_1[0]/A_LWL<13>
+ RM_IHPSG13_1P_COLUMN_256_0[4]/RM_IHPSG13_1P_BITKIT_16x2_SRAM_1[0]/A_LWL<11> RM_IHPSG13_1P_COLUMN_256_0[4]/RM_IHPSG13_1P_BITKIT_16x2_SRAM_2[3]/A_LWL<10>
+ RM_IHPSG13_1P_COLUMN_256_0[4]/RM_IHPSG13_1P_BITKIT_16x2_SRAM_1[1]/A_LWL<10> RM_IHPSG13_1P_COLUMN_256_0[4]/RM_IHPSG13_1P_BITKIT_16x2_SRAM_0[1]/A_RWL<2>
+ RM_IHPSG13_1P_COLUMN_256_0[4]/RM_IHPSG13_1P_BITKIT_16x2_SRAM_3[0]/A_LWL<3> RM_IHPSG13_1P_COLUMN_256_0[4]/RM_IHPSG13_1P_BITKIT_16x2_SRAM_0[3]/A_LWL<1>
+ RM_IHPSG13_1P_COLUMN_256_0[4]/RM_IHPSG13_1P_BITKIT_16x2_SRAM_3[2]/A_RWL<14> RM_IHPSG13_1P_COLUMN_256_0[4]/RM_IHPSG13_1P_BITKIT_16x2_SRAM_2[3]/A_LWL<0>
+ RM_IHPSG13_1P_COLUMN_256_0[4]/RM_IHPSG13_1P_BITKIT_16x2_SRAM_1[0]/A_LWL<5> RM_IHPSG13_1P_COLUMN_256_0[4]/RM_IHPSG13_1P_BITKIT_16x2_SRAM_3[3]/A_RWL<11>
+ RM_IHPSG13_1P_COLUMN_256_0[4]/RM_IHPSG13_1P_BITKIT_16x2_SRAM_3[3]/A_LWL<6> RM_IHPSG13_1P_COLUMN_256_0[4]/RM_IHPSG13_1P_BITKIT_16x2_SRAM_0[0]/A_LWL<6>
+ RM_IHPSG13_1P_COLUMN_256_0[4]/RM_IHPSG13_1P_BITKIT_16x2_SRAM_3[0]/A_RWL<9> RM_IHPSG13_1P_COLUMN_256_0[4]/RM_IHPSG13_1P_BITKIT_16x2_SRAM_2[3]/A_LWL<9>
+ RM_IHPSG13_1P_COLUMN_256_0[4]/RM_IHPSG13_1P_BITKIT_16x2_SRAM_1[0]/A_LWL<14> RM_IHPSG13_1P_COLUMN_256_0[4]/RM_IHPSG13_1P_BITKIT_16x2_SRAM_2[0]/A_RWL<13>
+ RM_IHPSG13_1P_COLUMN_256_0[4]/RM_IHPSG13_1P_BITKIT_16x2_SRAM_2[2]/A_LWL<15> RM_IHPSG13_1P_COLUMN_256_0[4]/RM_IHPSG13_1P_BITKIT_16x2_SRAM_1[1]/A_LWL<11>
+ RM_IHPSG13_1P_COLUMN_256_0[4]/RM_IHPSG13_1P_BITKIT_16x2_SRAM_3[0]/A_LWL<4> RM_IHPSG13_1P_COLUMN_256_0[4]/RM_IHPSG13_1P_BITKIT_16x2_SRAM_3[0]/A_RWL<8>
+ RM_IHPSG13_1P_COLUMN_256_0[4]/RM_IHPSG13_1P_BITKIT_16x2_SRAM_2[3]/A_LWL<12> RM_IHPSG13_1P_COLUMN_256_0[4]/RM_IHPSG13_1P_BITKIT_16x2_SRAM_2[0]/A_LWL<5>
+ RM_IHPSG13_1P_COLUMN_256_0[4]/RM_IHPSG13_1P_BITKIT_16x2_SRAM_1[1]/A_RWL<1> RM_IHPSG13_1P_COLUMN_256_0[4]/RM_IHPSG13_1P_BITKIT_16x2_SRAM_2[1]/A_RWL<11>
+ RM_IHPSG13_1P_COLUMN_256_0[4]/RM_IHPSG13_1P_BITKIT_16x2_SRAM_3[1]/A_RWL<1> RM_IHPSG13_1P_COLUMN_256_0[4]/RM_IHPSG13_1P_BITKIT_16x2_SRAM_3[0]/A_RWL<1>
+ RM_IHPSG13_1P_COLUMN_256_0[4]/RM_IHPSG13_1P_BITKIT_16x2_SRAM_3[3]/A_RWL<12> RM_IHPSG13_1P_COLUMN_256_0[4]/RM_IHPSG13_1P_BITKIT_16x2_SRAM_2[1]/A_RWL<2>
+ RM_IHPSG13_1P_COLUMN_256_0[4]/RM_IHPSG13_1P_BITKIT_16x2_SRAM_1[1]/A_RWL<3> RM_IHPSG13_1P_COLUMN_256_0[4]/RM_IHPSG13_1P_BITKIT_16x2_SRAM_3[3]/A_LWL<1>
+ RM_IHPSG13_1P_COLUMN_256_0[4]/RM_IHPSG13_1P_BITKIT_16x2_SRAM_2[2]/A_LWL<10> RM_IHPSG13_1P_COLUMN_256_0[4]/RM_IHPSG13_1P_BITKIT_16x2_SRAM_3[2]/A_LWL<12>
+ RM_IHPSG13_1P_COLUMN_256_0[4]/RM_IHPSG13_1P_BITKIT_16x2_SRAM_2[0]/A_RWL<15> RM_IHPSG13_1P_COLUMN_256_0[4]/RM_IHPSG13_1P_BITKIT_16x2_SRAM_2[0]/A_LWL<6>
+ RM_IHPSG13_1P_COLUMN_256_0[4]/RM_IHPSG13_1P_BITKIT_16x2_SRAM_3[2]/A_RWL<11> RM_IHPSG13_1P_COLUMN_256_0[4]/RM_IHPSG13_1P_BITKIT_16x2_SRAM_3[1]/A_RWL<15>
+ RM_IHPSG13_1P_COLUMN_256_0[4]/RM_IHPSG13_1P_BITKIT_16x2_SRAM_0[0]/A_LWL<7> RM_IHPSG13_1P_COLUMN_256_0[4]/RM_IHPSG13_1P_BITKIT_16x2_SRAM_1[3]/A_LWL<6>
+ RM_IHPSG13_1P_COLUMN_256_0[4]/RM_IHPSG13_1P_BITKIT_16x2_SRAM_3[1]/A_RWL<2> RM_IHPSG13_1P_COLUMN_256_0[4]/RM_IHPSG13_1P_BITKIT_16x2_SRAM_2[1]/A_RWL<3>
+ RM_IHPSG13_1P_COLUMN_256_0[4]/RM_IHPSG13_1P_BITKIT_16x2_SRAM_2[3]/A_LWL<3> RM_IHPSG13_1P_COLUMN_256_0[4]/RM_IHPSG13_1P_BITKIT_16x2_SRAM_1[1]/A_RWL<4>
+ RM_IHPSG13_1P_COLUMN_256_0[4]/RM_IHPSG13_1P_BITKIT_16x2_SRAM_0[0]/A_LWL<0> RM_IHPSG13_1P_COLUMN_256_0[4]/RM_IHPSG13_1P_BITKIT_16x2_SRAM_1[1]/A_LWL<13>
+ RM_IHPSG13_1P_COLUMN_256_0[4]/RM_IHPSG13_1P_BITKIT_16x2_SRAM_1[0]/A_RWL<8> RM_IHPSG13_1P_COLUMN_256_0[4]/RM_IHPSG13_1P_BITKIT_16x2_SRAM_0[1]/A_RWL<5>
+ RM_IHPSG13_1P_COLUMN_256_0[4]/RM_IHPSG13_1P_BITKIT_16x2_SRAM_2[3]/A_RWL<9> RM_IHPSG13_1P_COLUMN_256_0[4]/RM_IHPSG13_1P_BITKIT_16x2_SRAM_2[0]/A_LWL<7>
+ RM_IHPSG13_1P_COLUMN_256_0[4]/RM_IHPSG13_1P_BITKIT_16x2_SRAM_1[2]/A_LWL<10> RM_IHPSG13_1P_COLUMN_256_0[4]/RM_IHPSG13_1P_BITKIT_16x2_SRAM_1[0]/A_RWL<1>
+ RM_IHPSG13_1P_COLUMN_256_0[4]/RM_IHPSG13_1P_BITKIT_16x2_SRAM_2[1]/A_RWL<13> RM_IHPSG13_1P_COLUMN_256_0[4]/RM_IHPSG13_1P_BITKIT_16x2_SRAM_3[0]/A_RWL<6>
+ RM_IHPSG13_1P_COLUMN_256_0[4]/RM_IHPSG13_1P_BITKIT_16x2_SRAM_1[0]/A_LWL<8> RM_IHPSG13_1P_COLUMN_256_0[4]/RM_IHPSG13_1P_BITKIT_16x2_SRAM_0[2]/A_RWL<15>
+ RM_IHPSG13_1P_COLUMN_256_0[4]/RM_IHPSG13_1P_BITKIT_16x2_SRAM_3[3]/A_LWL<15> RM_IHPSG13_1P_COLUMN_256_0[4]/RM_IHPSG13_1P_BITKIT_16x2_SRAM_0[1]/A_RWL<4>
+ RM_IHPSG13_1P_COLUMN_256_0[4]/RM_IHPSG13_1P_BITKIT_16x2_SRAM_3[3]/A_RWL<14> RM_IHPSG13_1P_COLUMN_256_0[4]/RM_IHPSG13_1P_BITKIT_16x2_SRAM_0[0]/A_LWL<9>
+ RM_IHPSG13_1P_COLUMN_256_0[4]/RM_IHPSG13_1P_BITKIT_16x2_SRAM_2[1]/A_RWL<4> RM_IHPSG13_1P_COLUMN_256_0[4]/RM_IHPSG13_1P_BITKIT_16x2_SRAM_2[0]/A_RWL<4>
+ RM_IHPSG13_1P_COLUMN_256_0[4]/RM_IHPSG13_1P_BITKIT_16x2_SRAM_3[3]/A_RWL<5> RM_IHPSG13_1P_COLUMN_256_0[4]/RM_IHPSG13_1P_BITKIT_16x2_SRAM_2[1]/A_LWL<10>
+ RM_IHPSG13_1P_COLUMN_256_0[4]/RM_IHPSG13_1P_BITKIT_16x2_SRAM_1[1]/A_LWL<14> RM_IHPSG13_1P_COLUMN_256_0[4]/RM_IHPSG13_1P_BITKIT_16x2_SRAM_0[1]/A_RWL<6>
+ RM_IHPSG13_1P_COLUMN_256_0[4]/RM_IHPSG13_1P_BITKIT_16x2_SRAM_2[3]/A_LWL<15> RM_IHPSG13_1P_COLUMN_256_0[4]/RM_IHPSG13_1P_BITKIT_16x2_SRAM_2[0]/A_LWL<8>
+ RM_IHPSG13_1P_COLUMN_256_0[4]/RM_IHPSG13_1P_BITKIT_16x2_SRAM_3[1]/A_RWL<11> RM_IHPSG13_1P_COLUMN_256_0[4]/RM_IHPSG13_1P_BITKIT_16x2_SRAM_1[2]/A_LWL<11>
+ RM_IHPSG13_1P_COLUMN_256_0[4]/RM_IHPSG13_1P_BITKIT_16x2_SRAM_0[1]/A_LWL<1> RM_IHPSG13_1P_COLUMN_256_0[4]/RM_IHPSG13_1P_BITKIT_16x2_SRAM_1[0]/A_RWL<10>
+ RM_IHPSG13_1P_COLUMN_256_0[4]/RM_IHPSG13_1P_BITKIT_16x2_SRAM_1[0]/A_LWL<1> RM_IHPSG13_1P_COLUMN_256_0[4]/RM_IHPSG13_1P_BITKIT_16x2_SRAM_0[3]/A_LWL<3>
+ RM_IHPSG13_1P_COLUMN_256_0[4]/RM_IHPSG13_1P_BITKIT_16x2_SRAM_2[1]/A_RWL<5> RM_IHPSG13_1P_COLUMN_256_0[4]/RM_IHPSG13_1P_BITKIT_16x2_SRAM_3[0]/A_LWL<0>
+ RM_IHPSG13_1P_COLUMN_256_0[4]/RM_IHPSG13_1P_BITKIT_16x2_SRAM_2[2]/A_RWL<11> RM_IHPSG13_1P_COLUMN_256_0[4]/RM_IHPSG13_1P_BITKIT_16x2_SRAM_3[3]/A_LWL<12>
+ RM_IHPSG13_1P_COLUMN_256_0[4]/RM_IHPSG13_1P_BITKIT_16x2_SRAM_1[1]/A_RWL<6> RM_IHPSG13_1P_COLUMN_256_0[4]/RM_IHPSG13_1P_BITKIT_16x2_SRAM_0[3]/A_RWL<9>
+ RM_IHPSG13_1P_COLUMN_256_0[4]/RM_IHPSG13_1P_BITKIT_16x2_SRAM_2[1]/A_LWL<0> RM_IHPSG13_1P_COLUMN_256_0[4]/RM_IHPSG13_1P_BITKIT_16x2_SRAM_0[1]/A_RWL<7>
+ RM_IHPSG13_1P_COLUMN_256_0[4]/RM_IHPSG13_1P_BITKIT_16x2_SRAM_3[2]/A_RWL<15> RM_IHPSG13_1P_COLUMN_256_0[4]/RM_IHPSG13_1P_BITKIT_16x2_SRAM_2[0]/A_LWL<9>
+ RM_IHPSG13_1P_COLUMN_256_0[4]/RM_IHPSG13_1P_BITKIT_16x2_SRAM_1[0]/A_RWL<6> RM_IHPSG13_1P_COLUMN_256_0[4]/RM_IHPSG13_1P_BITKIT_16x2_SRAM_2[1]/A_RWL<15>
+ RM_IHPSG13_1P_COLUMN_256_0[4]/RM_IHPSG13_1P_BITKIT_16x2_SRAM_0[1]/A_LWL<2> RM_IHPSG13_1P_COLUMN_256_0[4]/RM_IHPSG13_1P_BITKIT_16x2_SRAM_3[2]/A_LWL<15>
+ RM_IHPSG13_1P_COLUMN_256_0[4]/RM_IHPSG13_1P_BITKIT_16x2_SRAM_0[0]/A_RWL<4> RM_IHPSG13_1P_COLUMN_256_0[4]/RM_IHPSG13_1P_BITKIT_16x2_SRAM_1[3]/A_RWL<5>
+ RM_IHPSG13_1P_COLUMN_256_0[4]/RM_IHPSG13_1P_BITKIT_16x2_SRAM_0[1]/A_LWL<0> RM_IHPSG13_1P_COLUMN_256_0[4]/RM_IHPSG13_1P_BITKIT_16x2_SRAM_2[0]/A_LWL<10>
+ RM_IHPSG13_1P_COLUMN_256_0[4]/RM_IHPSG13_1P_BITKIT_16x2_SRAM_3[0]/A_LWL<9> RM_IHPSG13_1P_COLUMN_256_0[4]/RM_IHPSG13_1P_BITKIT_16x2_SRAM_0[0]/A_LWL<12>
+ RM_IHPSG13_1P_COLUMN_256_0[4]/RM_IHPSG13_1P_BITKIT_16x2_SRAM_0[0]/A_RWL<3> RM_IHPSG13_1P_COLUMN_256_0[4]/RM_IHPSG13_1P_BITKIT_16x2_SRAM_0[3]/A_RWL<15>
+ RM_IHPSG13_1P_COLUMN_256_0[4]/RM_IHPSG13_1P_BITKIT_16x2_SRAM_3[0]/A_RWL<11> RM_IHPSG13_1P_COLUMN_256_0[4]/RM_IHPSG13_1P_BITKIT_16x2_SRAM_1[2]/A_LWL<13>
+ RM_IHPSG13_1P_COLUMN_256_0[4]/RM_IHPSG13_1P_BITKIT_16x2_SRAM_1[0]/A_RWL<12> RM_IHPSG13_1P_COLUMN_256_0[4]/RM_IHPSG13_1P_BITKIT_16x2_SRAM_3[1]/A_RWL<6>
+ RM_IHPSG13_1P_COLUMN_256_0[4]/RM_IHPSG13_1P_BITKIT_16x2_SRAM_3[0]/A_LWL<6> RM_IHPSG13_1P_COLUMN_256_0[4]/RM_IHPSG13_1P_BITKIT_16x2_SRAM_2[1]/A_RWL<7>
+ RM_IHPSG13_1P_COLUMN_256_0[4]/RM_IHPSG13_1P_BITKIT_16x2_SRAM_2[2]/A_RWL<13> RM_IHPSG13_1P_COLUMN_256_0[4]/RM_IHPSG13_1P_BITKIT_16x2_SRAM_0[2]/A_RWL<0>
+ RM_IHPSG13_1P_COLUMN_256_0[4]/RM_IHPSG13_1P_BITKIT_16x2_SRAM_3[1]/A_LWL<1> RM_IHPSG13_1P_COLUMN_256_0[4]/RM_IHPSG13_1P_BITKIT_16x2_SRAM_1[1]/A_RWL<8>
+ RM_IHPSG13_1P_COLUMN_256_0[4]/RM_IHPSG13_1P_BITKIT_16x2_SRAM_2[1]/A_LWL<2> RM_IHPSG13_1P_COLUMN_256_0[4]/RM_IHPSG13_1P_BITKIT_16x2_SRAM_1[1]/A_LWL<3>
+ RM_IHPSG13_1P_COLUMN_256_0[4]/RM_IHPSG13_1P_BITKIT_16x2_SRAM_1[1]/A_LWL<1> RM_IHPSG13_1P_COLUMN_256_0[4]/RM_IHPSG13_1P_BITKIT_16x2_SRAM_1[2]/A_LWL<14>
+ RM_IHPSG13_1P_COLUMN_256_0[4]/RM_IHPSG13_1P_BITKIT_16x2_SRAM_1[0]/A_LWL<12> RM_IHPSG13_1P_COLUMN_256_0[4]/RM_IHPSG13_1P_BITKIT_16x2_SRAM_0[1]/A_LWL<10>
+ RM_IHPSG13_1P_COLUMN_256_0[4]/RM_IHPSG13_1P_BITKIT_16x2_SRAM_0[1]/A_LWL<4> RM_IHPSG13_1P_COLUMN_256_0[4]/RM_IHPSG13_1P_BITKIT_16x2_SRAM_1[3]/A_LWL<4>
+ RM_IHPSG13_1P_COLUMN_256_0[4]/RM_IHPSG13_1P_BITKIT_16x2_SRAM_3[1]/A_LWL<0> RM_IHPSG13_1P_COLUMN_256_0[4]/RM_IHPSG13_1P_BITKIT_16x2_SRAM_3[1]/A_LWL<15>
+ RM_IHPSG13_1P_COLUMN_256_0[4]/RM_IHPSG13_1P_BITKIT_16x2_SRAM_1[3]/A_LWL<11> RM_IHPSG13_1P_COLUMN_256_0[4]/RM_IHPSG13_1P_BITKIT_16x2_SRAM_1[0]/A_RWL<2>
+ RM_IHPSG13_1P_COLUMN_256_0[4]/RM_IHPSG13_1P_BITKIT_16x2_SRAM_1[1]/A_RWL<10> RM_IHPSG13_1P_COLUMN_256_0[4]/RM_IHPSG13_1P_BITKIT_16x2_SRAM_3[1]/A_RWL<5>
+ RM_IHPSG13_1P_COLUMN_256_0[4]/RM_IHPSG13_1P_BITKIT_16x2_SRAM_0[0]/A_LWL<10> RM_IHPSG13_1P_COLUMN_256_0[4]/RM_IHPSG13_1P_BITKIT_16x2_SRAM_0[3]/A_RWL<12>
+ RM_IHPSG13_1P_COLUMN_256_0[4]/RM_IHPSG13_1P_BITKIT_16x2_SRAM_3[0]/A_RWL<3> RM_IHPSG13_1P_COLUMN_256_0[4]/RM_IHPSG13_1P_BITKIT_16x2_SRAM_1[1]/A_RWL<9>
+ RM_IHPSG13_1P_COLUMN_256_0[4]/RM_IHPSG13_1P_BITKIT_16x2_SRAM_3[3]/A_RWL<15> RM_IHPSG13_1P_COLUMN_256_0[4]/RM_IHPSG13_1P_BITKIT_16x2_SRAM_2[2]/A_RWL<12>
+ RM_IHPSG13_1P_COLUMN_256_0[4]/RM_IHPSG13_1P_BITKIT_16x2_SRAM_2[1]/A_LWL<3> RM_IHPSG13_1P_COLUMN_256_0[4]/RM_IHPSG13_1P_BITKIT_16x2_SRAM_1[0]/A_RWL<11>
+ RM_IHPSG13_1P_COLUMN_256_0[4]/RM_IHPSG13_1P_BITKIT_16x2_SRAM_2[3]/A_RWL<10> RM_IHPSG13_1P_COLUMN_256_0[4]/RM_IHPSG13_1P_BITKIT_16x2_SRAM_1[1]/A_LWL<4>
+ RM_IHPSG13_1P_COLUMN_256_0[4]/RM_IHPSG13_1P_BITKIT_16x2_SRAM_1[2]/A_LWL<15> RM_IHPSG13_1P_COLUMN_256_0[4]/RM_IHPSG13_1P_BITKIT_16x2_SRAM_2[2]/A_RWL<0>
+ RM_IHPSG13_1P_COLUMN_256_0[4]/RM_IHPSG13_1P_BITKIT_16x2_SRAM_1[0]/A_LWL<6> RM_IHPSG13_1P_COLUMN_256_0[4]/RM_IHPSG13_1P_BITKIT_16x2_SRAM_1[0]/A_RWL<14>
+ RM_IHPSG13_1P_COLUMN_256_0[4]/RM_IHPSG13_1P_BITKIT_16x2_SRAM_3[1]/A_RWL<8> RM_IHPSG13_1P_COLUMN_256_0[4]/RM_IHPSG13_1P_BITKIT_16x2_SRAM_3[3]/A_RWL<7>
+ RM_IHPSG13_1P_COLUMN_256_0[4]/RM_IHPSG13_1P_BITKIT_16x2_SRAM_1[2]/A_RWL<1> RM_IHPSG13_1P_COLUMN_256_0[4]/RM_IHPSG13_1P_BITKIT_16x2_SRAM_0[1]/A_LWL<3>
+ RM_IHPSG13_1P_COLUMN_256_0[4]/RM_IHPSG13_1P_BITKIT_16x2_SRAM_2[1]/A_RWL<9> RM_IHPSG13_1P_COLUMN_256_0[4]/RM_IHPSG13_1P_BITKIT_16x2_SRAM_2[2]/A_RWL<15>
+ RM_IHPSG13_1P_COLUMN_256_0[4]/RM_IHPSG13_1P_BITKIT_16x2_SRAM_1[1]/A_RWL<11> RM_IHPSG13_1P_COLUMN_256_0[4]/RM_IHPSG13_1P_BITKIT_16x2_SRAM_2[0]/A_LWL<3>
+ RM_IHPSG13_1P_COLUMN_256_0[4]/RM_IHPSG13_1P_BITKIT_16x2_SRAM_0[2]/A_RWL<2> RM_IHPSG13_1P_COLUMN_256_0[4]/RM_IHPSG13_1P_BITKIT_16x2_SRAM_3[1]/A_LWL<3>
+ RM_IHPSG13_1P_COLUMN_256_0[4]/RM_IHPSG13_1P_BITKIT_16x2_SRAM_0[2]/A_LWL<9> RM_IHPSG13_1P_COLUMN_256_0[4]/RM_IHPSG13_1P_BITKIT_16x2_SRAM_2[0]/A_LWL<13>
+ RM_IHPSG13_1P_COLUMN_256_0[4]/RM_IHPSG13_1P_BITKIT_16x2_SRAM_3[3]/A_LWL<2> RM_IHPSG13_1P_COLUMN_256_0[4]/RM_IHPSG13_1P_BITKIT_16x2_SRAM_0[1]/A_RWL<3>
+ RM_IHPSG13_1P_COLUMN_256_0[4]/RM_IHPSG13_1P_BITKIT_16x2_SRAM_0[1]/A_RWL<9> RM_IHPSG13_1P_COLUMN_256_0[4]/RM_IHPSG13_1P_BITKIT_16x2_SRAM_2[3]/A_RWL<12>
+ RM_IHPSG13_1P_COLUMN_256_0[4]/RM_IHPSG13_1P_BITKIT_16x2_SRAM_2[3]/A_LWL<5> RM_IHPSG13_1P_COLUMN_256_0[4]/RM_IHPSG13_1P_BITKIT_16x2_SRAM_2[2]/A_LWL<8>
+ RM_IHPSG13_1P_COLUMN_256_0[4]/RM_IHPSG13_1P_BITKIT_16x2_SRAM_0[0]/A_LWL<15> RM_IHPSG13_1P_COLUMN_256_0[4]/RM_IHPSG13_1P_BITKIT_16x2_SRAM_2[0]/A_RWL<9>
+ RM_IHPSG13_1P_COLUMN_256_0[4]/RM_IHPSG13_1P_BITKIT_16x2_SRAM_1[1]/A_LWL<5> RM_IHPSG13_1P_COLUMN_256_0[4]/RM_IHPSG13_1P_BITKIT_16x2_SRAM_3[2]/A_RWL<0>
+ RM_IHPSG13_1P_COLUMN_256_0[4]/RM_IHPSG13_1P_BITKIT_16x2_SRAM_1[1]/A_LWL<15> RM_IHPSG13_1P_COLUMN_256_0[4]/RM_IHPSG13_1P_BITKIT_16x2_SRAM_0[1]/A_LWL<12>
+ RM_IHPSG13_1P_COLUMN_256_0[4]/RM_IHPSG13_1P_BITKIT_16x2_SRAM_0[1]/A_LWL<6> RM_IHPSG13_1P_COLUMN_256_0[4]/RM_IHPSG13_1P_BITKIT_16x2_SRAM_3[0]/A_LWL<15>
+ RM_IHPSG13_1P_COLUMN_256_0[4]/RM_IHPSG13_1P_BITKIT_16x2_SRAM_3[1]/A_RWL<9> RM_IHPSG13_1P_COLUMN_256_0[4]/RM_IHPSG13_1P_BITKIT_16x2_SRAM_1[3]/A_LWL<13>
+ RM_IHPSG13_1P_COLUMN_256_0[4]/RM_IHPSG13_1P_BITKIT_16x2_SRAM_1[1]/A_RWL<5> RM_IHPSG13_1P_COLUMN_256_0[4]/RM_IHPSG13_1P_BITKIT_16x2_SRAM_1[1]/A_RWL<12>
+ RM_IHPSG13_1P_COLUMN_256_0[4]/RM_IHPSG13_1P_BITKIT_16x2_SRAM_3[0]/A_RWL<5> RM_IHPSG13_1P_COLUMN_256_0[4]/RM_IHPSG13_1P_BITKIT_16x2_SRAM_3[1]/A_LWL<4>
+ RM_IHPSG13_1P_COLUMN_256_0[4]/RM_IHPSG13_1P_BITKIT_16x2_SRAM_2[3]/A_RWL<13> RM_IHPSG13_1P_COLUMN_256_0[4]/RM_IHPSG13_1P_BITKIT_16x2_SRAM_2[1]/A_RWL<12>
+ RM_IHPSG13_1P_COLUMN_256_0[4]/RM_IHPSG13_1P_BITKIT_16x2_SRAM_2[1]/A_LWL<5> RM_IHPSG13_1P_COLUMN_256_0[4]/RM_IHPSG13_1P_BITKIT_16x2_SRAM_0[3]/A_RWL<10>
+ RM_IHPSG13_1P_COLUMN_256_0[4]/RM_IHPSG13_1P_BITKIT_16x2_SRAM_1[1]/A_LWL<12> RM_IHPSG13_1P_COLUMN_256_0[4]/RM_IHPSG13_1P_BITKIT_16x2_SRAM_2[2]/A_RWL<10>
+ RM_IHPSG13_1P_COLUMN_256_0[4]/RM_IHPSG13_1P_BITKIT_16x2_SRAM_1[1]/A_LWL<6> RM_IHPSG13_1P_COLUMN_256_0[4]/RM_IHPSG13_1P_BITKIT_16x2_SRAM_3[2]/A_RWL<1>
+ RM_IHPSG13_1P_COLUMN_256_0[4]/RM_IHPSG13_1P_BITKIT_16x2_SRAM_0[1]/A_LWL<13> RM_IHPSG13_1P_COLUMN_256_0[4]/RM_IHPSG13_1P_BITKIT_16x2_SRAM_1[3]/A_RWL<7>
+ RM_IHPSG13_1P_COLUMN_256_0[4]/RM_IHPSG13_1P_BITKIT_16x2_SRAM_0[1]/A_LWL<7> RM_IHPSG13_1P_COLUMN_256_0[4]/RM_IHPSG13_1P_BITKIT_16x2_SRAM_2[2]/A_RWL<2>
+ RM_IHPSG13_1P_COLUMN_256_0[4]/RM_IHPSG13_1P_BITKIT_16x2_SRAM_1[1]/A_RWL<2> RM_IHPSG13_1P_COLUMN_256_0[4]/RM_IHPSG13_1P_BITKIT_16x2_SRAM_1[2]/A_RWL<0>
+ RM_IHPSG13_1P_COLUMN_256_0[4]/RM_IHPSG13_1P_BITKIT_16x2_SRAM_1[0]/A_RWL<15> RM_IHPSG13_1P_COLUMN_256_0[4]/RM_IHPSG13_1P_BITKIT_16x2_SRAM_3[2]/A_LWL<9>
+ RM_IHPSG13_1P_COLUMN_256_0[4]/RM_IHPSG13_1P_BITKIT_16x2_SRAM_1[3]/A_LWL<14> RM_IHPSG13_1P_COLUMN_256_0[4]/RM_IHPSG13_1P_BITKIT_16x2_SRAM_3[1]/A_RWL<0>
+ RM_IHPSG13_1P_COLUMN_256_0[4]/RM_IHPSG13_1P_BITKIT_16x2_SRAM_3[1]/A_RWL<3> RM_IHPSG13_1P_COLUMN_256_0[4]/RM_IHPSG13_1P_BITKIT_16x2_SRAM_0[0]/A_LWL<3>
+ RM_IHPSG13_1P_COLUMN_256_0[4]/RM_IHPSG13_1P_BITKIT_16x2_SRAM_1[2]/A_RWL<3> RM_IHPSG13_1P_COLUMN_256_0[4]/RM_IHPSG13_1P_BITKIT_16x2_SRAM_0[2]/A_LWL<10>
+ RM_IHPSG13_1P_COLUMN_256_0[4]/RM_IHPSG13_1P_BITKIT_16x2_SRAM_1[3]/A_LWL<2> RM_IHPSG13_1P_COLUMN_256_0[4]/RM_IHPSG13_1P_BITKIT_16x2_SRAM_0[2]/A_RWL<4>
+ RM_IHPSG13_1P_COLUMN_256_0[4]/RM_IHPSG13_1P_BITKIT_16x2_SRAM_0[0]/A_RWL<9> RM_IHPSG13_1P_COLUMN_256_0[4]/RM_IHPSG13_1P_BITKIT_16x2_SRAM_2[1]/A_LWL<6>
+ RM_IHPSG13_1P_COLUMN_256_0[4]/RM_IHPSG13_1P_BITKIT_16x2_SRAM_1[2]/A_RWL<10> RM_IHPSG13_1P_COLUMN_256_0[4]/RM_IHPSG13_1P_BITKIT_16x2_SRAM_2[3]/A_LWL<11>
+ RM_IHPSG13_1P_COLUMN_256_0[4]/RM_IHPSG13_1P_BITKIT_16x2_SRAM_3[2]/A_RWL<2> RM_IHPSG13_1P_COLUMN_256_0[4]/RM_IHPSG13_1P_BITKIT_16x2_SRAM_1[0]/A_LWL<15>
+ RM_IHPSG13_1P_COLUMN_256_0[4]/RM_IHPSG13_1P_BITKIT_16x2_SRAM_0[3]/A_LWL<0> RM_IHPSG13_1P_COLUMN_256_0[4]/RM_IHPSG13_1P_BITKIT_16x2_SRAM_2[3]/A_LWL<14>
+ RM_IHPSG13_1P_COLUMN_256_0[4]/RM_IHPSG13_1P_BITKIT_16x2_SRAM_2[2]/A_RWL<3> RM_IHPSG13_1P_COLUMN_256_0[4]/RM_IHPSG13_1P_BITKIT_16x2_SRAM_0[0]/A_LWL<5>
+ RM_IHPSG13_1P_COLUMN_256_0[4]/RM_IHPSG13_1P_BITKIT_16x2_SRAM_1[3]/A_LWL<15> RM_IHPSG13_1P_COLUMN_256_0[4]/RM_IHPSG13_1P_BITKIT_16x2_SRAM_1[0]/A_RWL<5>
+ RM_IHPSG13_1P_COLUMN_256_0[4]/RM_IHPSG13_1P_BITKIT_16x2_SRAM_2[1]/A_LWL<13> RM_IHPSG13_1P_COLUMN_256_0[4]/RM_IHPSG13_1P_BITKIT_16x2_SRAM_0[3]/A_LWL<9>
+ RM_IHPSG13_1P_COLUMN_256_0[4]/RM_IHPSG13_1P_BITKIT_16x2_SRAM_0[2]/A_RWL<3> RM_IHPSG13_1P_COLUMN_256_0[4]/RM_IHPSG13_1P_BITKIT_16x2_SRAM_3[3]/A_LWL<7>
+ RM_IHPSG13_1P_COLUMN_256_0[4]/RM_IHPSG13_1P_BITKIT_16x2_SRAM_2[0]/A_LWL<4> RM_IHPSG13_1P_COLUMN_256_0[4]/RM_IHPSG13_1P_BITKIT_16x2_SRAM_1[1]/A_RWL<14>
+ RM_IHPSG13_1P_COLUMN_256_0[4]/RM_IHPSG13_1P_BITKIT_16x2_SRAM_0[2]/A_RWL<5> RM_IHPSG13_1P_COLUMN_256_0[4]/RM_IHPSG13_1P_BITKIT_16x2_SRAM_2[3]/A_LWL<8>
+ RM_IHPSG13_1P_COLUMN_256_0[4]/RM_IHPSG13_1P_BITKIT_16x2_SRAM_3[1]/A_LWL<6> RM_IHPSG13_1P_COLUMN_256_0[4]/RM_IHPSG13_1P_BITKIT_16x2_SRAM_2[0]/A_RWL<12>
+ RM_IHPSG13_1P_COLUMN_256_0[4]/RM_IHPSG13_1P_BITKIT_16x2_SRAM_2[3]/A_RWL<15> RM_IHPSG13_1P_COLUMN_256_0[4]/RM_IHPSG13_1P_BITKIT_16x2_SRAM_1[2]/A_RWL<11>
+ RM_IHPSG13_1P_COLUMN_256_0[4]/RM_IHPSG13_1P_BITKIT_16x2_SRAM_2[1]/A_LWL<7> RM_IHPSG13_1P_COLUMN_256_0[4]/RM_IHPSG13_1P_BITKIT_16x2_SRAM_2[0]/A_RWL<14>
+ RM_IHPSG13_1P_COLUMN_256_0[4]/RM_IHPSG13_1P_BITKIT_16x2_SRAM_3[3]/A_RWL<13> RM_IHPSG13_1P_COLUMN_256_0[4]/RM_IHPSG13_1P_BITKIT_16x2_SRAM_0[2]/A_LWL<0>
+ RM_IHPSG13_1P_COLUMN_256_0[4]/RM_IHPSG13_1P_BITKIT_16x2_SRAM_2[1]/A_RWL<10> RM_IHPSG13_1P_COLUMN_256_0[4]/RM_IHPSG13_1P_BITKIT_16x2_SRAM_1[1]/A_LWL<8>
+ RM_IHPSG13_1P_COLUMN_256_0[4]/RM_IHPSG13_1P_BITKIT_16x2_SRAM_0[1]/A_LWL<15> RM_IHPSG13_1P_COLUMN_256_0[4]/RM_IHPSG13_1P_BITKIT_16x2_SRAM_0[1]/A_LWL<9>
+ RM_IHPSG13_1P_COLUMN_256_0[4]/RM_IHPSG13_1P_BITKIT_16x2_SRAM_2[2]/A_RWL<4> RM_IHPSG13_1P_COLUMN_256_0[4]/RM_IHPSG13_1P_BITKIT_16x2_SRAM_1[1]/A_RWL<0>
+ RM_IHPSG13_1P_COLUMN_256_0[4]/RM_IHPSG13_1P_BITKIT_16x2_SRAM_3[1]/A_RWL<7> RM_IHPSG13_1P_COLUMN_256_0[4]/RM_IHPSG13_1P_BITKIT_16x2_SRAM_3[0]/A_RWL<0>
+ RM_IHPSG13_1P_COLUMN_256_0[4]/RM_IHPSG13_1P_BITKIT_16x2_SRAM_1[2]/A_RWL<5> RM_IHPSG13_1P_COLUMN_256_0[4]/RM_IHPSG13_1P_BITKIT_16x2_SRAM_0[2]/A_LWL<12>
+ RM_IHPSG13_1P_COLUMN_256_0[4]/RM_IHPSG13_1P_BITKIT_16x2_SRAM_0[0]/A_RWL<11> RM_IHPSG13_1P_COLUMN_256_0[4]/RM_IHPSG13_1P_BITKIT_16x2_SRAM_1[3]/A_LWL<1>
+ RM_IHPSG13_1P_COLUMN_256_0[4]/RM_IHPSG13_1P_BITKIT_16x2_SRAM_3[1]/A_LWL<2> RM_IHPSG13_1P_COLUMN_256_0[4]/RM_IHPSG13_1P_BITKIT_16x2_SRAM_1[2]/A_LWL<12>
+ RM_IHPSG13_1P_COLUMN_256_0[4]/RM_IHPSG13_1P_BITKIT_16x2_SRAM_1[2]/A_LWL<0> RM_IHPSG13_1P_COLUMN_256_0[4]/RM_IHPSG13_1P_BITKIT_16x2_SRAM_3[3]/A_LWL<0>
+ RM_IHPSG13_1P_COLUMN_256_0[4]/RM_IHPSG13_1P_BITKIT_16x2_SRAM_1[2]/A_RWL<12> RM_IHPSG13_1P_COLUMN_256_0[4]/RM_IHPSG13_1P_BITKIT_16x2_SRAM_2[1]/A_LWL<8>
+ RM_IHPSG13_1P_COLUMN_256_0[4]/RM_IHPSG13_1P_BITKIT_16x2_SRAM_2[2]/A_LWL<11> RM_IHPSG13_1P_COLUMN_256_0[4]/RM_IHPSG13_1P_BITKIT_16x2_SRAM_0[2]/A_LWL<1>
+ RM_IHPSG13_1P_COLUMN_256_0[4]/RM_IHPSG13_1P_BITKIT_16x2_SRAM_1[2]/A_RWL<2> RM_IHPSG13_1P_COLUMN_256_0[4]/RM_IHPSG13_1P_BITKIT_16x2_SRAM_3[0]/A_LWL<5>
+ RM_IHPSG13_1P_COLUMN_256_0[4]/RM_IHPSG13_1P_BITKIT_16x2_SRAM_1[1]/A_RWL<15> RM_IHPSG13_1P_COLUMN_256_0[4]/RM_IHPSG13_1P_BITKIT_16x2_SRAM_3[3]/A_LWL<9>
+ RM_IHPSG13_1P_COLUMN_256_0[4]/RM_IHPSG13_1P_BITKIT_16x2_SRAM_2[2]/A_LWL<14> RM_IHPSG13_1P_COLUMN_256_0[4]/RM_IHPSG13_1P_BITKIT_16x2_SRAM_3[2]/A_RWL<3>
+ RM_IHPSG13_1P_COLUMN_256_0[4]/RM_IHPSG13_1P_BITKIT_16x2_SRAM_2[2]/A_RWL<5> RM_IHPSG13_1P_COLUMN_256_0[4]/RM_IHPSG13_1P_BITKIT_16x2_SRAM_1[3]/A_LWL<7>
+ RM_IHPSG13_1P_COLUMN_256_0[4]/RM_IHPSG13_1P_BITKIT_16x2_SRAM_1[2]/A_RWL<6> RM_IHPSG13_1P_COLUMN_256_0[4]/RM_IHPSG13_1P_BITKIT_16x2_SRAM_0[2]/A_LWL<13>
+ RM_IHPSG13_1P_COLUMN_256_0[4]/RM_IHPSG13_1P_BITKIT_16x2_SRAM_3[2]/A_LWL<7> RM_IHPSG13_1P_COLUMN_256_0[4]/RM_IHPSG13_1P_BITKIT_16x2_SRAM_2[2]/A_LWL<0>
+ RM_IHPSG13_1P_COLUMN_256_0[4]/RM_IHPSG13_1P_BITKIT_16x2_SRAM_0[0]/A_RWL<12> RM_IHPSG13_1P_COLUMN_256_0[4]/RM_IHPSG13_1P_BITKIT_16x2_SRAM_0[2]/A_RWL<7>
+ RM_IHPSG13_1P_COLUMN_256_0[4]/RM_IHPSG13_1P_BITKIT_16x2_SRAM_0[3]/A_LWL<10> RM_IHPSG13_1P_COLUMN_256_0[4]/RM_IHPSG13_1P_BITKIT_16x2_SRAM_1[2]/A_LWL<1>
+ RM_IHPSG13_1P_COLUMN_256_0[4]/RM_IHPSG13_1P_BITKIT_16x2_SRAM_3[2]/A_RWL<13> RM_IHPSG13_1P_COLUMN_256_0[4]/RM_IHPSG13_1P_BITKIT_16x2_SRAM_2[1]/A_LWL<9>
+ RM_IHPSG13_1P_COLUMN_256_0[4]/RM_IHPSG13_1P_BITKIT_16x2_SRAM_2[0]/A_RWL<10> RM_IHPSG13_1P_COLUMN_256_0[4]/RM_IHPSG13_1P_BITKIT_16x2_SRAM_0[2]/A_LWL<2>
+ RM_IHPSG13_1P_COLUMN_256_0[4]/RM_IHPSG13_1P_BITKIT_16x2_SRAM_2[3]/A_RWL<8> RM_IHPSG13_1P_COLUMN_256_0[4]/RM_IHPSG13_1P_BITKIT_16x2_SRAM_3[2]/A_RWL<5>
+ RM_IHPSG13_1P_COLUMN_256_0[4]/RM_IHPSG13_1P_BITKIT_16x2_SRAM_1[3]/A_RWL<10> RM_IHPSG13_1P_COLUMN_256_0[4]/RM_IHPSG13_1P_BITKIT_16x2_SRAM_0[1]/A_LWL<5>
+ RM_IHPSG13_1P_COLUMN_256_0[4]/RM_IHPSG13_1P_BITKIT_16x2_SRAM_0[0]/A_LWL<8> RM_IHPSG13_1P_COLUMN_256_0[4]/RM_IHPSG13_1P_BITKIT_16x2_SRAM_1[1]/A_RWL<7>
+ RM_IHPSG13_1P_COLUMN_256_0[4]/RM_IHPSG13_1P_BITKIT_16x2_SRAM_2[2]/A_LWL<13> RM_IHPSG13_1P_COLUMN_256_0[4]/RM_IHPSG13_1P_BITKIT_16x2_SRAM_1[0]/A_RWL<0>
+ RM_IHPSG13_1P_COLUMN_256_0[4]/RM_IHPSG13_1P_BITKIT_16x2_SRAM_2[1]/A_LWL<4> RM_IHPSG13_1P_COLUMN_256_0[4]/RM_IHPSG13_1P_BITKIT_16x2_SRAM_3[0]/A_RWL<7>
+ RM_IHPSG13_1P_COLUMN_256_0[4]/RM_IHPSG13_1P_BITKIT_16x2_SRAM_3[2]/A_LWL<0> RM_IHPSG13_1P_COLUMN_256_0[4]/RM_IHPSG13_1P_BITKIT_16x2_SRAM_1[2]/A_RWL<7>
+ RM_IHPSG13_1P_COLUMN_256_0[4]/RM_IHPSG13_1P_BITKIT_16x2_SRAM_1[1]/A_LWL<2> RM_IHPSG13_1P_COLUMN_256_0[4]/RM_IHPSG13_1P_BITKIT_16x2_SRAM_0[0]/A_RWL<13>
+ RM_IHPSG13_1P_COLUMN_256_0[4]/RM_IHPSG13_1P_BITKIT_16x2_SRAM_2[1]/A_RWL<14> RM_IHPSG13_1P_COLUMN_256_0[4]/RM_IHPSG13_1P_BITKIT_16x2_SRAM_2[2]/A_LWL<1>
+ RM_IHPSG13_1P_COLUMN_256_0[4]/RM_IHPSG13_1P_BITKIT_16x2_SRAM_3[1]/A_LWL<9> RM_IHPSG13_1P_COLUMN_256_0[4]/RM_IHPSG13_1P_BITKIT_16x2_SRAM_3[0]/A_LWL<2>
+ RM_IHPSG13_1P_COLUMN_256_0[4]/RM_IHPSG13_1P_BITKIT_16x2_SRAM_3[3]/A_RWL<4> RM_IHPSG13_1P_COLUMN_256_0[4]/RM_IHPSG13_1P_BITKIT_16x2_SRAM_0[2]/A_LWL<11>
+ RM_IHPSG13_1P_COLUMN_256_0[4]/RM_IHPSG13_1P_BITKIT_16x2_SRAM_0[3]/A_LWL<11> RM_IHPSG13_1P_COLUMN_256_0[4]/RM_IHPSG13_1P_BITKIT_16x2_SRAM_1[2]/A_LWL<2>
+ RM_IHPSG13_1P_COLUMN_256_0[4]/RM_IHPSG13_1P_BITKIT_16x2_SRAM_1[2]/A_RWL<14> RM_IHPSG13_1P_COLUMN_256_0[4]/RM_IHPSG13_1P_BITKIT_16x2_SRAM_2[1]/A_LWL<11>
+ RM_IHPSG13_1P_COLUMN_256_0[4]/RM_IHPSG13_1P_BITKIT_16x2_SRAM_0[1]/A_RWL<10> RM_IHPSG13_1P_COLUMN_256_0[4]/RM_IHPSG13_1P_BITKIT_16x2_SRAM_0[2]/A_LWL<3>
+ RM_IHPSG13_1P_COLUMN_256_0[4]/RM_IHPSG13_1P_BITKIT_16x2_SRAM_0[2]/A_LWL<14> RM_IHPSG13_1P_COLUMN_256_0[4]/RM_IHPSG13_1P_BITKIT_16x2_SRAM_3[2]/A_RWL<6>
+ RM_IHPSG13_1P_COLUMN_256_0[4]/RM_IHPSG13_1P_BITKIT_16x2_SRAM_1[3]/A_RWL<11> RM_IHPSG13_1P_COLUMN_256_0[4]/RM_IHPSG13_1P_BITKIT_16x2_SRAM_2[1]/A_LWL<14>
+ RM_IHPSG13_1P_COLUMN_256_0[4]/RM_IHPSG13_1P_BITKIT_16x2_SRAM_2[2]/A_RWL<7> RM_IHPSG13_1P_COLUMN_256_0[4]/RM_IHPSG13_1P_BITKIT_16x2_SRAM_0[3]/A_RWL<0>
+ RM_IHPSG13_1P_COLUMN_256_0[4]/RM_IHPSG13_1P_BITKIT_16x2_SRAM_1[0]/A_LWL<0> RM_IHPSG13_1P_COLUMN_256_0[4]/RM_IHPSG13_1P_BITKIT_16x2_SRAM_1[2]/A_RWL<8>
+ RM_IHPSG13_1P_COLUMN_256_0[4]/RM_IHPSG13_1P_BITKIT_16x2_SRAM_3[2]/A_LWL<1> RM_IHPSG13_1P_COLUMN_256_0[4]/RM_IHPSG13_1P_BITKIT_16x2_SRAM_0[2]/A_LWL<15>
+ RM_IHPSG13_1P_COLUMN_256_0[4]/RM_IHPSG13_1P_BITKIT_16x2_SRAM_1[3]/A_LWL<12> RM_IHPSG13_1P_COLUMN_256_0[4]/RM_IHPSG13_1P_BITKIT_16x2_SRAM_3[1]/A_LWL<7>
+ RM_IHPSG13_1P_COLUMN_256_0[4]/RM_IHPSG13_1P_BITKIT_16x2_SRAM_0[2]/A_RWL<9> RM_IHPSG13_1P_COLUMN_256_0[4]/RM_IHPSG13_1P_BITKIT_16x2_SRAM_0[0]/A_RWL<14>
+ RM_IHPSG13_1P_COLUMN_256_0[4]/RM_IHPSG13_1P_BITKIT_16x2_SRAM_2[2]/A_LWL<2> RM_IHPSG13_1P_COLUMN_256_0[4]/RM_IHPSG13_1P_BITKIT_16x2_SRAM_1[2]/A_RWL<13>
+ RM_IHPSG13_1P_COLUMN_256_0[4]/RM_IHPSG13_1P_BITKIT_16x2_SRAM_1[0]/A_LWL<9> RM_IHPSG13_1P_COLUMN_256_0[4]/RM_IHPSG13_1P_BITKIT_16x2_SRAM_0[3]/A_LWL<12>
+ RM_IHPSG13_1P_COLUMN_256_0[4]/RM_IHPSG13_1P_BITKIT_16x2_SRAM_1[2]/A_LWL<3> RM_IHPSG13_1P_COLUMN_256_0[4]/RM_IHPSG13_1P_BITKIT_16x2_SRAM_3[1]/A_RWL<13>
+ RM_IHPSG13_1P_COLUMN_256_0[4]/RM_IHPSG13_1P_BITKIT_16x2_SRAM_3[1]/A_LWL<5> RM_IHPSG13_1P_COLUMN_256_0[4]/RM_IHPSG13_1P_BITKIT_16x2_SRAM_0[0]/A_RWL<10>
+ RM_IHPSG13_1P_COLUMN_256_0[4]/RM_IHPSG13_1P_BITKIT_16x2_SRAM_0[3]/A_RWL<8> RM_IHPSG13_1P_COLUMN_256_0[4]/RM_IHPSG13_1P_BITKIT_16x2_SRAM_1[2]/A_RWL<15>
+ RM_IHPSG13_1P_COLUMN_256_0[4]/RM_IHPSG13_1P_BITKIT_16x2_SRAM_3[0]/A_LWL<8> RM_IHPSG13_1P_COLUMN_256_0[4]/RM_IHPSG13_1P_BITKIT_16x2_SRAM_0[1]/A_RWL<11>
+ RM_IHPSG13_1P_COLUMN_256_0[4]/RM_IHPSG13_1P_BITKIT_16x2_SRAM_3[3]/A_RWL<3> RM_IHPSG13_1P_COLUMN_256_0[4]/RM_IHPSG13_1P_BITKIT_16x2_SRAM_0[2]/A_LWL<4>
+ RM_IHPSG13_1P_COLUMN_256_0[4]/RM_IHPSG13_1P_BITKIT_16x2_SRAM_3[2]/A_RWL<7> RM_IHPSG13_1P_COLUMN_256_0[4]/RM_IHPSG13_1P_BITKIT_16x2_SRAM_1[3]/A_RWL<12>
+ RM_IHPSG13_1P_COLUMN_256_0[4]/RM_IHPSG13_1P_BITKIT_16x2_SRAM_1[0]/A_RWL<7> RM_IHPSG13_1P_COLUMN_256_0[4]/RM_IHPSG13_1P_BITKIT_16x2_SRAM_1[3]/A_RWL<0>
+ RM_IHPSG13_1P_COLUMN_256_0[4]/RM_IHPSG13_1P_BITKIT_16x2_SRAM_2[2]/A_RWL<8> RM_IHPSG13_1P_COLUMN_256_0[4]/RM_IHPSG13_1P_BITKIT_16x2_SRAM_2[3]/A_RWL<6>
+ RM_IHPSG13_1P_COLUMN_256_0[4]/RM_IHPSG13_1P_BITKIT_16x2_SRAM_2[2]/A_RWL<1> RM_IHPSG13_1P_COLUMN_256_0[4]/RM_IHPSG13_1P_BITKIT_16x2_SRAM_0[3]/A_RWL<1>
+ RM_IHPSG13_1P_COLUMN_256_0[4]/RM_IHPSG13_1P_BITKIT_16x2_SRAM_3[2]/A_LWL<2> RM_IHPSG13_1P_COLUMN_256_0[4]/RM_IHPSG13_1P_BITKIT_16x2_SRAM_1[2]/A_RWL<9>
+ RM_IHPSG13_1P_COLUMN_256_0[4]/RM_IHPSG13_1P_BITKIT_16x2_SRAM_1[0]/A_LWL<2> RM_IHPSG13_1P_COLUMN_256_0[4]/RM_IHPSG13_1P_BITKIT_16x2_SRAM_2[2]/A_LWL<3>
+ RM_IHPSG13_1P_COLUMN_256_0[4]/RM_IHPSG13_1P_BITKIT_16x2_SRAM_0[0]/A_RWL<15> RM_IHPSG13_1P_COLUMN_256_0[4]/RM_IHPSG13_1P_BITKIT_16x2_SRAM_0[1]/A_LWL<11>
+ RM_IHPSG13_1P_COLUMN_256_0[4]/RM_IHPSG13_1P_BITKIT_16x2_SRAM_3[2]/A_RWL<4> RM_IHPSG13_1P_COLUMN_256_0[4]/RM_IHPSG13_1P_BITKIT_16x2_SRAM_0[3]/A_LWL<13>
+ RM_IHPSG13_1P_COLUMN_256_0[4]/RM_IHPSG13_1P_BITKIT_16x2_SRAM_1[2]/A_LWL<4> RM_IHPSG13_1P_COLUMN_256_0[4]/RM_IHPSG13_1P_BITKIT_16x2_SRAM_2[0]/A_LWL<11>
+ RM_IHPSG13_1P_COLUMN_256_0[4]/RM_IHPSG13_1P_BITKIT_16x2_SRAM_0[1]/A_RWL<12> RM_IHPSG13_1P_COLUMN_256_0[4]/RM_IHPSG13_1P_BITKIT_16x2_SRAM_3[3]/A_LWL<10>
+ RM_IHPSG13_1P_COLUMN_256_0[4]/RM_IHPSG13_1P_BITKIT_16x2_SRAM_2[0]/A_LWL<1> RM_IHPSG13_1P_COLUMN_256_0[4]/RM_IHPSG13_1P_BITKIT_16x2_SRAM_0[1]/A_LWL<8>
+ RM_IHPSG13_1P_COLUMN_256_0[4]/RM_IHPSG13_1P_BITKIT_16x2_SRAM_0[1]/A_LWL<14> RM_IHPSG13_1P_COLUMN_256_0[4]/RM_IHPSG13_1P_BITKIT_16x2_SRAM_0[2]/A_LWL<5>
+ RM_IHPSG13_1P_COLUMN_256_0[4]/RM_IHPSG13_1P_BITKIT_16x2_SRAM_2[3]/A_RWL<0> RM_IHPSG13_1P_COLUMN_256_0[4]/RM_IHPSG13_1P_BITKIT_16x2_SRAM_2[3]/A_LWL<13>
+ RM_IHPSG13_1P_COLUMN_256_0[4]/RM_IHPSG13_1P_BITKIT_16x2_SRAM_3[2]/A_RWL<8> RM_IHPSG13_1P_COLUMN_256_0[4]/RM_IHPSG13_1P_BITKIT_16x2_SRAM_1[3]/A_RWL<13>
+ RM_IHPSG13_1P_COLUMN_256_0[4]/RM_IHPSG13_1P_BITKIT_16x2_SRAM_2[0]/A_LWL<14> RM_IHPSG13_1P_COLUMN_256_0[4]/RM_IHPSG13_1P_BITKIT_16x2_SRAM_1[3]/A_RWL<1>
+ RM_IHPSG13_1P_COLUMN_256_0[4]/RM_IHPSG13_1P_BITKIT_16x2_SRAM_2[2]/A_RWL<9> RM_IHPSG13_1P_COLUMN_256_0[4]/RM_IHPSG13_1P_BITKIT_16x2_SRAM_1[1]/A_LWL<7>
+ RM_IHPSG13_1P_COLUMN_256_0[4]/RM_IHPSG13_1P_BITKIT_16x2_SRAM_2[2]/A_RWL<14> RM_IHPSG13_1P_COLUMN_256_0[4]/RM_IHPSG13_1P_BITKIT_16x2_SRAM_0[3]/A_RWL<2>
+ RM_IHPSG13_1P_COLUMN_256_0[4]/RM_IHPSG13_1P_BITKIT_16x2_SRAM_3[2]/A_LWL<3> RM_IHPSG13_1P_COLUMN_256_0[4]/RM_IHPSG13_1P_BITKIT_16x2_SRAM_3[0]/A_LWL<7>
+ RM_IHPSG13_1P_COLUMN_256_0[4]/RM_IHPSG13_1P_BITKIT_16x2_SRAM_2[2]/A_LWL<4> RM_IHPSG13_1P_COLUMN_256_0[4]/RM_IHPSG13_1P_BITKIT_16x2_SRAM_1[1]/A_RWL<13>
+ RM_IHPSG13_1P_COLUMN_256_0[4]/RM_IHPSG13_1P_BITKIT_16x2_SRAM_0[3]/A_LWL<14> RM_IHPSG13_1P_COLUMN_256_0[4]/RM_IHPSG13_1P_BITKIT_16x2_SRAM_3[0]/A_RWL<13>
+ RM_IHPSG13_1P_COLUMN_256_0[4]/RM_IHPSG13_1P_BITKIT_16x2_SRAM_1[2]/A_LWL<5> RM_IHPSG13_1P_COLUMN_256_0[4]/RM_IHPSG13_1P_BITKIT_16x2_SRAM_3[3]/A_RWL<0>
+ RM_IHPSG13_1P_COLUMN_256_0[4]/RM_IHPSG13_1P_BITKIT_16x2_SRAM_0[2]/A_RWL<8> RM_IHPSG13_1P_COLUMN_256_0[4]/RM_IHPSG13_1P_BITKIT_16x2_SRAM_0[1]/A_RWL<13>
+ RM_IHPSG13_1P_COLUMN_256_0[4]/RM_IHPSG13_1P_BITKIT_16x2_SRAM_3[0]/A_LWL<10> RM_IHPSG13_1P_COLUMN_256_0[4]/RM_IHPSG13_1P_BITKIT_16x2_SRAM_2[1]/A_RWL<8>
+ RM_IHPSG13_1P_COLUMN_256_0[4]/RM_IHPSG13_1P_BITKIT_16x2_SRAM_0[2]/A_LWL<6> RM_IHPSG13_1P_COLUMN_256_0[4]/RM_IHPSG13_1P_BITKIT_16x2_SRAM_2[3]/A_RWL<1>
+ RM_IHPSG13_1P_COLUMN_256_0[4]/RM_IHPSG13_1P_BITKIT_16x2_SRAM_3[2]/A_RWL<9> RM_IHPSG13_1P_COLUMN_256_0[4]/RM_IHPSG13_1P_BITKIT_16x2_SRAM_0[3]/A_RWL<6>
+ RM_IHPSG13_1P_COLUMN_256_0[4]/RM_IHPSG13_1P_BITKIT_16x2_SRAM_1[3]/A_RWL<14> RM_IHPSG13_1P_COLUMN_256_0[4]/RM_IHPSG13_1P_BITKIT_16x2_SRAM_0[2]/A_RWL<1>
+ RM_IHPSG13_1P_COLUMN_256_0[4]/RM_IHPSG13_1P_BITKIT_16x2_SRAM_1[1]/A_LWL<0> RM_IHPSG13_1P_COLUMN_256_0[4]/RM_IHPSG13_1P_BITKIT_16x2_SRAM_0[2]/A_RWL<10>
+ RM_IHPSG13_1P_COLUMN_256_0[4]/RM_IHPSG13_1P_BITKIT_16x2_SRAM_1[3]/A_RWL<2> RM_IHPSG13_1P_COLUMN_256_0[4]/RM_IHPSG13_1P_BITKIT_16x2_SRAM_2[2]/A_RWL<6>
+ RM_IHPSG13_1P_COLUMN_256_0[4]/RM_IHPSG13_1P_BITKIT_16x2_SRAM_2[1]/A_RWL<1> RM_IHPSG13_1P_COLUMN_256_0[4]/RM_IHPSG13_1P_BITKIT_16x2_SRAM_0[3]/A_RWL<3>
+ RM_IHPSG13_1P_COLUMN_256_0[4]/RM_IHPSG13_1P_BITKIT_16x2_SRAM_3[2]/A_LWL<4> RM_IHPSG13_1P_COLUMN_256_0[4]/RM_IHPSG13_1P_BITKIT_16x2_SRAM_1[1]/A_LWL<9>
+ RM_IHPSG13_1P_COLUMN_256_0[4]/RM_IHPSG13_1P_BITKIT_16x2_SRAM_1[2]/A_RWL<4> RM_IHPSG13_1P_COLUMN_256_0[4]/RM_IHPSG13_1P_BITKIT_16x2_SRAM_1[0]/A_RWL<3>
+ RM_IHPSG13_1P_COLUMN_256_0[4]/RM_IHPSG13_1P_BITKIT_16x2_SRAM_2[2]/A_LWL<5> RM_IHPSG13_1P_COLUMN_256_0[4]/RM_IHPSG13_1P_BITKIT_16x2_SRAM_3[1]/A_LWL<8>
+ RM_IHPSG13_1P_COLUMN_256_0[4]/RM_IHPSG13_1P_BITKIT_16x2_SRAM_0[0]/A_LWL<11> RM_IHPSG13_1P_COLUMN_256_0[4]/RM_IHPSG13_1P_BITKIT_16x2_SRAM_3[1]/A_RWL<4>
+ RM_IHPSG13_1P_COLUMN_256_0[4]/RM_IHPSG13_1P_BITKIT_16x2_SRAM_0[3]/A_LWL<15> RM_IHPSG13_1P_COLUMN_256_0[4]/RM_IHPSG13_1P_BITKIT_16x2_SRAM_1[3]/A_LWL<10>
+ RM_IHPSG13_1P_COLUMN_256_0[4]/RM_IHPSG13_1P_BITKIT_16x2_SRAM_1[2]/A_LWL<6> RM_IHPSG13_1P_COLUMN_256_0[4]/RM_IHPSG13_1P_BITKIT_16x2_SRAM_3[3]/A_RWL<1>
+ RM_IHPSG13_1P_COLUMN_256_0[4]/RM_IHPSG13_1P_BITKIT_16x2_SRAM_0[1]/A_RWL<14> RM_IHPSG13_1P_COLUMN_256_0[4]/RM_IHPSG13_1P_BITKIT_16x2_SRAM_3[2]/A_LWL<10>
+ RM_IHPSG13_1P_COLUMN_256_0[4]/RM_IHPSG13_1P_BITKIT_16x2_SRAM_3[0]/A_LWL<11> RM_IHPSG13_1P_COLUMN_256_0[4]/RM_IHPSG13_1P_BITKIT_16x2_SRAM_0[0]/A_LWL<14>
+ RM_IHPSG13_1P_COLUMN_256_0[4]/RM_IHPSG13_1P_BITKIT_16x2_SRAM_0[2]/A_LWL<7> RM_IHPSG13_1P_COLUMN_256_0[4]/RM_IHPSG13_1P_BITKIT_16x2_SRAM_2[3]/A_RWL<2>
+ RM_IHPSG13_1P_COLUMN_256_0[4]/RM_IHPSG13_1P_BITKIT_16x2_SRAM_2[3]/A_RWL<11> RM_IHPSG13_1P_COLUMN_256_0[4]/RM_IHPSG13_1P_BITKIT_16x2_SRAM_1[3]/A_RWL<15>
+ RM_IHPSG13_1P_COLUMN_256_0[4]/RM_IHPSG13_1P_BITKIT_16x2_SRAM_0[2]/A_RWL<11> RM_IHPSG13_1P_COLUMN_256_0[4]/RM_IHPSG13_1P_BITKIT_16x2_SRAM_1[3]/A_RWL<3>
+ RM_IHPSG13_1P_COLUMN_256_0[4]/RM_IHPSG13_1P_BITKIT_16x2_SRAM_1[0]/A_LWL<7> RM_IHPSG13_1P_COLUMN_256_0[4]/RM_IHPSG13_1P_BITKIT_16x2_SRAM_0[3]/A_RWL<4>
+ RM_IHPSG13_1P_COLUMN_256_0[4]/RM_IHPSG13_1P_BITKIT_16x2_SRAM_2[3]/A_LWL<6> RM_IHPSG13_1P_COLUMN_256_0[4]/RM_IHPSG13_1P_BITKIT_16x2_SRAM_3[2]/A_LWL<5>
+ RM_IHPSG13_1P_COLUMN_256_0[4]/RM_IHPSG13_1P_BITKIT_16x2_SRAM_0[0]/A_LWL<13> RM_IHPSG13_1P_COLUMN_256_0[4]/RM_IHPSG13_1P_BITKIT_16x2_SRAM_2[2]/A_LWL<6>
+ RM_IHPSG13_1P_COLUMN_256_0[4]/RM_IHPSG13_1P_BITKIT_16x2_SRAM_1[0]/A_RWL<13> RM_IHPSG13_1P_COLUMN_256_0[4]/RM_IHPSG13_1P_BITKIT_16x2_SRAM_2[1]/A_LWL<1>
+ RM_IHPSG13_1P_COLUMN_256_0[4]/RM_IHPSG13_1P_BITKIT_16x2_SRAM_0[3]/A_LWL<5> RM_IHPSG13_1P_COLUMN_256_0[4]/RM_IHPSG13_1P_BITKIT_16x2_SRAM_2[0]/A_LWL<12>
+ RM_IHPSG13_1P_COLUMN_256_0[4]/RM_IHPSG13_1P_BITKIT_16x2_SRAM_3[3]/A_LWL<3> RM_IHPSG13_1P_COLUMN_256_0[4]/RM_IHPSG13_1P_BITKIT_16x2_SRAM_1[2]/A_LWL<7>
+ RM_IHPSG13_1P_COLUMN_256_0[4]/RM_IHPSG13_1P_BITKIT_16x2_SRAM_3[3]/A_RWL<2> RM_IHPSG13_1P_COLUMN_256_0[4]/RM_IHPSG13_1P_BITKIT_16x2_SRAM_0[1]/A_RWL<8>
+ RM_IHPSG13_1P_COLUMN_256_0[4]/RM_IHPSG13_1P_BITKIT_16x2_SRAM_2[3]/A_LWL<4> RM_IHPSG13_1P_COLUMN_256_0[4]/RM_IHPSG13_1P_BITKIT_16x2_SRAM_0[1]/A_RWL<15>
+ RM_IHPSG13_1P_COLUMN_256_0[4]/RM_IHPSG13_1P_BITKIT_16x2_SRAM_3[0]/A_LWL<12> RM_IHPSG13_1P_COLUMN_256_0[4]/RM_IHPSG13_1P_BITKIT_16x2_SRAM_2[0]/A_RWL<8>
+ RM_IHPSG13_1P_COLUMN_256_0[4]/RM_IHPSG13_1P_BITKIT_16x2_SRAM_0[2]/A_LWL<8> RM_IHPSG13_1P_COLUMN_256_0[4]/RM_IHPSG13_1P_BITKIT_16x2_SRAM_2[3]/A_RWL<3>
+ RM_IHPSG13_1P_COLUMN_256_0[4]/RM_IHPSG13_1P_BITKIT_16x2_SRAM_2[0]/A_RWL<2> RM_IHPSG13_1P_COLUMN_256_0[4]/RM_IHPSG13_1P_BITKIT_16x2_SRAM_3[3]/A_RWL<9>
+ RM_IHPSG13_1P_COLUMN_256_0[4]/RM_IHPSG13_1P_BITKIT_16x2_SRAM_0[2]/A_RWL<6> RM_IHPSG13_1P_COLUMN_256_0[4]/RM_IHPSG13_1P_BITKIT_16x2_SRAM_0[1]/A_RWL<1>
+ RM_IHPSG13_1P_COLUMN_256_0[4]/RM_IHPSG13_1P_BITKIT_16x2_SRAM_2[3]/A_RWL<14> RM_IHPSG13_1P_COLUMN_256_0[4]/RM_IHPSG13_1P_BITKIT_16x2_SRAM_0[2]/A_RWL<12>
+ RM_IHPSG13_1P_COLUMN_256_0[4]/RM_IHPSG13_1P_BITKIT_16x2_SRAM_1[3]/A_RWL<4> RM_IHPSG13_1P_COLUMN_256_0[4]/RM_IHPSG13_1P_BITKIT_16x2_SRAM_2[1]/A_RWL<6>
+ RM_IHPSG13_1P_COLUMN_256_0[4]/RM_IHPSG13_1P_BITKIT_16x2_SRAM_2[0]/A_RWL<1> RM_IHPSG13_1P_COLUMN_256_0[7]/RM_IHPSG13_1P_BITKIT_16x2_SRAM_3[3]/VSS
+ RM_IHPSG13_1P_COLUMN_256_0[7]/RM_IHPSG13_1P_BITKIT_16x2_SRAM_3[3]/VDD RM_IHPSG13_1P_COLUMN_256_0[4]/RM_IHPSG13_1P_BITKIT_16x2_SRAM_0[3]/A_RWL<5>
+ RM_IHPSG13_1P_COLUMN_256_0[4]/RM_IHPSG13_1P_BITKIT_16x2_SRAM_3[2]/A_LWL<6> RM_IHPSG13_1P_COLUMN_256
XRM_IHPSG13_1P_COLUMN_256_0[5] RM_IHPSG13_1P_COLUMN_256_0[5]/RM_IHPSG13_1P_BITKIT_16x2_SRAM_0[0]/A_BLT_BOT<0>
+ RM_IHPSG13_1P_COLUMN_256_0[5]/RM_IHPSG13_1P_BITKIT_16x2_SRAM_3[1]/A_LWL<10> RM_IHPSG13_1P_COLUMN_256_0[5]/RM_IHPSG13_1P_BITKIT_16x2_SRAM_3[0]/A_LWL<13>
+ RM_IHPSG13_1P_COLUMN_256_0[5]/RM_IHPSG13_1P_BITKIT_16x2_SRAM_0[0]/A_BLT_BOT<1> RM_IHPSG13_1P_COLUMN_256_0[5]/RM_IHPSG13_1P_BITKIT_16x2_SRAM_1[2]/A_LWL<9>
+ RM_IHPSG13_1P_COLUMN_256_0[5]/RM_IHPSG13_1P_BITKIT_16x2_SRAM_0[0]/A_BLC_BOT<0> RM_IHPSG13_1P_COLUMN_256_0[5]/RM_IHPSG13_1P_BITKIT_16x2_SRAM_3[2]/A_LWL<8>
+ RM_IHPSG13_1P_COLUMN_256_0[5]/RM_IHPSG13_1P_BITKIT_16x2_SRAM_0[3]/A_RWL<11> RM_IHPSG13_1P_COLUMN_256_0[5]/RM_IHPSG13_1P_BITKIT_16x2_SRAM_2[3]/A_RWL<5>
+ RM_IHPSG13_1P_COLUMN_256_0[5]/RM_IHPSG13_1P_BITKIT_16x2_SRAM_0[0]/A_BLC_BOT<1> RM_IHPSG13_1P_COLUMN_256_0[5]/RM_IHPSG13_1P_BITKIT_16x2_SRAM_1[3]/A_LWL<0>
+ RM_IHPSG13_1P_COLUMN_256_0[5]/RM_IHPSG13_1P_BITKIT_16x2_SRAM_3[1]/A_LWL<13> RM_IHPSG13_1P_COLUMN_256_0[5]/RM_IHPSG13_1P_BITKIT_16x2_SRAM_1[3]/A_LWL<3>
+ RM_IHPSG13_1P_COLUMN_256_0[5]/RM_IHPSG13_1P_BITKIT_16x2_SRAM_1[3]/A_RWL<9> RM_IHPSG13_1P_COLUMN_256_0[5]/RM_IHPSG13_1P_BITKIT_16x2_SRAM_2[3]/A_LWL<1>
+ RM_IHPSG13_1P_COLUMN_256_0[5]/RM_IHPSG13_1P_BITKIT_16x2_SRAM_0[0]/A_RWL<1> RM_IHPSG13_1P_COLUMN_256_0[5]/RM_IHPSG13_1P_BITKIT_16x2_SRAM_0[3]/A_LWL<6>
+ RM_IHPSG13_1P_COLUMN_256_0[5]/RM_IHPSG13_1P_BITKIT_16x2_SRAM_2[3]/A_RWL<7> RM_IHPSG13_1P_COLUMN_256_0[5]/RM_IHPSG13_1P_BITKIT_16x2_SRAM_3[2]/A_LWL<13>
+ RM_IHPSG13_1P_COLUMN_256_0[5]/RM_IHPSG13_1P_BITKIT_16x2_SRAM_2[3]/A_LWL<2> RM_IHPSG13_1P_COLUMN_256_0[5]/RM_IHPSG13_1P_BITKIT_16x2_SRAM_3[3]/A_LWL<5>
+ RM_IHPSG13_1P_COLUMN_256_0[5]/RM_IHPSG13_1P_BITKIT_16x2_SRAM_0[2]/A_RWL<14> RM_IHPSG13_1P_COLUMN_256_0[5]/RM_IHPSG13_1P_BITKIT_16x2_SRAM_0[3]/A_LWL<8>
+ RM_IHPSG13_1P_COLUMN_256_0[5]/RM_IHPSG13_1P_BITKIT_16x2_SRAM_3[3]/A_LWL<11> RM_IHPSG13_1P_COLUMN_256_0[5]/RM_IHPSG13_1P_BITKIT_16x2_SRAM_3[0]/A_RWL<12>
+ RM_IHPSG13_1P_COLUMN_256_0[5]/RM_IHPSG13_1P_BITKIT_16x2_SRAM_3[1]/A_RWL<10> RM_IHPSG13_1P_COLUMN_256_0[5]/RM_IHPSG13_1P_BITKIT_16x2_SRAM_0[3]/A_RWL<7>
+ RM_IHPSG13_1P_COLUMN_256_0[5]/RM_IHPSG13_1P_BITKIT_16x2_SRAM_0[3]/A_LWL<2> RM_IHPSG13_1P_COLUMN_256_0[5]/RM_IHPSG13_1P_BITKIT_16x2_SRAM_3[0]/A_RWL<14>
+ RM_IHPSG13_1P_COLUMN_256_0[5]/RM_IHPSG13_1P_BITKIT_16x2_SRAM_1[0]/A_RWL<4> RM_IHPSG13_1P_COLUMN_256_0[5]/RM_IHPSG13_1P_BITKIT_16x2_SRAM_3[2]/A_LWL<11>
+ RM_IHPSG13_1P_COLUMN_256_0[5]/RM_IHPSG13_1P_BITKIT_16x2_SRAM_3[2]/A_LWL<14> RM_IHPSG13_1P_COLUMN_256_0[5]/RM_IHPSG13_1P_BITKIT_16x2_SRAM_2[0]/A_LWL<15>
+ RM_IHPSG13_1P_COLUMN_256_0[5]/RM_IHPSG13_1P_BITKIT_16x2_SRAM_0[0]/A_RWL<5> RM_IHPSG13_1P_COLUMN_256_0[5]/RM_IHPSG13_1P_BITKIT_16x2_SRAM_2[3]/A_LWL<7>
+ RM_IHPSG13_1P_COLUMN_256_0[5]/RM_IHPSG13_1P_BITKIT_16x2_SRAM_1[3]/A_LWL<9> RM_IHPSG13_1P_COLUMN_256_0[5]/RM_IHPSG13_1P_BITKIT_16x2_SRAM_2[1]/A_LWL<12>
+ RM_IHPSG13_1P_COLUMN_256_0[5]/RM_IHPSG13_1P_BITKIT_16x2_SRAM_0[3]/A_LWL<4> RM_IHPSG13_1P_COLUMN_256_0[5]/RM_IHPSG13_1P_BITKIT_16x2_SRAM_3[3]/A_LWL<13>
+ RM_IHPSG13_1P_COLUMN_256_0[5]/RM_IHPSG13_1P_BITKIT_16x2_SRAM_3[1]/A_RWL<12> RM_IHPSG13_1P_COLUMN_256_0[5]/RM_IHPSG13_1P_BITKIT_16x2_SRAM_0[0]/A_RWL<2>
+ RM_IHPSG13_1P_COLUMN_256_0[5]/RM_IHPSG13_1P_BITKIT_16x2_SRAM_0[3]/A_RWL<14> RM_IHPSG13_1P_COLUMN_256_0[5]/RM_IHPSG13_1P_BITKIT_16x2_SRAM_3[0]/A_RWL<10>
+ RM_IHPSG13_1P_COLUMN_256_0[5]/RM_IHPSG13_1P_BITKIT_16x2_SRAM_2[0]/A_RWL<3> RM_IHPSG13_1P_COLUMN_256_0[5]/RM_IHPSG13_1P_BITKIT_16x2_SRAM_3[3]/A_RWL<8>
+ RM_IHPSG13_1P_COLUMN_256_0[5]/RM_IHPSG13_1P_BITKIT_16x2_SRAM_0[0]/A_RWL<6> RM_IHPSG13_1P_COLUMN_256_0[5]/RM_IHPSG13_1P_BITKIT_16x2_SRAM_3[3]/A_LWL<8>
+ RM_IHPSG13_1P_COLUMN_256_0[5]/RM_IHPSG13_1P_BITKIT_16x2_SRAM_2[0]/A_RWL<0> RM_IHPSG13_1P_COLUMN_256_0[5]/RM_IHPSG13_1P_BITKIT_16x2_SRAM_0[0]/A_LWL<1>
+ RM_IHPSG13_1P_COLUMN_256_0[5]/RM_IHPSG13_1P_BITKIT_16x2_SRAM_3[0]/A_RWL<4> RM_IHPSG13_1P_COLUMN_256_0[5]/RM_IHPSG13_1P_BITKIT_16x2_SRAM_2[0]/A_RWL<5>
+ RM_IHPSG13_1P_COLUMN_256_0[5]/RM_IHPSG13_1P_BITKIT_16x2_SRAM_3[3]/A_LWL<14> RM_IHPSG13_1P_COLUMN_256_0[5]/RM_IHPSG13_1P_BITKIT_16x2_SRAM_3[1]/A_LWL<11>
+ RM_IHPSG13_1P_COLUMN_256_0[5]/RM_IHPSG13_1P_BITKIT_16x2_SRAM_2[0]/A_LWL<0> RM_IHPSG13_1P_COLUMN_256_0[5]/RM_IHPSG13_1P_BITKIT_16x2_SRAM_3[2]/A_RWL<10>
+ RM_IHPSG13_1P_COLUMN_256_0[5]/RM_IHPSG13_1P_BITKIT_16x2_SRAM_1[3]/A_LWL<5> RM_IHPSG13_1P_COLUMN_256_0[5]/RM_IHPSG13_1P_BITKIT_16x2_SRAM_3[1]/A_LWL<14>
+ RM_IHPSG13_1P_COLUMN_256_0[5]/RM_IHPSG13_1P_BITKIT_16x2_SRAM_0[3]/A_LWL<7> RM_IHPSG13_1P_COLUMN_256_0[5]/RM_IHPSG13_1P_BITKIT_16x2_SRAM_1[2]/A_LWL<8>
+ RM_IHPSG13_1P_COLUMN_256_0[5]/RM_IHPSG13_1P_BITKIT_16x2_SRAM_3[3]/A_LWL<4> RM_IHPSG13_1P_COLUMN_256_0[5]/RM_IHPSG13_1P_BITKIT_16x2_SRAM_2[2]/A_LWL<7>
+ RM_IHPSG13_1P_COLUMN_256_0[5]/RM_IHPSG13_1P_BITKIT_16x2_SRAM_0[3]/A_RWL<13> RM_IHPSG13_1P_COLUMN_256_0[5]/RM_IHPSG13_1P_BITKIT_16x2_SRAM_1[0]/A_LWL<10>
+ RM_IHPSG13_1P_COLUMN_256_0[5]/RM_IHPSG13_1P_BITKIT_16x2_SRAM_3[0]/A_RWL<2> RM_IHPSG13_1P_COLUMN_256_0[5]/RM_IHPSG13_1P_BITKIT_16x2_SRAM_2[0]/A_RWL<6>
+ RM_IHPSG13_1P_COLUMN_256_0[5]/RM_IHPSG13_1P_BITKIT_16x2_SRAM_3[1]/A_RWL<14> RM_IHPSG13_1P_COLUMN_256_0[5]/RM_IHPSG13_1P_BITKIT_16x2_SRAM_1[3]/A_RWL<8>
+ RM_IHPSG13_1P_COLUMN_256_0[5]/RM_IHPSG13_1P_BITKIT_16x2_SRAM_0[0]/A_RWL<8> RM_IHPSG13_1P_COLUMN_256_0[5]/RM_IHPSG13_1P_BITKIT_16x2_SRAM_0[0]/A_RWL<0>
+ RM_IHPSG13_1P_COLUMN_256_0[5]/RM_IHPSG13_1P_BITKIT_16x2_SRAM_3[3]/A_RWL<6> RM_IHPSG13_1P_COLUMN_256_0[5]/RM_IHPSG13_1P_BITKIT_16x2_SRAM_2[1]/A_LWL<15>
+ RM_IHPSG13_1P_COLUMN_256_0[5]/RM_IHPSG13_1P_BITKIT_16x2_SRAM_2[3]/A_RWL<4> RM_IHPSG13_1P_COLUMN_256_0[5]/RM_IHPSG13_1P_BITKIT_16x2_SRAM_2[0]/A_RWL<7>
+ RM_IHPSG13_1P_COLUMN_256_0[5]/RM_IHPSG13_1P_BITKIT_16x2_SRAM_2[2]/A_LWL<9> RM_IHPSG13_1P_COLUMN_256_0[5]/RM_IHPSG13_1P_BITKIT_16x2_SRAM_2[2]/A_LWL<12>
+ RM_IHPSG13_1P_COLUMN_256_0[5]/RM_IHPSG13_1P_BITKIT_16x2_SRAM_0[1]/A_RWL<0> RM_IHPSG13_1P_COLUMN_256_0[5]/RM_IHPSG13_1P_BITKIT_16x2_SRAM_3[0]/A_LWL<1>
+ RM_IHPSG13_1P_COLUMN_256_0[5]/RM_IHPSG13_1P_BITKIT_16x2_SRAM_2[0]/A_RWL<11> RM_IHPSG13_1P_COLUMN_256_0[5]/RM_IHPSG13_1P_BITKIT_16x2_SRAM_2[0]/A_LWL<2>
+ RM_IHPSG13_1P_COLUMN_256_0[5]/RM_IHPSG13_1P_BITKIT_16x2_SRAM_3[2]/A_RWL<12> RM_IHPSG13_1P_COLUMN_256_0[5]/RM_IHPSG13_1P_BITKIT_16x2_SRAM_3[0]/A_LWL<14>
+ RM_IHPSG13_1P_COLUMN_256_0[5]/RM_IHPSG13_1P_BITKIT_16x2_SRAM_1[0]/A_LWL<3> RM_IHPSG13_1P_COLUMN_256_0[5]/RM_IHPSG13_1P_BITKIT_16x2_SRAM_0[0]/A_LWL<4>
+ RM_IHPSG13_1P_COLUMN_256_0[5]/RM_IHPSG13_1P_BITKIT_16x2_SRAM_0[2]/A_RWL<13> RM_IHPSG13_1P_COLUMN_256_0[5]/RM_IHPSG13_1P_BITKIT_16x2_SRAM_1[0]/A_RWL<9>
+ RM_IHPSG13_1P_COLUMN_256_0[5]/RM_IHPSG13_1P_BITKIT_16x2_SRAM_1[3]/A_LWL<8> RM_IHPSG13_1P_COLUMN_256_0[5]/RM_IHPSG13_1P_BITKIT_16x2_SRAM_3[1]/A_LWL<12>
+ RM_IHPSG13_1P_COLUMN_256_0[5]/RM_IHPSG13_1P_BITKIT_16x2_SRAM_0[0]/A_RWL<7> RM_IHPSG13_1P_COLUMN_256_0[5]/RM_IHPSG13_1P_BITKIT_16x2_SRAM_1[3]/A_RWL<6>
+ RM_IHPSG13_1P_COLUMN_256_0[5]/RM_IHPSG13_1P_BITKIT_16x2_SRAM_1[0]/A_LWL<4> RM_IHPSG13_1P_COLUMN_256_0[5]/RM_IHPSG13_1P_BITKIT_16x2_SRAM_0[0]/A_LWL<2>
+ RM_IHPSG13_1P_COLUMN_256_0[5]/RM_IHPSG13_1P_BITKIT_16x2_SRAM_3[0]/A_RWL<15> RM_IHPSG13_1P_COLUMN_256_0[5]/RM_IHPSG13_1P_BITKIT_16x2_SRAM_3[3]/A_RWL<10>
+ RM_IHPSG13_1P_COLUMN_256_0[5]/RM_IHPSG13_1P_BITKIT_16x2_SRAM_2[1]/A_RWL<0> RM_IHPSG13_1P_COLUMN_256_0[5]/RM_IHPSG13_1P_BITKIT_16x2_SRAM_1[0]/A_LWL<13>
+ RM_IHPSG13_1P_COLUMN_256_0[5]/RM_IHPSG13_1P_BITKIT_16x2_SRAM_1[0]/A_LWL<11> RM_IHPSG13_1P_COLUMN_256_0[5]/RM_IHPSG13_1P_BITKIT_16x2_SRAM_2[3]/A_LWL<10>
+ RM_IHPSG13_1P_COLUMN_256_0[5]/RM_IHPSG13_1P_BITKIT_16x2_SRAM_1[1]/A_LWL<10> RM_IHPSG13_1P_COLUMN_256_0[5]/RM_IHPSG13_1P_BITKIT_16x2_SRAM_0[1]/A_RWL<2>
+ RM_IHPSG13_1P_COLUMN_256_0[5]/RM_IHPSG13_1P_BITKIT_16x2_SRAM_3[0]/A_LWL<3> RM_IHPSG13_1P_COLUMN_256_0[5]/RM_IHPSG13_1P_BITKIT_16x2_SRAM_0[3]/A_LWL<1>
+ RM_IHPSG13_1P_COLUMN_256_0[5]/RM_IHPSG13_1P_BITKIT_16x2_SRAM_3[2]/A_RWL<14> RM_IHPSG13_1P_COLUMN_256_0[5]/RM_IHPSG13_1P_BITKIT_16x2_SRAM_2[3]/A_LWL<0>
+ RM_IHPSG13_1P_COLUMN_256_0[5]/RM_IHPSG13_1P_BITKIT_16x2_SRAM_1[0]/A_LWL<5> RM_IHPSG13_1P_COLUMN_256_0[5]/RM_IHPSG13_1P_BITKIT_16x2_SRAM_3[3]/A_RWL<11>
+ RM_IHPSG13_1P_COLUMN_256_0[5]/RM_IHPSG13_1P_BITKIT_16x2_SRAM_3[3]/A_LWL<6> RM_IHPSG13_1P_COLUMN_256_0[5]/RM_IHPSG13_1P_BITKIT_16x2_SRAM_0[0]/A_LWL<6>
+ RM_IHPSG13_1P_COLUMN_256_0[5]/RM_IHPSG13_1P_BITKIT_16x2_SRAM_3[0]/A_RWL<9> RM_IHPSG13_1P_COLUMN_256_0[5]/RM_IHPSG13_1P_BITKIT_16x2_SRAM_2[3]/A_LWL<9>
+ RM_IHPSG13_1P_COLUMN_256_0[5]/RM_IHPSG13_1P_BITKIT_16x2_SRAM_1[0]/A_LWL<14> RM_IHPSG13_1P_COLUMN_256_0[5]/RM_IHPSG13_1P_BITKIT_16x2_SRAM_2[0]/A_RWL<13>
+ RM_IHPSG13_1P_COLUMN_256_0[5]/RM_IHPSG13_1P_BITKIT_16x2_SRAM_2[2]/A_LWL<15> RM_IHPSG13_1P_COLUMN_256_0[5]/RM_IHPSG13_1P_BITKIT_16x2_SRAM_1[1]/A_LWL<11>
+ RM_IHPSG13_1P_COLUMN_256_0[5]/RM_IHPSG13_1P_BITKIT_16x2_SRAM_3[0]/A_LWL<4> RM_IHPSG13_1P_COLUMN_256_0[5]/RM_IHPSG13_1P_BITKIT_16x2_SRAM_3[0]/A_RWL<8>
+ RM_IHPSG13_1P_COLUMN_256_0[5]/RM_IHPSG13_1P_BITKIT_16x2_SRAM_2[3]/A_LWL<12> RM_IHPSG13_1P_COLUMN_256_0[5]/RM_IHPSG13_1P_BITKIT_16x2_SRAM_2[0]/A_LWL<5>
+ RM_IHPSG13_1P_COLUMN_256_0[5]/RM_IHPSG13_1P_BITKIT_16x2_SRAM_1[1]/A_RWL<1> RM_IHPSG13_1P_COLUMN_256_0[5]/RM_IHPSG13_1P_BITKIT_16x2_SRAM_2[1]/A_RWL<11>
+ RM_IHPSG13_1P_COLUMN_256_0[5]/RM_IHPSG13_1P_BITKIT_16x2_SRAM_3[1]/A_RWL<1> RM_IHPSG13_1P_COLUMN_256_0[5]/RM_IHPSG13_1P_BITKIT_16x2_SRAM_3[0]/A_RWL<1>
+ RM_IHPSG13_1P_COLUMN_256_0[5]/RM_IHPSG13_1P_BITKIT_16x2_SRAM_3[3]/A_RWL<12> RM_IHPSG13_1P_COLUMN_256_0[5]/RM_IHPSG13_1P_BITKIT_16x2_SRAM_2[1]/A_RWL<2>
+ RM_IHPSG13_1P_COLUMN_256_0[5]/RM_IHPSG13_1P_BITKIT_16x2_SRAM_1[1]/A_RWL<3> RM_IHPSG13_1P_COLUMN_256_0[5]/RM_IHPSG13_1P_BITKIT_16x2_SRAM_3[3]/A_LWL<1>
+ RM_IHPSG13_1P_COLUMN_256_0[5]/RM_IHPSG13_1P_BITKIT_16x2_SRAM_2[2]/A_LWL<10> RM_IHPSG13_1P_COLUMN_256_0[5]/RM_IHPSG13_1P_BITKIT_16x2_SRAM_3[2]/A_LWL<12>
+ RM_IHPSG13_1P_COLUMN_256_0[5]/RM_IHPSG13_1P_BITKIT_16x2_SRAM_2[0]/A_RWL<15> RM_IHPSG13_1P_COLUMN_256_0[5]/RM_IHPSG13_1P_BITKIT_16x2_SRAM_2[0]/A_LWL<6>
+ RM_IHPSG13_1P_COLUMN_256_0[5]/RM_IHPSG13_1P_BITKIT_16x2_SRAM_3[2]/A_RWL<11> RM_IHPSG13_1P_COLUMN_256_0[5]/RM_IHPSG13_1P_BITKIT_16x2_SRAM_3[1]/A_RWL<15>
+ RM_IHPSG13_1P_COLUMN_256_0[5]/RM_IHPSG13_1P_BITKIT_16x2_SRAM_0[0]/A_LWL<7> RM_IHPSG13_1P_COLUMN_256_0[5]/RM_IHPSG13_1P_BITKIT_16x2_SRAM_1[3]/A_LWL<6>
+ RM_IHPSG13_1P_COLUMN_256_0[5]/RM_IHPSG13_1P_BITKIT_16x2_SRAM_3[1]/A_RWL<2> RM_IHPSG13_1P_COLUMN_256_0[5]/RM_IHPSG13_1P_BITKIT_16x2_SRAM_2[1]/A_RWL<3>
+ RM_IHPSG13_1P_COLUMN_256_0[5]/RM_IHPSG13_1P_BITKIT_16x2_SRAM_2[3]/A_LWL<3> RM_IHPSG13_1P_COLUMN_256_0[5]/RM_IHPSG13_1P_BITKIT_16x2_SRAM_1[1]/A_RWL<4>
+ RM_IHPSG13_1P_COLUMN_256_0[5]/RM_IHPSG13_1P_BITKIT_16x2_SRAM_0[0]/A_LWL<0> RM_IHPSG13_1P_COLUMN_256_0[5]/RM_IHPSG13_1P_BITKIT_16x2_SRAM_1[1]/A_LWL<13>
+ RM_IHPSG13_1P_COLUMN_256_0[5]/RM_IHPSG13_1P_BITKIT_16x2_SRAM_1[0]/A_RWL<8> RM_IHPSG13_1P_COLUMN_256_0[5]/RM_IHPSG13_1P_BITKIT_16x2_SRAM_0[1]/A_RWL<5>
+ RM_IHPSG13_1P_COLUMN_256_0[5]/RM_IHPSG13_1P_BITKIT_16x2_SRAM_2[3]/A_RWL<9> RM_IHPSG13_1P_COLUMN_256_0[5]/RM_IHPSG13_1P_BITKIT_16x2_SRAM_2[0]/A_LWL<7>
+ RM_IHPSG13_1P_COLUMN_256_0[5]/RM_IHPSG13_1P_BITKIT_16x2_SRAM_1[2]/A_LWL<10> RM_IHPSG13_1P_COLUMN_256_0[5]/RM_IHPSG13_1P_BITKIT_16x2_SRAM_1[0]/A_RWL<1>
+ RM_IHPSG13_1P_COLUMN_256_0[5]/RM_IHPSG13_1P_BITKIT_16x2_SRAM_2[1]/A_RWL<13> RM_IHPSG13_1P_COLUMN_256_0[5]/RM_IHPSG13_1P_BITKIT_16x2_SRAM_3[0]/A_RWL<6>
+ RM_IHPSG13_1P_COLUMN_256_0[5]/RM_IHPSG13_1P_BITKIT_16x2_SRAM_1[0]/A_LWL<8> RM_IHPSG13_1P_COLUMN_256_0[5]/RM_IHPSG13_1P_BITKIT_16x2_SRAM_0[2]/A_RWL<15>
+ RM_IHPSG13_1P_COLUMN_256_0[5]/RM_IHPSG13_1P_BITKIT_16x2_SRAM_3[3]/A_LWL<15> RM_IHPSG13_1P_COLUMN_256_0[5]/RM_IHPSG13_1P_BITKIT_16x2_SRAM_0[1]/A_RWL<4>
+ RM_IHPSG13_1P_COLUMN_256_0[5]/RM_IHPSG13_1P_BITKIT_16x2_SRAM_3[3]/A_RWL<14> RM_IHPSG13_1P_COLUMN_256_0[5]/RM_IHPSG13_1P_BITKIT_16x2_SRAM_0[0]/A_LWL<9>
+ RM_IHPSG13_1P_COLUMN_256_0[5]/RM_IHPSG13_1P_BITKIT_16x2_SRAM_2[1]/A_RWL<4> RM_IHPSG13_1P_COLUMN_256_0[5]/RM_IHPSG13_1P_BITKIT_16x2_SRAM_2[0]/A_RWL<4>
+ RM_IHPSG13_1P_COLUMN_256_0[5]/RM_IHPSG13_1P_BITKIT_16x2_SRAM_3[3]/A_RWL<5> RM_IHPSG13_1P_COLUMN_256_0[5]/RM_IHPSG13_1P_BITKIT_16x2_SRAM_2[1]/A_LWL<10>
+ RM_IHPSG13_1P_COLUMN_256_0[5]/RM_IHPSG13_1P_BITKIT_16x2_SRAM_1[1]/A_LWL<14> RM_IHPSG13_1P_COLUMN_256_0[5]/RM_IHPSG13_1P_BITKIT_16x2_SRAM_0[1]/A_RWL<6>
+ RM_IHPSG13_1P_COLUMN_256_0[5]/RM_IHPSG13_1P_BITKIT_16x2_SRAM_2[3]/A_LWL<15> RM_IHPSG13_1P_COLUMN_256_0[5]/RM_IHPSG13_1P_BITKIT_16x2_SRAM_2[0]/A_LWL<8>
+ RM_IHPSG13_1P_COLUMN_256_0[5]/RM_IHPSG13_1P_BITKIT_16x2_SRAM_3[1]/A_RWL<11> RM_IHPSG13_1P_COLUMN_256_0[5]/RM_IHPSG13_1P_BITKIT_16x2_SRAM_1[2]/A_LWL<11>
+ RM_IHPSG13_1P_COLUMN_256_0[5]/RM_IHPSG13_1P_BITKIT_16x2_SRAM_0[1]/A_LWL<1> RM_IHPSG13_1P_COLUMN_256_0[5]/RM_IHPSG13_1P_BITKIT_16x2_SRAM_1[0]/A_RWL<10>
+ RM_IHPSG13_1P_COLUMN_256_0[5]/RM_IHPSG13_1P_BITKIT_16x2_SRAM_1[0]/A_LWL<1> RM_IHPSG13_1P_COLUMN_256_0[5]/RM_IHPSG13_1P_BITKIT_16x2_SRAM_0[3]/A_LWL<3>
+ RM_IHPSG13_1P_COLUMN_256_0[5]/RM_IHPSG13_1P_BITKIT_16x2_SRAM_2[1]/A_RWL<5> RM_IHPSG13_1P_COLUMN_256_0[5]/RM_IHPSG13_1P_BITKIT_16x2_SRAM_3[0]/A_LWL<0>
+ RM_IHPSG13_1P_COLUMN_256_0[5]/RM_IHPSG13_1P_BITKIT_16x2_SRAM_2[2]/A_RWL<11> RM_IHPSG13_1P_COLUMN_256_0[5]/RM_IHPSG13_1P_BITKIT_16x2_SRAM_3[3]/A_LWL<12>
+ RM_IHPSG13_1P_COLUMN_256_0[5]/RM_IHPSG13_1P_BITKIT_16x2_SRAM_1[1]/A_RWL<6> RM_IHPSG13_1P_COLUMN_256_0[5]/RM_IHPSG13_1P_BITKIT_16x2_SRAM_0[3]/A_RWL<9>
+ RM_IHPSG13_1P_COLUMN_256_0[5]/RM_IHPSG13_1P_BITKIT_16x2_SRAM_2[1]/A_LWL<0> RM_IHPSG13_1P_COLUMN_256_0[5]/RM_IHPSG13_1P_BITKIT_16x2_SRAM_0[1]/A_RWL<7>
+ RM_IHPSG13_1P_COLUMN_256_0[5]/RM_IHPSG13_1P_BITKIT_16x2_SRAM_3[2]/A_RWL<15> RM_IHPSG13_1P_COLUMN_256_0[5]/RM_IHPSG13_1P_BITKIT_16x2_SRAM_2[0]/A_LWL<9>
+ RM_IHPSG13_1P_COLUMN_256_0[5]/RM_IHPSG13_1P_BITKIT_16x2_SRAM_1[0]/A_RWL<6> RM_IHPSG13_1P_COLUMN_256_0[5]/RM_IHPSG13_1P_BITKIT_16x2_SRAM_2[1]/A_RWL<15>
+ RM_IHPSG13_1P_COLUMN_256_0[5]/RM_IHPSG13_1P_BITKIT_16x2_SRAM_0[1]/A_LWL<2> RM_IHPSG13_1P_COLUMN_256_0[5]/RM_IHPSG13_1P_BITKIT_16x2_SRAM_3[2]/A_LWL<15>
+ RM_IHPSG13_1P_COLUMN_256_0[5]/RM_IHPSG13_1P_BITKIT_16x2_SRAM_0[0]/A_RWL<4> RM_IHPSG13_1P_COLUMN_256_0[5]/RM_IHPSG13_1P_BITKIT_16x2_SRAM_1[3]/A_RWL<5>
+ RM_IHPSG13_1P_COLUMN_256_0[5]/RM_IHPSG13_1P_BITKIT_16x2_SRAM_0[1]/A_LWL<0> RM_IHPSG13_1P_COLUMN_256_0[5]/RM_IHPSG13_1P_BITKIT_16x2_SRAM_2[0]/A_LWL<10>
+ RM_IHPSG13_1P_COLUMN_256_0[5]/RM_IHPSG13_1P_BITKIT_16x2_SRAM_3[0]/A_LWL<9> RM_IHPSG13_1P_COLUMN_256_0[5]/RM_IHPSG13_1P_BITKIT_16x2_SRAM_0[0]/A_LWL<12>
+ RM_IHPSG13_1P_COLUMN_256_0[5]/RM_IHPSG13_1P_BITKIT_16x2_SRAM_0[0]/A_RWL<3> RM_IHPSG13_1P_COLUMN_256_0[5]/RM_IHPSG13_1P_BITKIT_16x2_SRAM_0[3]/A_RWL<15>
+ RM_IHPSG13_1P_COLUMN_256_0[5]/RM_IHPSG13_1P_BITKIT_16x2_SRAM_3[0]/A_RWL<11> RM_IHPSG13_1P_COLUMN_256_0[5]/RM_IHPSG13_1P_BITKIT_16x2_SRAM_1[2]/A_LWL<13>
+ RM_IHPSG13_1P_COLUMN_256_0[5]/RM_IHPSG13_1P_BITKIT_16x2_SRAM_1[0]/A_RWL<12> RM_IHPSG13_1P_COLUMN_256_0[5]/RM_IHPSG13_1P_BITKIT_16x2_SRAM_3[1]/A_RWL<6>
+ RM_IHPSG13_1P_COLUMN_256_0[5]/RM_IHPSG13_1P_BITKIT_16x2_SRAM_3[0]/A_LWL<6> RM_IHPSG13_1P_COLUMN_256_0[5]/RM_IHPSG13_1P_BITKIT_16x2_SRAM_2[1]/A_RWL<7>
+ RM_IHPSG13_1P_COLUMN_256_0[5]/RM_IHPSG13_1P_BITKIT_16x2_SRAM_2[2]/A_RWL<13> RM_IHPSG13_1P_COLUMN_256_0[5]/RM_IHPSG13_1P_BITKIT_16x2_SRAM_0[2]/A_RWL<0>
+ RM_IHPSG13_1P_COLUMN_256_0[5]/RM_IHPSG13_1P_BITKIT_16x2_SRAM_3[1]/A_LWL<1> RM_IHPSG13_1P_COLUMN_256_0[5]/RM_IHPSG13_1P_BITKIT_16x2_SRAM_1[1]/A_RWL<8>
+ RM_IHPSG13_1P_COLUMN_256_0[5]/RM_IHPSG13_1P_BITKIT_16x2_SRAM_2[1]/A_LWL<2> RM_IHPSG13_1P_COLUMN_256_0[5]/RM_IHPSG13_1P_BITKIT_16x2_SRAM_1[1]/A_LWL<3>
+ RM_IHPSG13_1P_COLUMN_256_0[5]/RM_IHPSG13_1P_BITKIT_16x2_SRAM_1[1]/A_LWL<1> RM_IHPSG13_1P_COLUMN_256_0[5]/RM_IHPSG13_1P_BITKIT_16x2_SRAM_1[2]/A_LWL<14>
+ RM_IHPSG13_1P_COLUMN_256_0[5]/RM_IHPSG13_1P_BITKIT_16x2_SRAM_1[0]/A_LWL<12> RM_IHPSG13_1P_COLUMN_256_0[5]/RM_IHPSG13_1P_BITKIT_16x2_SRAM_0[1]/A_LWL<10>
+ RM_IHPSG13_1P_COLUMN_256_0[5]/RM_IHPSG13_1P_BITKIT_16x2_SRAM_0[1]/A_LWL<4> RM_IHPSG13_1P_COLUMN_256_0[5]/RM_IHPSG13_1P_BITKIT_16x2_SRAM_1[3]/A_LWL<4>
+ RM_IHPSG13_1P_COLUMN_256_0[5]/RM_IHPSG13_1P_BITKIT_16x2_SRAM_3[1]/A_LWL<0> RM_IHPSG13_1P_COLUMN_256_0[5]/RM_IHPSG13_1P_BITKIT_16x2_SRAM_3[1]/A_LWL<15>
+ RM_IHPSG13_1P_COLUMN_256_0[5]/RM_IHPSG13_1P_BITKIT_16x2_SRAM_1[3]/A_LWL<11> RM_IHPSG13_1P_COLUMN_256_0[5]/RM_IHPSG13_1P_BITKIT_16x2_SRAM_1[0]/A_RWL<2>
+ RM_IHPSG13_1P_COLUMN_256_0[5]/RM_IHPSG13_1P_BITKIT_16x2_SRAM_1[1]/A_RWL<10> RM_IHPSG13_1P_COLUMN_256_0[5]/RM_IHPSG13_1P_BITKIT_16x2_SRAM_3[1]/A_RWL<5>
+ RM_IHPSG13_1P_COLUMN_256_0[5]/RM_IHPSG13_1P_BITKIT_16x2_SRAM_0[0]/A_LWL<10> RM_IHPSG13_1P_COLUMN_256_0[5]/RM_IHPSG13_1P_BITKIT_16x2_SRAM_0[3]/A_RWL<12>
+ RM_IHPSG13_1P_COLUMN_256_0[5]/RM_IHPSG13_1P_BITKIT_16x2_SRAM_3[0]/A_RWL<3> RM_IHPSG13_1P_COLUMN_256_0[5]/RM_IHPSG13_1P_BITKIT_16x2_SRAM_1[1]/A_RWL<9>
+ RM_IHPSG13_1P_COLUMN_256_0[5]/RM_IHPSG13_1P_BITKIT_16x2_SRAM_3[3]/A_RWL<15> RM_IHPSG13_1P_COLUMN_256_0[5]/RM_IHPSG13_1P_BITKIT_16x2_SRAM_2[2]/A_RWL<12>
+ RM_IHPSG13_1P_COLUMN_256_0[5]/RM_IHPSG13_1P_BITKIT_16x2_SRAM_2[1]/A_LWL<3> RM_IHPSG13_1P_COLUMN_256_0[5]/RM_IHPSG13_1P_BITKIT_16x2_SRAM_1[0]/A_RWL<11>
+ RM_IHPSG13_1P_COLUMN_256_0[5]/RM_IHPSG13_1P_BITKIT_16x2_SRAM_2[3]/A_RWL<10> RM_IHPSG13_1P_COLUMN_256_0[5]/RM_IHPSG13_1P_BITKIT_16x2_SRAM_1[1]/A_LWL<4>
+ RM_IHPSG13_1P_COLUMN_256_0[5]/RM_IHPSG13_1P_BITKIT_16x2_SRAM_1[2]/A_LWL<15> RM_IHPSG13_1P_COLUMN_256_0[5]/RM_IHPSG13_1P_BITKIT_16x2_SRAM_2[2]/A_RWL<0>
+ RM_IHPSG13_1P_COLUMN_256_0[5]/RM_IHPSG13_1P_BITKIT_16x2_SRAM_1[0]/A_LWL<6> RM_IHPSG13_1P_COLUMN_256_0[5]/RM_IHPSG13_1P_BITKIT_16x2_SRAM_1[0]/A_RWL<14>
+ RM_IHPSG13_1P_COLUMN_256_0[5]/RM_IHPSG13_1P_BITKIT_16x2_SRAM_3[1]/A_RWL<8> RM_IHPSG13_1P_COLUMN_256_0[5]/RM_IHPSG13_1P_BITKIT_16x2_SRAM_3[3]/A_RWL<7>
+ RM_IHPSG13_1P_COLUMN_256_0[5]/RM_IHPSG13_1P_BITKIT_16x2_SRAM_1[2]/A_RWL<1> RM_IHPSG13_1P_COLUMN_256_0[5]/RM_IHPSG13_1P_BITKIT_16x2_SRAM_0[1]/A_LWL<3>
+ RM_IHPSG13_1P_COLUMN_256_0[5]/RM_IHPSG13_1P_BITKIT_16x2_SRAM_2[1]/A_RWL<9> RM_IHPSG13_1P_COLUMN_256_0[5]/RM_IHPSG13_1P_BITKIT_16x2_SRAM_2[2]/A_RWL<15>
+ RM_IHPSG13_1P_COLUMN_256_0[5]/RM_IHPSG13_1P_BITKIT_16x2_SRAM_1[1]/A_RWL<11> RM_IHPSG13_1P_COLUMN_256_0[5]/RM_IHPSG13_1P_BITKIT_16x2_SRAM_2[0]/A_LWL<3>
+ RM_IHPSG13_1P_COLUMN_256_0[5]/RM_IHPSG13_1P_BITKIT_16x2_SRAM_0[2]/A_RWL<2> RM_IHPSG13_1P_COLUMN_256_0[5]/RM_IHPSG13_1P_BITKIT_16x2_SRAM_3[1]/A_LWL<3>
+ RM_IHPSG13_1P_COLUMN_256_0[5]/RM_IHPSG13_1P_BITKIT_16x2_SRAM_0[2]/A_LWL<9> RM_IHPSG13_1P_COLUMN_256_0[5]/RM_IHPSG13_1P_BITKIT_16x2_SRAM_2[0]/A_LWL<13>
+ RM_IHPSG13_1P_COLUMN_256_0[5]/RM_IHPSG13_1P_BITKIT_16x2_SRAM_3[3]/A_LWL<2> RM_IHPSG13_1P_COLUMN_256_0[5]/RM_IHPSG13_1P_BITKIT_16x2_SRAM_0[1]/A_RWL<3>
+ RM_IHPSG13_1P_COLUMN_256_0[5]/RM_IHPSG13_1P_BITKIT_16x2_SRAM_0[1]/A_RWL<9> RM_IHPSG13_1P_COLUMN_256_0[5]/RM_IHPSG13_1P_BITKIT_16x2_SRAM_2[3]/A_RWL<12>
+ RM_IHPSG13_1P_COLUMN_256_0[5]/RM_IHPSG13_1P_BITKIT_16x2_SRAM_2[3]/A_LWL<5> RM_IHPSG13_1P_COLUMN_256_0[5]/RM_IHPSG13_1P_BITKIT_16x2_SRAM_2[2]/A_LWL<8>
+ RM_IHPSG13_1P_COLUMN_256_0[5]/RM_IHPSG13_1P_BITKIT_16x2_SRAM_0[0]/A_LWL<15> RM_IHPSG13_1P_COLUMN_256_0[5]/RM_IHPSG13_1P_BITKIT_16x2_SRAM_2[0]/A_RWL<9>
+ RM_IHPSG13_1P_COLUMN_256_0[5]/RM_IHPSG13_1P_BITKIT_16x2_SRAM_1[1]/A_LWL<5> RM_IHPSG13_1P_COLUMN_256_0[5]/RM_IHPSG13_1P_BITKIT_16x2_SRAM_3[2]/A_RWL<0>
+ RM_IHPSG13_1P_COLUMN_256_0[5]/RM_IHPSG13_1P_BITKIT_16x2_SRAM_1[1]/A_LWL<15> RM_IHPSG13_1P_COLUMN_256_0[5]/RM_IHPSG13_1P_BITKIT_16x2_SRAM_0[1]/A_LWL<12>
+ RM_IHPSG13_1P_COLUMN_256_0[5]/RM_IHPSG13_1P_BITKIT_16x2_SRAM_0[1]/A_LWL<6> RM_IHPSG13_1P_COLUMN_256_0[5]/RM_IHPSG13_1P_BITKIT_16x2_SRAM_3[0]/A_LWL<15>
+ RM_IHPSG13_1P_COLUMN_256_0[5]/RM_IHPSG13_1P_BITKIT_16x2_SRAM_3[1]/A_RWL<9> RM_IHPSG13_1P_COLUMN_256_0[5]/RM_IHPSG13_1P_BITKIT_16x2_SRAM_1[3]/A_LWL<13>
+ RM_IHPSG13_1P_COLUMN_256_0[5]/RM_IHPSG13_1P_BITKIT_16x2_SRAM_1[1]/A_RWL<5> RM_IHPSG13_1P_COLUMN_256_0[5]/RM_IHPSG13_1P_BITKIT_16x2_SRAM_1[1]/A_RWL<12>
+ RM_IHPSG13_1P_COLUMN_256_0[5]/RM_IHPSG13_1P_BITKIT_16x2_SRAM_3[0]/A_RWL<5> RM_IHPSG13_1P_COLUMN_256_0[5]/RM_IHPSG13_1P_BITKIT_16x2_SRAM_3[1]/A_LWL<4>
+ RM_IHPSG13_1P_COLUMN_256_0[5]/RM_IHPSG13_1P_BITKIT_16x2_SRAM_2[3]/A_RWL<13> RM_IHPSG13_1P_COLUMN_256_0[5]/RM_IHPSG13_1P_BITKIT_16x2_SRAM_2[1]/A_RWL<12>
+ RM_IHPSG13_1P_COLUMN_256_0[5]/RM_IHPSG13_1P_BITKIT_16x2_SRAM_2[1]/A_LWL<5> RM_IHPSG13_1P_COLUMN_256_0[5]/RM_IHPSG13_1P_BITKIT_16x2_SRAM_0[3]/A_RWL<10>
+ RM_IHPSG13_1P_COLUMN_256_0[5]/RM_IHPSG13_1P_BITKIT_16x2_SRAM_1[1]/A_LWL<12> RM_IHPSG13_1P_COLUMN_256_0[5]/RM_IHPSG13_1P_BITKIT_16x2_SRAM_2[2]/A_RWL<10>
+ RM_IHPSG13_1P_COLUMN_256_0[5]/RM_IHPSG13_1P_BITKIT_16x2_SRAM_1[1]/A_LWL<6> RM_IHPSG13_1P_COLUMN_256_0[5]/RM_IHPSG13_1P_BITKIT_16x2_SRAM_3[2]/A_RWL<1>
+ RM_IHPSG13_1P_COLUMN_256_0[5]/RM_IHPSG13_1P_BITKIT_16x2_SRAM_0[1]/A_LWL<13> RM_IHPSG13_1P_COLUMN_256_0[5]/RM_IHPSG13_1P_BITKIT_16x2_SRAM_1[3]/A_RWL<7>
+ RM_IHPSG13_1P_COLUMN_256_0[5]/RM_IHPSG13_1P_BITKIT_16x2_SRAM_0[1]/A_LWL<7> RM_IHPSG13_1P_COLUMN_256_0[5]/RM_IHPSG13_1P_BITKIT_16x2_SRAM_2[2]/A_RWL<2>
+ RM_IHPSG13_1P_COLUMN_256_0[5]/RM_IHPSG13_1P_BITKIT_16x2_SRAM_1[1]/A_RWL<2> RM_IHPSG13_1P_COLUMN_256_0[5]/RM_IHPSG13_1P_BITKIT_16x2_SRAM_1[2]/A_RWL<0>
+ RM_IHPSG13_1P_COLUMN_256_0[5]/RM_IHPSG13_1P_BITKIT_16x2_SRAM_1[0]/A_RWL<15> RM_IHPSG13_1P_COLUMN_256_0[5]/RM_IHPSG13_1P_BITKIT_16x2_SRAM_3[2]/A_LWL<9>
+ RM_IHPSG13_1P_COLUMN_256_0[5]/RM_IHPSG13_1P_BITKIT_16x2_SRAM_1[3]/A_LWL<14> RM_IHPSG13_1P_COLUMN_256_0[5]/RM_IHPSG13_1P_BITKIT_16x2_SRAM_3[1]/A_RWL<0>
+ RM_IHPSG13_1P_COLUMN_256_0[5]/RM_IHPSG13_1P_BITKIT_16x2_SRAM_3[1]/A_RWL<3> RM_IHPSG13_1P_COLUMN_256_0[5]/RM_IHPSG13_1P_BITKIT_16x2_SRAM_0[0]/A_LWL<3>
+ RM_IHPSG13_1P_COLUMN_256_0[5]/RM_IHPSG13_1P_BITKIT_16x2_SRAM_1[2]/A_RWL<3> RM_IHPSG13_1P_COLUMN_256_0[5]/RM_IHPSG13_1P_BITKIT_16x2_SRAM_0[2]/A_LWL<10>
+ RM_IHPSG13_1P_COLUMN_256_0[5]/RM_IHPSG13_1P_BITKIT_16x2_SRAM_1[3]/A_LWL<2> RM_IHPSG13_1P_COLUMN_256_0[5]/RM_IHPSG13_1P_BITKIT_16x2_SRAM_0[2]/A_RWL<4>
+ RM_IHPSG13_1P_COLUMN_256_0[5]/RM_IHPSG13_1P_BITKIT_16x2_SRAM_0[0]/A_RWL<9> RM_IHPSG13_1P_COLUMN_256_0[5]/RM_IHPSG13_1P_BITKIT_16x2_SRAM_2[1]/A_LWL<6>
+ RM_IHPSG13_1P_COLUMN_256_0[5]/RM_IHPSG13_1P_BITKIT_16x2_SRAM_1[2]/A_RWL<10> RM_IHPSG13_1P_COLUMN_256_0[5]/RM_IHPSG13_1P_BITKIT_16x2_SRAM_2[3]/A_LWL<11>
+ RM_IHPSG13_1P_COLUMN_256_0[5]/RM_IHPSG13_1P_BITKIT_16x2_SRAM_3[2]/A_RWL<2> RM_IHPSG13_1P_COLUMN_256_0[5]/RM_IHPSG13_1P_BITKIT_16x2_SRAM_1[0]/A_LWL<15>
+ RM_IHPSG13_1P_COLUMN_256_0[5]/RM_IHPSG13_1P_BITKIT_16x2_SRAM_0[3]/A_LWL<0> RM_IHPSG13_1P_COLUMN_256_0[5]/RM_IHPSG13_1P_BITKIT_16x2_SRAM_2[3]/A_LWL<14>
+ RM_IHPSG13_1P_COLUMN_256_0[5]/RM_IHPSG13_1P_BITKIT_16x2_SRAM_2[2]/A_RWL<3> RM_IHPSG13_1P_COLUMN_256_0[5]/RM_IHPSG13_1P_BITKIT_16x2_SRAM_0[0]/A_LWL<5>
+ RM_IHPSG13_1P_COLUMN_256_0[5]/RM_IHPSG13_1P_BITKIT_16x2_SRAM_1[3]/A_LWL<15> RM_IHPSG13_1P_COLUMN_256_0[5]/RM_IHPSG13_1P_BITKIT_16x2_SRAM_1[0]/A_RWL<5>
+ RM_IHPSG13_1P_COLUMN_256_0[5]/RM_IHPSG13_1P_BITKIT_16x2_SRAM_2[1]/A_LWL<13> RM_IHPSG13_1P_COLUMN_256_0[5]/RM_IHPSG13_1P_BITKIT_16x2_SRAM_0[3]/A_LWL<9>
+ RM_IHPSG13_1P_COLUMN_256_0[5]/RM_IHPSG13_1P_BITKIT_16x2_SRAM_0[2]/A_RWL<3> RM_IHPSG13_1P_COLUMN_256_0[5]/RM_IHPSG13_1P_BITKIT_16x2_SRAM_3[3]/A_LWL<7>
+ RM_IHPSG13_1P_COLUMN_256_0[5]/RM_IHPSG13_1P_BITKIT_16x2_SRAM_2[0]/A_LWL<4> RM_IHPSG13_1P_COLUMN_256_0[5]/RM_IHPSG13_1P_BITKIT_16x2_SRAM_1[1]/A_RWL<14>
+ RM_IHPSG13_1P_COLUMN_256_0[5]/RM_IHPSG13_1P_BITKIT_16x2_SRAM_0[2]/A_RWL<5> RM_IHPSG13_1P_COLUMN_256_0[5]/RM_IHPSG13_1P_BITKIT_16x2_SRAM_2[3]/A_LWL<8>
+ RM_IHPSG13_1P_COLUMN_256_0[5]/RM_IHPSG13_1P_BITKIT_16x2_SRAM_3[1]/A_LWL<6> RM_IHPSG13_1P_COLUMN_256_0[5]/RM_IHPSG13_1P_BITKIT_16x2_SRAM_2[0]/A_RWL<12>
+ RM_IHPSG13_1P_COLUMN_256_0[5]/RM_IHPSG13_1P_BITKIT_16x2_SRAM_2[3]/A_RWL<15> RM_IHPSG13_1P_COLUMN_256_0[5]/RM_IHPSG13_1P_BITKIT_16x2_SRAM_1[2]/A_RWL<11>
+ RM_IHPSG13_1P_COLUMN_256_0[5]/RM_IHPSG13_1P_BITKIT_16x2_SRAM_2[1]/A_LWL<7> RM_IHPSG13_1P_COLUMN_256_0[5]/RM_IHPSG13_1P_BITKIT_16x2_SRAM_2[0]/A_RWL<14>
+ RM_IHPSG13_1P_COLUMN_256_0[5]/RM_IHPSG13_1P_BITKIT_16x2_SRAM_3[3]/A_RWL<13> RM_IHPSG13_1P_COLUMN_256_0[5]/RM_IHPSG13_1P_BITKIT_16x2_SRAM_0[2]/A_LWL<0>
+ RM_IHPSG13_1P_COLUMN_256_0[5]/RM_IHPSG13_1P_BITKIT_16x2_SRAM_2[1]/A_RWL<10> RM_IHPSG13_1P_COLUMN_256_0[5]/RM_IHPSG13_1P_BITKIT_16x2_SRAM_1[1]/A_LWL<8>
+ RM_IHPSG13_1P_COLUMN_256_0[5]/RM_IHPSG13_1P_BITKIT_16x2_SRAM_0[1]/A_LWL<15> RM_IHPSG13_1P_COLUMN_256_0[5]/RM_IHPSG13_1P_BITKIT_16x2_SRAM_0[1]/A_LWL<9>
+ RM_IHPSG13_1P_COLUMN_256_0[5]/RM_IHPSG13_1P_BITKIT_16x2_SRAM_2[2]/A_RWL<4> RM_IHPSG13_1P_COLUMN_256_0[5]/RM_IHPSG13_1P_BITKIT_16x2_SRAM_1[1]/A_RWL<0>
+ RM_IHPSG13_1P_COLUMN_256_0[5]/RM_IHPSG13_1P_BITKIT_16x2_SRAM_3[1]/A_RWL<7> RM_IHPSG13_1P_COLUMN_256_0[5]/RM_IHPSG13_1P_BITKIT_16x2_SRAM_3[0]/A_RWL<0>
+ RM_IHPSG13_1P_COLUMN_256_0[5]/RM_IHPSG13_1P_BITKIT_16x2_SRAM_1[2]/A_RWL<5> RM_IHPSG13_1P_COLUMN_256_0[5]/RM_IHPSG13_1P_BITKIT_16x2_SRAM_0[2]/A_LWL<12>
+ RM_IHPSG13_1P_COLUMN_256_0[5]/RM_IHPSG13_1P_BITKIT_16x2_SRAM_0[0]/A_RWL<11> RM_IHPSG13_1P_COLUMN_256_0[5]/RM_IHPSG13_1P_BITKIT_16x2_SRAM_1[3]/A_LWL<1>
+ RM_IHPSG13_1P_COLUMN_256_0[5]/RM_IHPSG13_1P_BITKIT_16x2_SRAM_3[1]/A_LWL<2> RM_IHPSG13_1P_COLUMN_256_0[5]/RM_IHPSG13_1P_BITKIT_16x2_SRAM_1[2]/A_LWL<12>
+ RM_IHPSG13_1P_COLUMN_256_0[5]/RM_IHPSG13_1P_BITKIT_16x2_SRAM_1[2]/A_LWL<0> RM_IHPSG13_1P_COLUMN_256_0[5]/RM_IHPSG13_1P_BITKIT_16x2_SRAM_3[3]/A_LWL<0>
+ RM_IHPSG13_1P_COLUMN_256_0[5]/RM_IHPSG13_1P_BITKIT_16x2_SRAM_1[2]/A_RWL<12> RM_IHPSG13_1P_COLUMN_256_0[5]/RM_IHPSG13_1P_BITKIT_16x2_SRAM_2[1]/A_LWL<8>
+ RM_IHPSG13_1P_COLUMN_256_0[5]/RM_IHPSG13_1P_BITKIT_16x2_SRAM_2[2]/A_LWL<11> RM_IHPSG13_1P_COLUMN_256_0[5]/RM_IHPSG13_1P_BITKIT_16x2_SRAM_0[2]/A_LWL<1>
+ RM_IHPSG13_1P_COLUMN_256_0[5]/RM_IHPSG13_1P_BITKIT_16x2_SRAM_1[2]/A_RWL<2> RM_IHPSG13_1P_COLUMN_256_0[5]/RM_IHPSG13_1P_BITKIT_16x2_SRAM_3[0]/A_LWL<5>
+ RM_IHPSG13_1P_COLUMN_256_0[5]/RM_IHPSG13_1P_BITKIT_16x2_SRAM_1[1]/A_RWL<15> RM_IHPSG13_1P_COLUMN_256_0[5]/RM_IHPSG13_1P_BITKIT_16x2_SRAM_3[3]/A_LWL<9>
+ RM_IHPSG13_1P_COLUMN_256_0[5]/RM_IHPSG13_1P_BITKIT_16x2_SRAM_2[2]/A_LWL<14> RM_IHPSG13_1P_COLUMN_256_0[5]/RM_IHPSG13_1P_BITKIT_16x2_SRAM_3[2]/A_RWL<3>
+ RM_IHPSG13_1P_COLUMN_256_0[5]/RM_IHPSG13_1P_BITKIT_16x2_SRAM_2[2]/A_RWL<5> RM_IHPSG13_1P_COLUMN_256_0[5]/RM_IHPSG13_1P_BITKIT_16x2_SRAM_1[3]/A_LWL<7>
+ RM_IHPSG13_1P_COLUMN_256_0[5]/RM_IHPSG13_1P_BITKIT_16x2_SRAM_1[2]/A_RWL<6> RM_IHPSG13_1P_COLUMN_256_0[5]/RM_IHPSG13_1P_BITKIT_16x2_SRAM_0[2]/A_LWL<13>
+ RM_IHPSG13_1P_COLUMN_256_0[5]/RM_IHPSG13_1P_BITKIT_16x2_SRAM_3[2]/A_LWL<7> RM_IHPSG13_1P_COLUMN_256_0[5]/RM_IHPSG13_1P_BITKIT_16x2_SRAM_2[2]/A_LWL<0>
+ RM_IHPSG13_1P_COLUMN_256_0[5]/RM_IHPSG13_1P_BITKIT_16x2_SRAM_0[0]/A_RWL<12> RM_IHPSG13_1P_COLUMN_256_0[5]/RM_IHPSG13_1P_BITKIT_16x2_SRAM_0[2]/A_RWL<7>
+ RM_IHPSG13_1P_COLUMN_256_0[5]/RM_IHPSG13_1P_BITKIT_16x2_SRAM_0[3]/A_LWL<10> RM_IHPSG13_1P_COLUMN_256_0[5]/RM_IHPSG13_1P_BITKIT_16x2_SRAM_1[2]/A_LWL<1>
+ RM_IHPSG13_1P_COLUMN_256_0[5]/RM_IHPSG13_1P_BITKIT_16x2_SRAM_3[2]/A_RWL<13> RM_IHPSG13_1P_COLUMN_256_0[5]/RM_IHPSG13_1P_BITKIT_16x2_SRAM_2[1]/A_LWL<9>
+ RM_IHPSG13_1P_COLUMN_256_0[5]/RM_IHPSG13_1P_BITKIT_16x2_SRAM_2[0]/A_RWL<10> RM_IHPSG13_1P_COLUMN_256_0[5]/RM_IHPSG13_1P_BITKIT_16x2_SRAM_0[2]/A_LWL<2>
+ RM_IHPSG13_1P_COLUMN_256_0[5]/RM_IHPSG13_1P_BITKIT_16x2_SRAM_2[3]/A_RWL<8> RM_IHPSG13_1P_COLUMN_256_0[5]/RM_IHPSG13_1P_BITKIT_16x2_SRAM_3[2]/A_RWL<5>
+ RM_IHPSG13_1P_COLUMN_256_0[5]/RM_IHPSG13_1P_BITKIT_16x2_SRAM_1[3]/A_RWL<10> RM_IHPSG13_1P_COLUMN_256_0[5]/RM_IHPSG13_1P_BITKIT_16x2_SRAM_0[1]/A_LWL<5>
+ RM_IHPSG13_1P_COLUMN_256_0[5]/RM_IHPSG13_1P_BITKIT_16x2_SRAM_0[0]/A_LWL<8> RM_IHPSG13_1P_COLUMN_256_0[5]/RM_IHPSG13_1P_BITKIT_16x2_SRAM_1[1]/A_RWL<7>
+ RM_IHPSG13_1P_COLUMN_256_0[5]/RM_IHPSG13_1P_BITKIT_16x2_SRAM_2[2]/A_LWL<13> RM_IHPSG13_1P_COLUMN_256_0[5]/RM_IHPSG13_1P_BITKIT_16x2_SRAM_1[0]/A_RWL<0>
+ RM_IHPSG13_1P_COLUMN_256_0[5]/RM_IHPSG13_1P_BITKIT_16x2_SRAM_2[1]/A_LWL<4> RM_IHPSG13_1P_COLUMN_256_0[5]/RM_IHPSG13_1P_BITKIT_16x2_SRAM_3[0]/A_RWL<7>
+ RM_IHPSG13_1P_COLUMN_256_0[5]/RM_IHPSG13_1P_BITKIT_16x2_SRAM_3[2]/A_LWL<0> RM_IHPSG13_1P_COLUMN_256_0[5]/RM_IHPSG13_1P_BITKIT_16x2_SRAM_1[2]/A_RWL<7>
+ RM_IHPSG13_1P_COLUMN_256_0[5]/RM_IHPSG13_1P_BITKIT_16x2_SRAM_1[1]/A_LWL<2> RM_IHPSG13_1P_COLUMN_256_0[5]/RM_IHPSG13_1P_BITKIT_16x2_SRAM_0[0]/A_RWL<13>
+ RM_IHPSG13_1P_COLUMN_256_0[5]/RM_IHPSG13_1P_BITKIT_16x2_SRAM_2[1]/A_RWL<14> RM_IHPSG13_1P_COLUMN_256_0[5]/RM_IHPSG13_1P_BITKIT_16x2_SRAM_2[2]/A_LWL<1>
+ RM_IHPSG13_1P_COLUMN_256_0[5]/RM_IHPSG13_1P_BITKIT_16x2_SRAM_3[1]/A_LWL<9> RM_IHPSG13_1P_COLUMN_256_0[5]/RM_IHPSG13_1P_BITKIT_16x2_SRAM_3[0]/A_LWL<2>
+ RM_IHPSG13_1P_COLUMN_256_0[5]/RM_IHPSG13_1P_BITKIT_16x2_SRAM_3[3]/A_RWL<4> RM_IHPSG13_1P_COLUMN_256_0[5]/RM_IHPSG13_1P_BITKIT_16x2_SRAM_0[2]/A_LWL<11>
+ RM_IHPSG13_1P_COLUMN_256_0[5]/RM_IHPSG13_1P_BITKIT_16x2_SRAM_0[3]/A_LWL<11> RM_IHPSG13_1P_COLUMN_256_0[5]/RM_IHPSG13_1P_BITKIT_16x2_SRAM_1[2]/A_LWL<2>
+ RM_IHPSG13_1P_COLUMN_256_0[5]/RM_IHPSG13_1P_BITKIT_16x2_SRAM_1[2]/A_RWL<14> RM_IHPSG13_1P_COLUMN_256_0[5]/RM_IHPSG13_1P_BITKIT_16x2_SRAM_2[1]/A_LWL<11>
+ RM_IHPSG13_1P_COLUMN_256_0[5]/RM_IHPSG13_1P_BITKIT_16x2_SRAM_0[1]/A_RWL<10> RM_IHPSG13_1P_COLUMN_256_0[5]/RM_IHPSG13_1P_BITKIT_16x2_SRAM_0[2]/A_LWL<3>
+ RM_IHPSG13_1P_COLUMN_256_0[5]/RM_IHPSG13_1P_BITKIT_16x2_SRAM_0[2]/A_LWL<14> RM_IHPSG13_1P_COLUMN_256_0[5]/RM_IHPSG13_1P_BITKIT_16x2_SRAM_3[2]/A_RWL<6>
+ RM_IHPSG13_1P_COLUMN_256_0[5]/RM_IHPSG13_1P_BITKIT_16x2_SRAM_1[3]/A_RWL<11> RM_IHPSG13_1P_COLUMN_256_0[5]/RM_IHPSG13_1P_BITKIT_16x2_SRAM_2[1]/A_LWL<14>
+ RM_IHPSG13_1P_COLUMN_256_0[5]/RM_IHPSG13_1P_BITKIT_16x2_SRAM_2[2]/A_RWL<7> RM_IHPSG13_1P_COLUMN_256_0[5]/RM_IHPSG13_1P_BITKIT_16x2_SRAM_0[3]/A_RWL<0>
+ RM_IHPSG13_1P_COLUMN_256_0[5]/RM_IHPSG13_1P_BITKIT_16x2_SRAM_1[0]/A_LWL<0> RM_IHPSG13_1P_COLUMN_256_0[5]/RM_IHPSG13_1P_BITKIT_16x2_SRAM_1[2]/A_RWL<8>
+ RM_IHPSG13_1P_COLUMN_256_0[5]/RM_IHPSG13_1P_BITKIT_16x2_SRAM_3[2]/A_LWL<1> RM_IHPSG13_1P_COLUMN_256_0[5]/RM_IHPSG13_1P_BITKIT_16x2_SRAM_0[2]/A_LWL<15>
+ RM_IHPSG13_1P_COLUMN_256_0[5]/RM_IHPSG13_1P_BITKIT_16x2_SRAM_1[3]/A_LWL<12> RM_IHPSG13_1P_COLUMN_256_0[5]/RM_IHPSG13_1P_BITKIT_16x2_SRAM_3[1]/A_LWL<7>
+ RM_IHPSG13_1P_COLUMN_256_0[5]/RM_IHPSG13_1P_BITKIT_16x2_SRAM_0[2]/A_RWL<9> RM_IHPSG13_1P_COLUMN_256_0[5]/RM_IHPSG13_1P_BITKIT_16x2_SRAM_0[0]/A_RWL<14>
+ RM_IHPSG13_1P_COLUMN_256_0[5]/RM_IHPSG13_1P_BITKIT_16x2_SRAM_2[2]/A_LWL<2> RM_IHPSG13_1P_COLUMN_256_0[5]/RM_IHPSG13_1P_BITKIT_16x2_SRAM_1[2]/A_RWL<13>
+ RM_IHPSG13_1P_COLUMN_256_0[5]/RM_IHPSG13_1P_BITKIT_16x2_SRAM_1[0]/A_LWL<9> RM_IHPSG13_1P_COLUMN_256_0[5]/RM_IHPSG13_1P_BITKIT_16x2_SRAM_0[3]/A_LWL<12>
+ RM_IHPSG13_1P_COLUMN_256_0[5]/RM_IHPSG13_1P_BITKIT_16x2_SRAM_1[2]/A_LWL<3> RM_IHPSG13_1P_COLUMN_256_0[5]/RM_IHPSG13_1P_BITKIT_16x2_SRAM_3[1]/A_RWL<13>
+ RM_IHPSG13_1P_COLUMN_256_0[5]/RM_IHPSG13_1P_BITKIT_16x2_SRAM_3[1]/A_LWL<5> RM_IHPSG13_1P_COLUMN_256_0[5]/RM_IHPSG13_1P_BITKIT_16x2_SRAM_0[0]/A_RWL<10>
+ RM_IHPSG13_1P_COLUMN_256_0[5]/RM_IHPSG13_1P_BITKIT_16x2_SRAM_0[3]/A_RWL<8> RM_IHPSG13_1P_COLUMN_256_0[5]/RM_IHPSG13_1P_BITKIT_16x2_SRAM_1[2]/A_RWL<15>
+ RM_IHPSG13_1P_COLUMN_256_0[5]/RM_IHPSG13_1P_BITKIT_16x2_SRAM_3[0]/A_LWL<8> RM_IHPSG13_1P_COLUMN_256_0[5]/RM_IHPSG13_1P_BITKIT_16x2_SRAM_0[1]/A_RWL<11>
+ RM_IHPSG13_1P_COLUMN_256_0[5]/RM_IHPSG13_1P_BITKIT_16x2_SRAM_3[3]/A_RWL<3> RM_IHPSG13_1P_COLUMN_256_0[5]/RM_IHPSG13_1P_BITKIT_16x2_SRAM_0[2]/A_LWL<4>
+ RM_IHPSG13_1P_COLUMN_256_0[5]/RM_IHPSG13_1P_BITKIT_16x2_SRAM_3[2]/A_RWL<7> RM_IHPSG13_1P_COLUMN_256_0[5]/RM_IHPSG13_1P_BITKIT_16x2_SRAM_1[3]/A_RWL<12>
+ RM_IHPSG13_1P_COLUMN_256_0[5]/RM_IHPSG13_1P_BITKIT_16x2_SRAM_1[0]/A_RWL<7> RM_IHPSG13_1P_COLUMN_256_0[5]/RM_IHPSG13_1P_BITKIT_16x2_SRAM_1[3]/A_RWL<0>
+ RM_IHPSG13_1P_COLUMN_256_0[5]/RM_IHPSG13_1P_BITKIT_16x2_SRAM_2[2]/A_RWL<8> RM_IHPSG13_1P_COLUMN_256_0[5]/RM_IHPSG13_1P_BITKIT_16x2_SRAM_2[3]/A_RWL<6>
+ RM_IHPSG13_1P_COLUMN_256_0[5]/RM_IHPSG13_1P_BITKIT_16x2_SRAM_2[2]/A_RWL<1> RM_IHPSG13_1P_COLUMN_256_0[5]/RM_IHPSG13_1P_BITKIT_16x2_SRAM_0[3]/A_RWL<1>
+ RM_IHPSG13_1P_COLUMN_256_0[5]/RM_IHPSG13_1P_BITKIT_16x2_SRAM_3[2]/A_LWL<2> RM_IHPSG13_1P_COLUMN_256_0[5]/RM_IHPSG13_1P_BITKIT_16x2_SRAM_1[2]/A_RWL<9>
+ RM_IHPSG13_1P_COLUMN_256_0[5]/RM_IHPSG13_1P_BITKIT_16x2_SRAM_1[0]/A_LWL<2> RM_IHPSG13_1P_COLUMN_256_0[5]/RM_IHPSG13_1P_BITKIT_16x2_SRAM_2[2]/A_LWL<3>
+ RM_IHPSG13_1P_COLUMN_256_0[5]/RM_IHPSG13_1P_BITKIT_16x2_SRAM_0[0]/A_RWL<15> RM_IHPSG13_1P_COLUMN_256_0[5]/RM_IHPSG13_1P_BITKIT_16x2_SRAM_0[1]/A_LWL<11>
+ RM_IHPSG13_1P_COLUMN_256_0[5]/RM_IHPSG13_1P_BITKIT_16x2_SRAM_3[2]/A_RWL<4> RM_IHPSG13_1P_COLUMN_256_0[5]/RM_IHPSG13_1P_BITKIT_16x2_SRAM_0[3]/A_LWL<13>
+ RM_IHPSG13_1P_COLUMN_256_0[5]/RM_IHPSG13_1P_BITKIT_16x2_SRAM_1[2]/A_LWL<4> RM_IHPSG13_1P_COLUMN_256_0[5]/RM_IHPSG13_1P_BITKIT_16x2_SRAM_2[0]/A_LWL<11>
+ RM_IHPSG13_1P_COLUMN_256_0[5]/RM_IHPSG13_1P_BITKIT_16x2_SRAM_0[1]/A_RWL<12> RM_IHPSG13_1P_COLUMN_256_0[5]/RM_IHPSG13_1P_BITKIT_16x2_SRAM_3[3]/A_LWL<10>
+ RM_IHPSG13_1P_COLUMN_256_0[5]/RM_IHPSG13_1P_BITKIT_16x2_SRAM_2[0]/A_LWL<1> RM_IHPSG13_1P_COLUMN_256_0[5]/RM_IHPSG13_1P_BITKIT_16x2_SRAM_0[1]/A_LWL<8>
+ RM_IHPSG13_1P_COLUMN_256_0[5]/RM_IHPSG13_1P_BITKIT_16x2_SRAM_0[1]/A_LWL<14> RM_IHPSG13_1P_COLUMN_256_0[5]/RM_IHPSG13_1P_BITKIT_16x2_SRAM_0[2]/A_LWL<5>
+ RM_IHPSG13_1P_COLUMN_256_0[5]/RM_IHPSG13_1P_BITKIT_16x2_SRAM_2[3]/A_RWL<0> RM_IHPSG13_1P_COLUMN_256_0[5]/RM_IHPSG13_1P_BITKIT_16x2_SRAM_2[3]/A_LWL<13>
+ RM_IHPSG13_1P_COLUMN_256_0[5]/RM_IHPSG13_1P_BITKIT_16x2_SRAM_3[2]/A_RWL<8> RM_IHPSG13_1P_COLUMN_256_0[5]/RM_IHPSG13_1P_BITKIT_16x2_SRAM_1[3]/A_RWL<13>
+ RM_IHPSG13_1P_COLUMN_256_0[5]/RM_IHPSG13_1P_BITKIT_16x2_SRAM_2[0]/A_LWL<14> RM_IHPSG13_1P_COLUMN_256_0[5]/RM_IHPSG13_1P_BITKIT_16x2_SRAM_1[3]/A_RWL<1>
+ RM_IHPSG13_1P_COLUMN_256_0[5]/RM_IHPSG13_1P_BITKIT_16x2_SRAM_2[2]/A_RWL<9> RM_IHPSG13_1P_COLUMN_256_0[5]/RM_IHPSG13_1P_BITKIT_16x2_SRAM_1[1]/A_LWL<7>
+ RM_IHPSG13_1P_COLUMN_256_0[5]/RM_IHPSG13_1P_BITKIT_16x2_SRAM_2[2]/A_RWL<14> RM_IHPSG13_1P_COLUMN_256_0[5]/RM_IHPSG13_1P_BITKIT_16x2_SRAM_0[3]/A_RWL<2>
+ RM_IHPSG13_1P_COLUMN_256_0[5]/RM_IHPSG13_1P_BITKIT_16x2_SRAM_3[2]/A_LWL<3> RM_IHPSG13_1P_COLUMN_256_0[5]/RM_IHPSG13_1P_BITKIT_16x2_SRAM_3[0]/A_LWL<7>
+ RM_IHPSG13_1P_COLUMN_256_0[5]/RM_IHPSG13_1P_BITKIT_16x2_SRAM_2[2]/A_LWL<4> RM_IHPSG13_1P_COLUMN_256_0[5]/RM_IHPSG13_1P_BITKIT_16x2_SRAM_1[1]/A_RWL<13>
+ RM_IHPSG13_1P_COLUMN_256_0[5]/RM_IHPSG13_1P_BITKIT_16x2_SRAM_0[3]/A_LWL<14> RM_IHPSG13_1P_COLUMN_256_0[5]/RM_IHPSG13_1P_BITKIT_16x2_SRAM_3[0]/A_RWL<13>
+ RM_IHPSG13_1P_COLUMN_256_0[5]/RM_IHPSG13_1P_BITKIT_16x2_SRAM_1[2]/A_LWL<5> RM_IHPSG13_1P_COLUMN_256_0[5]/RM_IHPSG13_1P_BITKIT_16x2_SRAM_3[3]/A_RWL<0>
+ RM_IHPSG13_1P_COLUMN_256_0[5]/RM_IHPSG13_1P_BITKIT_16x2_SRAM_0[2]/A_RWL<8> RM_IHPSG13_1P_COLUMN_256_0[5]/RM_IHPSG13_1P_BITKIT_16x2_SRAM_0[1]/A_RWL<13>
+ RM_IHPSG13_1P_COLUMN_256_0[5]/RM_IHPSG13_1P_BITKIT_16x2_SRAM_3[0]/A_LWL<10> RM_IHPSG13_1P_COLUMN_256_0[5]/RM_IHPSG13_1P_BITKIT_16x2_SRAM_2[1]/A_RWL<8>
+ RM_IHPSG13_1P_COLUMN_256_0[5]/RM_IHPSG13_1P_BITKIT_16x2_SRAM_0[2]/A_LWL<6> RM_IHPSG13_1P_COLUMN_256_0[5]/RM_IHPSG13_1P_BITKIT_16x2_SRAM_2[3]/A_RWL<1>
+ RM_IHPSG13_1P_COLUMN_256_0[5]/RM_IHPSG13_1P_BITKIT_16x2_SRAM_3[2]/A_RWL<9> RM_IHPSG13_1P_COLUMN_256_0[5]/RM_IHPSG13_1P_BITKIT_16x2_SRAM_0[3]/A_RWL<6>
+ RM_IHPSG13_1P_COLUMN_256_0[5]/RM_IHPSG13_1P_BITKIT_16x2_SRAM_1[3]/A_RWL<14> RM_IHPSG13_1P_COLUMN_256_0[5]/RM_IHPSG13_1P_BITKIT_16x2_SRAM_0[2]/A_RWL<1>
+ RM_IHPSG13_1P_COLUMN_256_0[5]/RM_IHPSG13_1P_BITKIT_16x2_SRAM_1[1]/A_LWL<0> RM_IHPSG13_1P_COLUMN_256_0[5]/RM_IHPSG13_1P_BITKIT_16x2_SRAM_0[2]/A_RWL<10>
+ RM_IHPSG13_1P_COLUMN_256_0[5]/RM_IHPSG13_1P_BITKIT_16x2_SRAM_1[3]/A_RWL<2> RM_IHPSG13_1P_COLUMN_256_0[5]/RM_IHPSG13_1P_BITKIT_16x2_SRAM_2[2]/A_RWL<6>
+ RM_IHPSG13_1P_COLUMN_256_0[5]/RM_IHPSG13_1P_BITKIT_16x2_SRAM_2[1]/A_RWL<1> RM_IHPSG13_1P_COLUMN_256_0[5]/RM_IHPSG13_1P_BITKIT_16x2_SRAM_0[3]/A_RWL<3>
+ RM_IHPSG13_1P_COLUMN_256_0[5]/RM_IHPSG13_1P_BITKIT_16x2_SRAM_3[2]/A_LWL<4> RM_IHPSG13_1P_COLUMN_256_0[5]/RM_IHPSG13_1P_BITKIT_16x2_SRAM_1[1]/A_LWL<9>
+ RM_IHPSG13_1P_COLUMN_256_0[5]/RM_IHPSG13_1P_BITKIT_16x2_SRAM_1[2]/A_RWL<4> RM_IHPSG13_1P_COLUMN_256_0[5]/RM_IHPSG13_1P_BITKIT_16x2_SRAM_1[0]/A_RWL<3>
+ RM_IHPSG13_1P_COLUMN_256_0[5]/RM_IHPSG13_1P_BITKIT_16x2_SRAM_2[2]/A_LWL<5> RM_IHPSG13_1P_COLUMN_256_0[5]/RM_IHPSG13_1P_BITKIT_16x2_SRAM_3[1]/A_LWL<8>
+ RM_IHPSG13_1P_COLUMN_256_0[5]/RM_IHPSG13_1P_BITKIT_16x2_SRAM_0[0]/A_LWL<11> RM_IHPSG13_1P_COLUMN_256_0[5]/RM_IHPSG13_1P_BITKIT_16x2_SRAM_3[1]/A_RWL<4>
+ RM_IHPSG13_1P_COLUMN_256_0[5]/RM_IHPSG13_1P_BITKIT_16x2_SRAM_0[3]/A_LWL<15> RM_IHPSG13_1P_COLUMN_256_0[5]/RM_IHPSG13_1P_BITKIT_16x2_SRAM_1[3]/A_LWL<10>
+ RM_IHPSG13_1P_COLUMN_256_0[5]/RM_IHPSG13_1P_BITKIT_16x2_SRAM_1[2]/A_LWL<6> RM_IHPSG13_1P_COLUMN_256_0[5]/RM_IHPSG13_1P_BITKIT_16x2_SRAM_3[3]/A_RWL<1>
+ RM_IHPSG13_1P_COLUMN_256_0[5]/RM_IHPSG13_1P_BITKIT_16x2_SRAM_0[1]/A_RWL<14> RM_IHPSG13_1P_COLUMN_256_0[5]/RM_IHPSG13_1P_BITKIT_16x2_SRAM_3[2]/A_LWL<10>
+ RM_IHPSG13_1P_COLUMN_256_0[5]/RM_IHPSG13_1P_BITKIT_16x2_SRAM_3[0]/A_LWL<11> RM_IHPSG13_1P_COLUMN_256_0[5]/RM_IHPSG13_1P_BITKIT_16x2_SRAM_0[0]/A_LWL<14>
+ RM_IHPSG13_1P_COLUMN_256_0[5]/RM_IHPSG13_1P_BITKIT_16x2_SRAM_0[2]/A_LWL<7> RM_IHPSG13_1P_COLUMN_256_0[5]/RM_IHPSG13_1P_BITKIT_16x2_SRAM_2[3]/A_RWL<2>
+ RM_IHPSG13_1P_COLUMN_256_0[5]/RM_IHPSG13_1P_BITKIT_16x2_SRAM_2[3]/A_RWL<11> RM_IHPSG13_1P_COLUMN_256_0[5]/RM_IHPSG13_1P_BITKIT_16x2_SRAM_1[3]/A_RWL<15>
+ RM_IHPSG13_1P_COLUMN_256_0[5]/RM_IHPSG13_1P_BITKIT_16x2_SRAM_0[2]/A_RWL<11> RM_IHPSG13_1P_COLUMN_256_0[5]/RM_IHPSG13_1P_BITKIT_16x2_SRAM_1[3]/A_RWL<3>
+ RM_IHPSG13_1P_COLUMN_256_0[5]/RM_IHPSG13_1P_BITKIT_16x2_SRAM_1[0]/A_LWL<7> RM_IHPSG13_1P_COLUMN_256_0[5]/RM_IHPSG13_1P_BITKIT_16x2_SRAM_0[3]/A_RWL<4>
+ RM_IHPSG13_1P_COLUMN_256_0[5]/RM_IHPSG13_1P_BITKIT_16x2_SRAM_2[3]/A_LWL<6> RM_IHPSG13_1P_COLUMN_256_0[5]/RM_IHPSG13_1P_BITKIT_16x2_SRAM_3[2]/A_LWL<5>
+ RM_IHPSG13_1P_COLUMN_256_0[5]/RM_IHPSG13_1P_BITKIT_16x2_SRAM_0[0]/A_LWL<13> RM_IHPSG13_1P_COLUMN_256_0[5]/RM_IHPSG13_1P_BITKIT_16x2_SRAM_2[2]/A_LWL<6>
+ RM_IHPSG13_1P_COLUMN_256_0[5]/RM_IHPSG13_1P_BITKIT_16x2_SRAM_1[0]/A_RWL<13> RM_IHPSG13_1P_COLUMN_256_0[5]/RM_IHPSG13_1P_BITKIT_16x2_SRAM_2[1]/A_LWL<1>
+ RM_IHPSG13_1P_COLUMN_256_0[5]/RM_IHPSG13_1P_BITKIT_16x2_SRAM_0[3]/A_LWL<5> RM_IHPSG13_1P_COLUMN_256_0[5]/RM_IHPSG13_1P_BITKIT_16x2_SRAM_2[0]/A_LWL<12>
+ RM_IHPSG13_1P_COLUMN_256_0[5]/RM_IHPSG13_1P_BITKIT_16x2_SRAM_3[3]/A_LWL<3> RM_IHPSG13_1P_COLUMN_256_0[5]/RM_IHPSG13_1P_BITKIT_16x2_SRAM_1[2]/A_LWL<7>
+ RM_IHPSG13_1P_COLUMN_256_0[5]/RM_IHPSG13_1P_BITKIT_16x2_SRAM_3[3]/A_RWL<2> RM_IHPSG13_1P_COLUMN_256_0[5]/RM_IHPSG13_1P_BITKIT_16x2_SRAM_0[1]/A_RWL<8>
+ RM_IHPSG13_1P_COLUMN_256_0[5]/RM_IHPSG13_1P_BITKIT_16x2_SRAM_2[3]/A_LWL<4> RM_IHPSG13_1P_COLUMN_256_0[5]/RM_IHPSG13_1P_BITKIT_16x2_SRAM_0[1]/A_RWL<15>
+ RM_IHPSG13_1P_COLUMN_256_0[5]/RM_IHPSG13_1P_BITKIT_16x2_SRAM_3[0]/A_LWL<12> RM_IHPSG13_1P_COLUMN_256_0[5]/RM_IHPSG13_1P_BITKIT_16x2_SRAM_2[0]/A_RWL<8>
+ RM_IHPSG13_1P_COLUMN_256_0[5]/RM_IHPSG13_1P_BITKIT_16x2_SRAM_0[2]/A_LWL<8> RM_IHPSG13_1P_COLUMN_256_0[5]/RM_IHPSG13_1P_BITKIT_16x2_SRAM_2[3]/A_RWL<3>
+ RM_IHPSG13_1P_COLUMN_256_0[5]/RM_IHPSG13_1P_BITKIT_16x2_SRAM_2[0]/A_RWL<2> RM_IHPSG13_1P_COLUMN_256_0[5]/RM_IHPSG13_1P_BITKIT_16x2_SRAM_3[3]/A_RWL<9>
+ RM_IHPSG13_1P_COLUMN_256_0[5]/RM_IHPSG13_1P_BITKIT_16x2_SRAM_0[2]/A_RWL<6> RM_IHPSG13_1P_COLUMN_256_0[5]/RM_IHPSG13_1P_BITKIT_16x2_SRAM_0[1]/A_RWL<1>
+ RM_IHPSG13_1P_COLUMN_256_0[5]/RM_IHPSG13_1P_BITKIT_16x2_SRAM_2[3]/A_RWL<14> RM_IHPSG13_1P_COLUMN_256_0[5]/RM_IHPSG13_1P_BITKIT_16x2_SRAM_0[2]/A_RWL<12>
+ RM_IHPSG13_1P_COLUMN_256_0[5]/RM_IHPSG13_1P_BITKIT_16x2_SRAM_1[3]/A_RWL<4> RM_IHPSG13_1P_COLUMN_256_0[5]/RM_IHPSG13_1P_BITKIT_16x2_SRAM_2[1]/A_RWL<6>
+ RM_IHPSG13_1P_COLUMN_256_0[5]/RM_IHPSG13_1P_BITKIT_16x2_SRAM_2[0]/A_RWL<1> RM_IHPSG13_1P_COLUMN_256_0[7]/RM_IHPSG13_1P_BITKIT_16x2_SRAM_3[3]/VSS
+ RM_IHPSG13_1P_COLUMN_256_0[7]/RM_IHPSG13_1P_BITKIT_16x2_SRAM_3[3]/VDD RM_IHPSG13_1P_COLUMN_256_0[5]/RM_IHPSG13_1P_BITKIT_16x2_SRAM_0[3]/A_RWL<5>
+ RM_IHPSG13_1P_COLUMN_256_0[5]/RM_IHPSG13_1P_BITKIT_16x2_SRAM_3[2]/A_LWL<6> RM_IHPSG13_1P_COLUMN_256
XRM_IHPSG13_1P_COLUMN_256_0[6] RM_IHPSG13_1P_COLUMN_256_0[6]/RM_IHPSG13_1P_BITKIT_16x2_SRAM_0[0]/A_BLT_BOT<0>
+ RM_IHPSG13_1P_COLUMN_256_0[6]/RM_IHPSG13_1P_BITKIT_16x2_SRAM_3[1]/A_LWL<10> RM_IHPSG13_1P_COLUMN_256_0[6]/RM_IHPSG13_1P_BITKIT_16x2_SRAM_3[0]/A_LWL<13>
+ RM_IHPSG13_1P_COLUMN_256_0[6]/RM_IHPSG13_1P_BITKIT_16x2_SRAM_0[0]/A_BLT_BOT<1> RM_IHPSG13_1P_COLUMN_256_0[6]/RM_IHPSG13_1P_BITKIT_16x2_SRAM_1[2]/A_LWL<9>
+ RM_IHPSG13_1P_COLUMN_256_0[6]/RM_IHPSG13_1P_BITKIT_16x2_SRAM_0[0]/A_BLC_BOT<0> RM_IHPSG13_1P_COLUMN_256_0[6]/RM_IHPSG13_1P_BITKIT_16x2_SRAM_3[2]/A_LWL<8>
+ RM_IHPSG13_1P_COLUMN_256_0[6]/RM_IHPSG13_1P_BITKIT_16x2_SRAM_0[3]/A_RWL<11> RM_IHPSG13_1P_COLUMN_256_0[6]/RM_IHPSG13_1P_BITKIT_16x2_SRAM_2[3]/A_RWL<5>
+ RM_IHPSG13_1P_COLUMN_256_0[6]/RM_IHPSG13_1P_BITKIT_16x2_SRAM_0[0]/A_BLC_BOT<1> RM_IHPSG13_1P_COLUMN_256_0[6]/RM_IHPSG13_1P_BITKIT_16x2_SRAM_1[3]/A_LWL<0>
+ RM_IHPSG13_1P_COLUMN_256_0[6]/RM_IHPSG13_1P_BITKIT_16x2_SRAM_3[1]/A_LWL<13> RM_IHPSG13_1P_COLUMN_256_0[6]/RM_IHPSG13_1P_BITKIT_16x2_SRAM_1[3]/A_LWL<3>
+ RM_IHPSG13_1P_COLUMN_256_0[6]/RM_IHPSG13_1P_BITKIT_16x2_SRAM_1[3]/A_RWL<9> RM_IHPSG13_1P_COLUMN_256_0[6]/RM_IHPSG13_1P_BITKIT_16x2_SRAM_2[3]/A_LWL<1>
+ RM_IHPSG13_1P_COLUMN_256_0[6]/RM_IHPSG13_1P_BITKIT_16x2_SRAM_0[0]/A_RWL<1> RM_IHPSG13_1P_COLUMN_256_0[6]/RM_IHPSG13_1P_BITKIT_16x2_SRAM_0[3]/A_LWL<6>
+ RM_IHPSG13_1P_COLUMN_256_0[6]/RM_IHPSG13_1P_BITKIT_16x2_SRAM_2[3]/A_RWL<7> RM_IHPSG13_1P_COLUMN_256_0[6]/RM_IHPSG13_1P_BITKIT_16x2_SRAM_3[2]/A_LWL<13>
+ RM_IHPSG13_1P_COLUMN_256_0[6]/RM_IHPSG13_1P_BITKIT_16x2_SRAM_2[3]/A_LWL<2> RM_IHPSG13_1P_COLUMN_256_0[6]/RM_IHPSG13_1P_BITKIT_16x2_SRAM_3[3]/A_LWL<5>
+ RM_IHPSG13_1P_COLUMN_256_0[6]/RM_IHPSG13_1P_BITKIT_16x2_SRAM_0[2]/A_RWL<14> RM_IHPSG13_1P_COLUMN_256_0[6]/RM_IHPSG13_1P_BITKIT_16x2_SRAM_0[3]/A_LWL<8>
+ RM_IHPSG13_1P_COLUMN_256_0[6]/RM_IHPSG13_1P_BITKIT_16x2_SRAM_3[3]/A_LWL<11> RM_IHPSG13_1P_COLUMN_256_0[6]/RM_IHPSG13_1P_BITKIT_16x2_SRAM_3[0]/A_RWL<12>
+ RM_IHPSG13_1P_COLUMN_256_0[6]/RM_IHPSG13_1P_BITKIT_16x2_SRAM_3[1]/A_RWL<10> RM_IHPSG13_1P_COLUMN_256_0[6]/RM_IHPSG13_1P_BITKIT_16x2_SRAM_0[3]/A_RWL<7>
+ RM_IHPSG13_1P_COLUMN_256_0[6]/RM_IHPSG13_1P_BITKIT_16x2_SRAM_0[3]/A_LWL<2> RM_IHPSG13_1P_COLUMN_256_0[6]/RM_IHPSG13_1P_BITKIT_16x2_SRAM_3[0]/A_RWL<14>
+ RM_IHPSG13_1P_COLUMN_256_0[6]/RM_IHPSG13_1P_BITKIT_16x2_SRAM_1[0]/A_RWL<4> RM_IHPSG13_1P_COLUMN_256_0[6]/RM_IHPSG13_1P_BITKIT_16x2_SRAM_3[2]/A_LWL<11>
+ RM_IHPSG13_1P_COLUMN_256_0[6]/RM_IHPSG13_1P_BITKIT_16x2_SRAM_3[2]/A_LWL<14> RM_IHPSG13_1P_COLUMN_256_0[6]/RM_IHPSG13_1P_BITKIT_16x2_SRAM_2[0]/A_LWL<15>
+ RM_IHPSG13_1P_COLUMN_256_0[6]/RM_IHPSG13_1P_BITKIT_16x2_SRAM_0[0]/A_RWL<5> RM_IHPSG13_1P_COLUMN_256_0[6]/RM_IHPSG13_1P_BITKIT_16x2_SRAM_2[3]/A_LWL<7>
+ RM_IHPSG13_1P_COLUMN_256_0[6]/RM_IHPSG13_1P_BITKIT_16x2_SRAM_1[3]/A_LWL<9> RM_IHPSG13_1P_COLUMN_256_0[6]/RM_IHPSG13_1P_BITKIT_16x2_SRAM_2[1]/A_LWL<12>
+ RM_IHPSG13_1P_COLUMN_256_0[6]/RM_IHPSG13_1P_BITKIT_16x2_SRAM_0[3]/A_LWL<4> RM_IHPSG13_1P_COLUMN_256_0[6]/RM_IHPSG13_1P_BITKIT_16x2_SRAM_3[3]/A_LWL<13>
+ RM_IHPSG13_1P_COLUMN_256_0[6]/RM_IHPSG13_1P_BITKIT_16x2_SRAM_3[1]/A_RWL<12> RM_IHPSG13_1P_COLUMN_256_0[6]/RM_IHPSG13_1P_BITKIT_16x2_SRAM_0[0]/A_RWL<2>
+ RM_IHPSG13_1P_COLUMN_256_0[6]/RM_IHPSG13_1P_BITKIT_16x2_SRAM_0[3]/A_RWL<14> RM_IHPSG13_1P_COLUMN_256_0[6]/RM_IHPSG13_1P_BITKIT_16x2_SRAM_3[0]/A_RWL<10>
+ RM_IHPSG13_1P_COLUMN_256_0[6]/RM_IHPSG13_1P_BITKIT_16x2_SRAM_2[0]/A_RWL<3> RM_IHPSG13_1P_COLUMN_256_0[6]/RM_IHPSG13_1P_BITKIT_16x2_SRAM_3[3]/A_RWL<8>
+ RM_IHPSG13_1P_COLUMN_256_0[6]/RM_IHPSG13_1P_BITKIT_16x2_SRAM_0[0]/A_RWL<6> RM_IHPSG13_1P_COLUMN_256_0[6]/RM_IHPSG13_1P_BITKIT_16x2_SRAM_3[3]/A_LWL<8>
+ RM_IHPSG13_1P_COLUMN_256_0[6]/RM_IHPSG13_1P_BITKIT_16x2_SRAM_2[0]/A_RWL<0> RM_IHPSG13_1P_COLUMN_256_0[6]/RM_IHPSG13_1P_BITKIT_16x2_SRAM_0[0]/A_LWL<1>
+ RM_IHPSG13_1P_COLUMN_256_0[6]/RM_IHPSG13_1P_BITKIT_16x2_SRAM_3[0]/A_RWL<4> RM_IHPSG13_1P_COLUMN_256_0[6]/RM_IHPSG13_1P_BITKIT_16x2_SRAM_2[0]/A_RWL<5>
+ RM_IHPSG13_1P_COLUMN_256_0[6]/RM_IHPSG13_1P_BITKIT_16x2_SRAM_3[3]/A_LWL<14> RM_IHPSG13_1P_COLUMN_256_0[6]/RM_IHPSG13_1P_BITKIT_16x2_SRAM_3[1]/A_LWL<11>
+ RM_IHPSG13_1P_COLUMN_256_0[6]/RM_IHPSG13_1P_BITKIT_16x2_SRAM_2[0]/A_LWL<0> RM_IHPSG13_1P_COLUMN_256_0[6]/RM_IHPSG13_1P_BITKIT_16x2_SRAM_3[2]/A_RWL<10>
+ RM_IHPSG13_1P_COLUMN_256_0[6]/RM_IHPSG13_1P_BITKIT_16x2_SRAM_1[3]/A_LWL<5> RM_IHPSG13_1P_COLUMN_256_0[6]/RM_IHPSG13_1P_BITKIT_16x2_SRAM_3[1]/A_LWL<14>
+ RM_IHPSG13_1P_COLUMN_256_0[6]/RM_IHPSG13_1P_BITKIT_16x2_SRAM_0[3]/A_LWL<7> RM_IHPSG13_1P_COLUMN_256_0[6]/RM_IHPSG13_1P_BITKIT_16x2_SRAM_1[2]/A_LWL<8>
+ RM_IHPSG13_1P_COLUMN_256_0[6]/RM_IHPSG13_1P_BITKIT_16x2_SRAM_3[3]/A_LWL<4> RM_IHPSG13_1P_COLUMN_256_0[6]/RM_IHPSG13_1P_BITKIT_16x2_SRAM_2[2]/A_LWL<7>
+ RM_IHPSG13_1P_COLUMN_256_0[6]/RM_IHPSG13_1P_BITKIT_16x2_SRAM_0[3]/A_RWL<13> RM_IHPSG13_1P_COLUMN_256_0[6]/RM_IHPSG13_1P_BITKIT_16x2_SRAM_1[0]/A_LWL<10>
+ RM_IHPSG13_1P_COLUMN_256_0[6]/RM_IHPSG13_1P_BITKIT_16x2_SRAM_3[0]/A_RWL<2> RM_IHPSG13_1P_COLUMN_256_0[6]/RM_IHPSG13_1P_BITKIT_16x2_SRAM_2[0]/A_RWL<6>
+ RM_IHPSG13_1P_COLUMN_256_0[6]/RM_IHPSG13_1P_BITKIT_16x2_SRAM_3[1]/A_RWL<14> RM_IHPSG13_1P_COLUMN_256_0[6]/RM_IHPSG13_1P_BITKIT_16x2_SRAM_1[3]/A_RWL<8>
+ RM_IHPSG13_1P_COLUMN_256_0[6]/RM_IHPSG13_1P_BITKIT_16x2_SRAM_0[0]/A_RWL<8> RM_IHPSG13_1P_COLUMN_256_0[6]/RM_IHPSG13_1P_BITKIT_16x2_SRAM_0[0]/A_RWL<0>
+ RM_IHPSG13_1P_COLUMN_256_0[6]/RM_IHPSG13_1P_BITKIT_16x2_SRAM_3[3]/A_RWL<6> RM_IHPSG13_1P_COLUMN_256_0[6]/RM_IHPSG13_1P_BITKIT_16x2_SRAM_2[1]/A_LWL<15>
+ RM_IHPSG13_1P_COLUMN_256_0[6]/RM_IHPSG13_1P_BITKIT_16x2_SRAM_2[3]/A_RWL<4> RM_IHPSG13_1P_COLUMN_256_0[6]/RM_IHPSG13_1P_BITKIT_16x2_SRAM_2[0]/A_RWL<7>
+ RM_IHPSG13_1P_COLUMN_256_0[6]/RM_IHPSG13_1P_BITKIT_16x2_SRAM_2[2]/A_LWL<9> RM_IHPSG13_1P_COLUMN_256_0[6]/RM_IHPSG13_1P_BITKIT_16x2_SRAM_2[2]/A_LWL<12>
+ RM_IHPSG13_1P_COLUMN_256_0[6]/RM_IHPSG13_1P_BITKIT_16x2_SRAM_0[1]/A_RWL<0> RM_IHPSG13_1P_COLUMN_256_0[6]/RM_IHPSG13_1P_BITKIT_16x2_SRAM_3[0]/A_LWL<1>
+ RM_IHPSG13_1P_COLUMN_256_0[6]/RM_IHPSG13_1P_BITKIT_16x2_SRAM_2[0]/A_RWL<11> RM_IHPSG13_1P_COLUMN_256_0[6]/RM_IHPSG13_1P_BITKIT_16x2_SRAM_2[0]/A_LWL<2>
+ RM_IHPSG13_1P_COLUMN_256_0[6]/RM_IHPSG13_1P_BITKIT_16x2_SRAM_3[2]/A_RWL<12> RM_IHPSG13_1P_COLUMN_256_0[6]/RM_IHPSG13_1P_BITKIT_16x2_SRAM_3[0]/A_LWL<14>
+ RM_IHPSG13_1P_COLUMN_256_0[6]/RM_IHPSG13_1P_BITKIT_16x2_SRAM_1[0]/A_LWL<3> RM_IHPSG13_1P_COLUMN_256_0[6]/RM_IHPSG13_1P_BITKIT_16x2_SRAM_0[0]/A_LWL<4>
+ RM_IHPSG13_1P_COLUMN_256_0[6]/RM_IHPSG13_1P_BITKIT_16x2_SRAM_0[2]/A_RWL<13> RM_IHPSG13_1P_COLUMN_256_0[6]/RM_IHPSG13_1P_BITKIT_16x2_SRAM_1[0]/A_RWL<9>
+ RM_IHPSG13_1P_COLUMN_256_0[6]/RM_IHPSG13_1P_BITKIT_16x2_SRAM_1[3]/A_LWL<8> RM_IHPSG13_1P_COLUMN_256_0[6]/RM_IHPSG13_1P_BITKIT_16x2_SRAM_3[1]/A_LWL<12>
+ RM_IHPSG13_1P_COLUMN_256_0[6]/RM_IHPSG13_1P_BITKIT_16x2_SRAM_0[0]/A_RWL<7> RM_IHPSG13_1P_COLUMN_256_0[6]/RM_IHPSG13_1P_BITKIT_16x2_SRAM_1[3]/A_RWL<6>
+ RM_IHPSG13_1P_COLUMN_256_0[6]/RM_IHPSG13_1P_BITKIT_16x2_SRAM_1[0]/A_LWL<4> RM_IHPSG13_1P_COLUMN_256_0[6]/RM_IHPSG13_1P_BITKIT_16x2_SRAM_0[0]/A_LWL<2>
+ RM_IHPSG13_1P_COLUMN_256_0[6]/RM_IHPSG13_1P_BITKIT_16x2_SRAM_3[0]/A_RWL<15> RM_IHPSG13_1P_COLUMN_256_0[6]/RM_IHPSG13_1P_BITKIT_16x2_SRAM_3[3]/A_RWL<10>
+ RM_IHPSG13_1P_COLUMN_256_0[6]/RM_IHPSG13_1P_BITKIT_16x2_SRAM_2[1]/A_RWL<0> RM_IHPSG13_1P_COLUMN_256_0[6]/RM_IHPSG13_1P_BITKIT_16x2_SRAM_1[0]/A_LWL<13>
+ RM_IHPSG13_1P_COLUMN_256_0[6]/RM_IHPSG13_1P_BITKIT_16x2_SRAM_1[0]/A_LWL<11> RM_IHPSG13_1P_COLUMN_256_0[6]/RM_IHPSG13_1P_BITKIT_16x2_SRAM_2[3]/A_LWL<10>
+ RM_IHPSG13_1P_COLUMN_256_0[6]/RM_IHPSG13_1P_BITKIT_16x2_SRAM_1[1]/A_LWL<10> RM_IHPSG13_1P_COLUMN_256_0[6]/RM_IHPSG13_1P_BITKIT_16x2_SRAM_0[1]/A_RWL<2>
+ RM_IHPSG13_1P_COLUMN_256_0[6]/RM_IHPSG13_1P_BITKIT_16x2_SRAM_3[0]/A_LWL<3> RM_IHPSG13_1P_COLUMN_256_0[6]/RM_IHPSG13_1P_BITKIT_16x2_SRAM_0[3]/A_LWL<1>
+ RM_IHPSG13_1P_COLUMN_256_0[6]/RM_IHPSG13_1P_BITKIT_16x2_SRAM_3[2]/A_RWL<14> RM_IHPSG13_1P_COLUMN_256_0[6]/RM_IHPSG13_1P_BITKIT_16x2_SRAM_2[3]/A_LWL<0>
+ RM_IHPSG13_1P_COLUMN_256_0[6]/RM_IHPSG13_1P_BITKIT_16x2_SRAM_1[0]/A_LWL<5> RM_IHPSG13_1P_COLUMN_256_0[6]/RM_IHPSG13_1P_BITKIT_16x2_SRAM_3[3]/A_RWL<11>
+ RM_IHPSG13_1P_COLUMN_256_0[6]/RM_IHPSG13_1P_BITKIT_16x2_SRAM_3[3]/A_LWL<6> RM_IHPSG13_1P_COLUMN_256_0[6]/RM_IHPSG13_1P_BITKIT_16x2_SRAM_0[0]/A_LWL<6>
+ RM_IHPSG13_1P_COLUMN_256_0[6]/RM_IHPSG13_1P_BITKIT_16x2_SRAM_3[0]/A_RWL<9> RM_IHPSG13_1P_COLUMN_256_0[6]/RM_IHPSG13_1P_BITKIT_16x2_SRAM_2[3]/A_LWL<9>
+ RM_IHPSG13_1P_COLUMN_256_0[6]/RM_IHPSG13_1P_BITKIT_16x2_SRAM_1[0]/A_LWL<14> RM_IHPSG13_1P_COLUMN_256_0[6]/RM_IHPSG13_1P_BITKIT_16x2_SRAM_2[0]/A_RWL<13>
+ RM_IHPSG13_1P_COLUMN_256_0[6]/RM_IHPSG13_1P_BITKIT_16x2_SRAM_2[2]/A_LWL<15> RM_IHPSG13_1P_COLUMN_256_0[6]/RM_IHPSG13_1P_BITKIT_16x2_SRAM_1[1]/A_LWL<11>
+ RM_IHPSG13_1P_COLUMN_256_0[6]/RM_IHPSG13_1P_BITKIT_16x2_SRAM_3[0]/A_LWL<4> RM_IHPSG13_1P_COLUMN_256_0[6]/RM_IHPSG13_1P_BITKIT_16x2_SRAM_3[0]/A_RWL<8>
+ RM_IHPSG13_1P_COLUMN_256_0[6]/RM_IHPSG13_1P_BITKIT_16x2_SRAM_2[3]/A_LWL<12> RM_IHPSG13_1P_COLUMN_256_0[6]/RM_IHPSG13_1P_BITKIT_16x2_SRAM_2[0]/A_LWL<5>
+ RM_IHPSG13_1P_COLUMN_256_0[6]/RM_IHPSG13_1P_BITKIT_16x2_SRAM_1[1]/A_RWL<1> RM_IHPSG13_1P_COLUMN_256_0[6]/RM_IHPSG13_1P_BITKIT_16x2_SRAM_2[1]/A_RWL<11>
+ RM_IHPSG13_1P_COLUMN_256_0[6]/RM_IHPSG13_1P_BITKIT_16x2_SRAM_3[1]/A_RWL<1> RM_IHPSG13_1P_COLUMN_256_0[6]/RM_IHPSG13_1P_BITKIT_16x2_SRAM_3[0]/A_RWL<1>
+ RM_IHPSG13_1P_COLUMN_256_0[6]/RM_IHPSG13_1P_BITKIT_16x2_SRAM_3[3]/A_RWL<12> RM_IHPSG13_1P_COLUMN_256_0[6]/RM_IHPSG13_1P_BITKIT_16x2_SRAM_2[1]/A_RWL<2>
+ RM_IHPSG13_1P_COLUMN_256_0[6]/RM_IHPSG13_1P_BITKIT_16x2_SRAM_1[1]/A_RWL<3> RM_IHPSG13_1P_COLUMN_256_0[6]/RM_IHPSG13_1P_BITKIT_16x2_SRAM_3[3]/A_LWL<1>
+ RM_IHPSG13_1P_COLUMN_256_0[6]/RM_IHPSG13_1P_BITKIT_16x2_SRAM_2[2]/A_LWL<10> RM_IHPSG13_1P_COLUMN_256_0[6]/RM_IHPSG13_1P_BITKIT_16x2_SRAM_3[2]/A_LWL<12>
+ RM_IHPSG13_1P_COLUMN_256_0[6]/RM_IHPSG13_1P_BITKIT_16x2_SRAM_2[0]/A_RWL<15> RM_IHPSG13_1P_COLUMN_256_0[6]/RM_IHPSG13_1P_BITKIT_16x2_SRAM_2[0]/A_LWL<6>
+ RM_IHPSG13_1P_COLUMN_256_0[6]/RM_IHPSG13_1P_BITKIT_16x2_SRAM_3[2]/A_RWL<11> RM_IHPSG13_1P_COLUMN_256_0[6]/RM_IHPSG13_1P_BITKIT_16x2_SRAM_3[1]/A_RWL<15>
+ RM_IHPSG13_1P_COLUMN_256_0[6]/RM_IHPSG13_1P_BITKIT_16x2_SRAM_0[0]/A_LWL<7> RM_IHPSG13_1P_COLUMN_256_0[6]/RM_IHPSG13_1P_BITKIT_16x2_SRAM_1[3]/A_LWL<6>
+ RM_IHPSG13_1P_COLUMN_256_0[6]/RM_IHPSG13_1P_BITKIT_16x2_SRAM_3[1]/A_RWL<2> RM_IHPSG13_1P_COLUMN_256_0[6]/RM_IHPSG13_1P_BITKIT_16x2_SRAM_2[1]/A_RWL<3>
+ RM_IHPSG13_1P_COLUMN_256_0[6]/RM_IHPSG13_1P_BITKIT_16x2_SRAM_2[3]/A_LWL<3> RM_IHPSG13_1P_COLUMN_256_0[6]/RM_IHPSG13_1P_BITKIT_16x2_SRAM_1[1]/A_RWL<4>
+ RM_IHPSG13_1P_COLUMN_256_0[6]/RM_IHPSG13_1P_BITKIT_16x2_SRAM_0[0]/A_LWL<0> RM_IHPSG13_1P_COLUMN_256_0[6]/RM_IHPSG13_1P_BITKIT_16x2_SRAM_1[1]/A_LWL<13>
+ RM_IHPSG13_1P_COLUMN_256_0[6]/RM_IHPSG13_1P_BITKIT_16x2_SRAM_1[0]/A_RWL<8> RM_IHPSG13_1P_COLUMN_256_0[6]/RM_IHPSG13_1P_BITKIT_16x2_SRAM_0[1]/A_RWL<5>
+ RM_IHPSG13_1P_COLUMN_256_0[6]/RM_IHPSG13_1P_BITKIT_16x2_SRAM_2[3]/A_RWL<9> RM_IHPSG13_1P_COLUMN_256_0[6]/RM_IHPSG13_1P_BITKIT_16x2_SRAM_2[0]/A_LWL<7>
+ RM_IHPSG13_1P_COLUMN_256_0[6]/RM_IHPSG13_1P_BITKIT_16x2_SRAM_1[2]/A_LWL<10> RM_IHPSG13_1P_COLUMN_256_0[6]/RM_IHPSG13_1P_BITKIT_16x2_SRAM_1[0]/A_RWL<1>
+ RM_IHPSG13_1P_COLUMN_256_0[6]/RM_IHPSG13_1P_BITKIT_16x2_SRAM_2[1]/A_RWL<13> RM_IHPSG13_1P_COLUMN_256_0[6]/RM_IHPSG13_1P_BITKIT_16x2_SRAM_3[0]/A_RWL<6>
+ RM_IHPSG13_1P_COLUMN_256_0[6]/RM_IHPSG13_1P_BITKIT_16x2_SRAM_1[0]/A_LWL<8> RM_IHPSG13_1P_COLUMN_256_0[6]/RM_IHPSG13_1P_BITKIT_16x2_SRAM_0[2]/A_RWL<15>
+ RM_IHPSG13_1P_COLUMN_256_0[6]/RM_IHPSG13_1P_BITKIT_16x2_SRAM_3[3]/A_LWL<15> RM_IHPSG13_1P_COLUMN_256_0[6]/RM_IHPSG13_1P_BITKIT_16x2_SRAM_0[1]/A_RWL<4>
+ RM_IHPSG13_1P_COLUMN_256_0[6]/RM_IHPSG13_1P_BITKIT_16x2_SRAM_3[3]/A_RWL<14> RM_IHPSG13_1P_COLUMN_256_0[6]/RM_IHPSG13_1P_BITKIT_16x2_SRAM_0[0]/A_LWL<9>
+ RM_IHPSG13_1P_COLUMN_256_0[6]/RM_IHPSG13_1P_BITKIT_16x2_SRAM_2[1]/A_RWL<4> RM_IHPSG13_1P_COLUMN_256_0[6]/RM_IHPSG13_1P_BITKIT_16x2_SRAM_2[0]/A_RWL<4>
+ RM_IHPSG13_1P_COLUMN_256_0[6]/RM_IHPSG13_1P_BITKIT_16x2_SRAM_3[3]/A_RWL<5> RM_IHPSG13_1P_COLUMN_256_0[6]/RM_IHPSG13_1P_BITKIT_16x2_SRAM_2[1]/A_LWL<10>
+ RM_IHPSG13_1P_COLUMN_256_0[6]/RM_IHPSG13_1P_BITKIT_16x2_SRAM_1[1]/A_LWL<14> RM_IHPSG13_1P_COLUMN_256_0[6]/RM_IHPSG13_1P_BITKIT_16x2_SRAM_0[1]/A_RWL<6>
+ RM_IHPSG13_1P_COLUMN_256_0[6]/RM_IHPSG13_1P_BITKIT_16x2_SRAM_2[3]/A_LWL<15> RM_IHPSG13_1P_COLUMN_256_0[6]/RM_IHPSG13_1P_BITKIT_16x2_SRAM_2[0]/A_LWL<8>
+ RM_IHPSG13_1P_COLUMN_256_0[6]/RM_IHPSG13_1P_BITKIT_16x2_SRAM_3[1]/A_RWL<11> RM_IHPSG13_1P_COLUMN_256_0[6]/RM_IHPSG13_1P_BITKIT_16x2_SRAM_1[2]/A_LWL<11>
+ RM_IHPSG13_1P_COLUMN_256_0[6]/RM_IHPSG13_1P_BITKIT_16x2_SRAM_0[1]/A_LWL<1> RM_IHPSG13_1P_COLUMN_256_0[6]/RM_IHPSG13_1P_BITKIT_16x2_SRAM_1[0]/A_RWL<10>
+ RM_IHPSG13_1P_COLUMN_256_0[6]/RM_IHPSG13_1P_BITKIT_16x2_SRAM_1[0]/A_LWL<1> RM_IHPSG13_1P_COLUMN_256_0[6]/RM_IHPSG13_1P_BITKIT_16x2_SRAM_0[3]/A_LWL<3>
+ RM_IHPSG13_1P_COLUMN_256_0[6]/RM_IHPSG13_1P_BITKIT_16x2_SRAM_2[1]/A_RWL<5> RM_IHPSG13_1P_COLUMN_256_0[6]/RM_IHPSG13_1P_BITKIT_16x2_SRAM_3[0]/A_LWL<0>
+ RM_IHPSG13_1P_COLUMN_256_0[6]/RM_IHPSG13_1P_BITKIT_16x2_SRAM_2[2]/A_RWL<11> RM_IHPSG13_1P_COLUMN_256_0[6]/RM_IHPSG13_1P_BITKIT_16x2_SRAM_3[3]/A_LWL<12>
+ RM_IHPSG13_1P_COLUMN_256_0[6]/RM_IHPSG13_1P_BITKIT_16x2_SRAM_1[1]/A_RWL<6> RM_IHPSG13_1P_COLUMN_256_0[6]/RM_IHPSG13_1P_BITKIT_16x2_SRAM_0[3]/A_RWL<9>
+ RM_IHPSG13_1P_COLUMN_256_0[6]/RM_IHPSG13_1P_BITKIT_16x2_SRAM_2[1]/A_LWL<0> RM_IHPSG13_1P_COLUMN_256_0[6]/RM_IHPSG13_1P_BITKIT_16x2_SRAM_0[1]/A_RWL<7>
+ RM_IHPSG13_1P_COLUMN_256_0[6]/RM_IHPSG13_1P_BITKIT_16x2_SRAM_3[2]/A_RWL<15> RM_IHPSG13_1P_COLUMN_256_0[6]/RM_IHPSG13_1P_BITKIT_16x2_SRAM_2[0]/A_LWL<9>
+ RM_IHPSG13_1P_COLUMN_256_0[6]/RM_IHPSG13_1P_BITKIT_16x2_SRAM_1[0]/A_RWL<6> RM_IHPSG13_1P_COLUMN_256_0[6]/RM_IHPSG13_1P_BITKIT_16x2_SRAM_2[1]/A_RWL<15>
+ RM_IHPSG13_1P_COLUMN_256_0[6]/RM_IHPSG13_1P_BITKIT_16x2_SRAM_0[1]/A_LWL<2> RM_IHPSG13_1P_COLUMN_256_0[6]/RM_IHPSG13_1P_BITKIT_16x2_SRAM_3[2]/A_LWL<15>
+ RM_IHPSG13_1P_COLUMN_256_0[6]/RM_IHPSG13_1P_BITKIT_16x2_SRAM_0[0]/A_RWL<4> RM_IHPSG13_1P_COLUMN_256_0[6]/RM_IHPSG13_1P_BITKIT_16x2_SRAM_1[3]/A_RWL<5>
+ RM_IHPSG13_1P_COLUMN_256_0[6]/RM_IHPSG13_1P_BITKIT_16x2_SRAM_0[1]/A_LWL<0> RM_IHPSG13_1P_COLUMN_256_0[6]/RM_IHPSG13_1P_BITKIT_16x2_SRAM_2[0]/A_LWL<10>
+ RM_IHPSG13_1P_COLUMN_256_0[6]/RM_IHPSG13_1P_BITKIT_16x2_SRAM_3[0]/A_LWL<9> RM_IHPSG13_1P_COLUMN_256_0[6]/RM_IHPSG13_1P_BITKIT_16x2_SRAM_0[0]/A_LWL<12>
+ RM_IHPSG13_1P_COLUMN_256_0[6]/RM_IHPSG13_1P_BITKIT_16x2_SRAM_0[0]/A_RWL<3> RM_IHPSG13_1P_COLUMN_256_0[6]/RM_IHPSG13_1P_BITKIT_16x2_SRAM_0[3]/A_RWL<15>
+ RM_IHPSG13_1P_COLUMN_256_0[6]/RM_IHPSG13_1P_BITKIT_16x2_SRAM_3[0]/A_RWL<11> RM_IHPSG13_1P_COLUMN_256_0[6]/RM_IHPSG13_1P_BITKIT_16x2_SRAM_1[2]/A_LWL<13>
+ RM_IHPSG13_1P_COLUMN_256_0[6]/RM_IHPSG13_1P_BITKIT_16x2_SRAM_1[0]/A_RWL<12> RM_IHPSG13_1P_COLUMN_256_0[6]/RM_IHPSG13_1P_BITKIT_16x2_SRAM_3[1]/A_RWL<6>
+ RM_IHPSG13_1P_COLUMN_256_0[6]/RM_IHPSG13_1P_BITKIT_16x2_SRAM_3[0]/A_LWL<6> RM_IHPSG13_1P_COLUMN_256_0[6]/RM_IHPSG13_1P_BITKIT_16x2_SRAM_2[1]/A_RWL<7>
+ RM_IHPSG13_1P_COLUMN_256_0[6]/RM_IHPSG13_1P_BITKIT_16x2_SRAM_2[2]/A_RWL<13> RM_IHPSG13_1P_COLUMN_256_0[6]/RM_IHPSG13_1P_BITKIT_16x2_SRAM_0[2]/A_RWL<0>
+ RM_IHPSG13_1P_COLUMN_256_0[6]/RM_IHPSG13_1P_BITKIT_16x2_SRAM_3[1]/A_LWL<1> RM_IHPSG13_1P_COLUMN_256_0[6]/RM_IHPSG13_1P_BITKIT_16x2_SRAM_1[1]/A_RWL<8>
+ RM_IHPSG13_1P_COLUMN_256_0[6]/RM_IHPSG13_1P_BITKIT_16x2_SRAM_2[1]/A_LWL<2> RM_IHPSG13_1P_COLUMN_256_0[6]/RM_IHPSG13_1P_BITKIT_16x2_SRAM_1[1]/A_LWL<3>
+ RM_IHPSG13_1P_COLUMN_256_0[6]/RM_IHPSG13_1P_BITKIT_16x2_SRAM_1[1]/A_LWL<1> RM_IHPSG13_1P_COLUMN_256_0[6]/RM_IHPSG13_1P_BITKIT_16x2_SRAM_1[2]/A_LWL<14>
+ RM_IHPSG13_1P_COLUMN_256_0[6]/RM_IHPSG13_1P_BITKIT_16x2_SRAM_1[0]/A_LWL<12> RM_IHPSG13_1P_COLUMN_256_0[6]/RM_IHPSG13_1P_BITKIT_16x2_SRAM_0[1]/A_LWL<10>
+ RM_IHPSG13_1P_COLUMN_256_0[6]/RM_IHPSG13_1P_BITKIT_16x2_SRAM_0[1]/A_LWL<4> RM_IHPSG13_1P_COLUMN_256_0[6]/RM_IHPSG13_1P_BITKIT_16x2_SRAM_1[3]/A_LWL<4>
+ RM_IHPSG13_1P_COLUMN_256_0[6]/RM_IHPSG13_1P_BITKIT_16x2_SRAM_3[1]/A_LWL<0> RM_IHPSG13_1P_COLUMN_256_0[6]/RM_IHPSG13_1P_BITKIT_16x2_SRAM_3[1]/A_LWL<15>
+ RM_IHPSG13_1P_COLUMN_256_0[6]/RM_IHPSG13_1P_BITKIT_16x2_SRAM_1[3]/A_LWL<11> RM_IHPSG13_1P_COLUMN_256_0[6]/RM_IHPSG13_1P_BITKIT_16x2_SRAM_1[0]/A_RWL<2>
+ RM_IHPSG13_1P_COLUMN_256_0[6]/RM_IHPSG13_1P_BITKIT_16x2_SRAM_1[1]/A_RWL<10> RM_IHPSG13_1P_COLUMN_256_0[6]/RM_IHPSG13_1P_BITKIT_16x2_SRAM_3[1]/A_RWL<5>
+ RM_IHPSG13_1P_COLUMN_256_0[6]/RM_IHPSG13_1P_BITKIT_16x2_SRAM_0[0]/A_LWL<10> RM_IHPSG13_1P_COLUMN_256_0[6]/RM_IHPSG13_1P_BITKIT_16x2_SRAM_0[3]/A_RWL<12>
+ RM_IHPSG13_1P_COLUMN_256_0[6]/RM_IHPSG13_1P_BITKIT_16x2_SRAM_3[0]/A_RWL<3> RM_IHPSG13_1P_COLUMN_256_0[6]/RM_IHPSG13_1P_BITKIT_16x2_SRAM_1[1]/A_RWL<9>
+ RM_IHPSG13_1P_COLUMN_256_0[6]/RM_IHPSG13_1P_BITKIT_16x2_SRAM_3[3]/A_RWL<15> RM_IHPSG13_1P_COLUMN_256_0[6]/RM_IHPSG13_1P_BITKIT_16x2_SRAM_2[2]/A_RWL<12>
+ RM_IHPSG13_1P_COLUMN_256_0[6]/RM_IHPSG13_1P_BITKIT_16x2_SRAM_2[1]/A_LWL<3> RM_IHPSG13_1P_COLUMN_256_0[6]/RM_IHPSG13_1P_BITKIT_16x2_SRAM_1[0]/A_RWL<11>
+ RM_IHPSG13_1P_COLUMN_256_0[6]/RM_IHPSG13_1P_BITKIT_16x2_SRAM_2[3]/A_RWL<10> RM_IHPSG13_1P_COLUMN_256_0[6]/RM_IHPSG13_1P_BITKIT_16x2_SRAM_1[1]/A_LWL<4>
+ RM_IHPSG13_1P_COLUMN_256_0[6]/RM_IHPSG13_1P_BITKIT_16x2_SRAM_1[2]/A_LWL<15> RM_IHPSG13_1P_COLUMN_256_0[6]/RM_IHPSG13_1P_BITKIT_16x2_SRAM_2[2]/A_RWL<0>
+ RM_IHPSG13_1P_COLUMN_256_0[6]/RM_IHPSG13_1P_BITKIT_16x2_SRAM_1[0]/A_LWL<6> RM_IHPSG13_1P_COLUMN_256_0[6]/RM_IHPSG13_1P_BITKIT_16x2_SRAM_1[0]/A_RWL<14>
+ RM_IHPSG13_1P_COLUMN_256_0[6]/RM_IHPSG13_1P_BITKIT_16x2_SRAM_3[1]/A_RWL<8> RM_IHPSG13_1P_COLUMN_256_0[6]/RM_IHPSG13_1P_BITKIT_16x2_SRAM_3[3]/A_RWL<7>
+ RM_IHPSG13_1P_COLUMN_256_0[6]/RM_IHPSG13_1P_BITKIT_16x2_SRAM_1[2]/A_RWL<1> RM_IHPSG13_1P_COLUMN_256_0[6]/RM_IHPSG13_1P_BITKIT_16x2_SRAM_0[1]/A_LWL<3>
+ RM_IHPSG13_1P_COLUMN_256_0[6]/RM_IHPSG13_1P_BITKIT_16x2_SRAM_2[1]/A_RWL<9> RM_IHPSG13_1P_COLUMN_256_0[6]/RM_IHPSG13_1P_BITKIT_16x2_SRAM_2[2]/A_RWL<15>
+ RM_IHPSG13_1P_COLUMN_256_0[6]/RM_IHPSG13_1P_BITKIT_16x2_SRAM_1[1]/A_RWL<11> RM_IHPSG13_1P_COLUMN_256_0[6]/RM_IHPSG13_1P_BITKIT_16x2_SRAM_2[0]/A_LWL<3>
+ RM_IHPSG13_1P_COLUMN_256_0[6]/RM_IHPSG13_1P_BITKIT_16x2_SRAM_0[2]/A_RWL<2> RM_IHPSG13_1P_COLUMN_256_0[6]/RM_IHPSG13_1P_BITKIT_16x2_SRAM_3[1]/A_LWL<3>
+ RM_IHPSG13_1P_COLUMN_256_0[6]/RM_IHPSG13_1P_BITKIT_16x2_SRAM_0[2]/A_LWL<9> RM_IHPSG13_1P_COLUMN_256_0[6]/RM_IHPSG13_1P_BITKIT_16x2_SRAM_2[0]/A_LWL<13>
+ RM_IHPSG13_1P_COLUMN_256_0[6]/RM_IHPSG13_1P_BITKIT_16x2_SRAM_3[3]/A_LWL<2> RM_IHPSG13_1P_COLUMN_256_0[6]/RM_IHPSG13_1P_BITKIT_16x2_SRAM_0[1]/A_RWL<3>
+ RM_IHPSG13_1P_COLUMN_256_0[6]/RM_IHPSG13_1P_BITKIT_16x2_SRAM_0[1]/A_RWL<9> RM_IHPSG13_1P_COLUMN_256_0[6]/RM_IHPSG13_1P_BITKIT_16x2_SRAM_2[3]/A_RWL<12>
+ RM_IHPSG13_1P_COLUMN_256_0[6]/RM_IHPSG13_1P_BITKIT_16x2_SRAM_2[3]/A_LWL<5> RM_IHPSG13_1P_COLUMN_256_0[6]/RM_IHPSG13_1P_BITKIT_16x2_SRAM_2[2]/A_LWL<8>
+ RM_IHPSG13_1P_COLUMN_256_0[6]/RM_IHPSG13_1P_BITKIT_16x2_SRAM_0[0]/A_LWL<15> RM_IHPSG13_1P_COLUMN_256_0[6]/RM_IHPSG13_1P_BITKIT_16x2_SRAM_2[0]/A_RWL<9>
+ RM_IHPSG13_1P_COLUMN_256_0[6]/RM_IHPSG13_1P_BITKIT_16x2_SRAM_1[1]/A_LWL<5> RM_IHPSG13_1P_COLUMN_256_0[6]/RM_IHPSG13_1P_BITKIT_16x2_SRAM_3[2]/A_RWL<0>
+ RM_IHPSG13_1P_COLUMN_256_0[6]/RM_IHPSG13_1P_BITKIT_16x2_SRAM_1[1]/A_LWL<15> RM_IHPSG13_1P_COLUMN_256_0[6]/RM_IHPSG13_1P_BITKIT_16x2_SRAM_0[1]/A_LWL<12>
+ RM_IHPSG13_1P_COLUMN_256_0[6]/RM_IHPSG13_1P_BITKIT_16x2_SRAM_0[1]/A_LWL<6> RM_IHPSG13_1P_COLUMN_256_0[6]/RM_IHPSG13_1P_BITKIT_16x2_SRAM_3[0]/A_LWL<15>
+ RM_IHPSG13_1P_COLUMN_256_0[6]/RM_IHPSG13_1P_BITKIT_16x2_SRAM_3[1]/A_RWL<9> RM_IHPSG13_1P_COLUMN_256_0[6]/RM_IHPSG13_1P_BITKIT_16x2_SRAM_1[3]/A_LWL<13>
+ RM_IHPSG13_1P_COLUMN_256_0[6]/RM_IHPSG13_1P_BITKIT_16x2_SRAM_1[1]/A_RWL<5> RM_IHPSG13_1P_COLUMN_256_0[6]/RM_IHPSG13_1P_BITKIT_16x2_SRAM_1[1]/A_RWL<12>
+ RM_IHPSG13_1P_COLUMN_256_0[6]/RM_IHPSG13_1P_BITKIT_16x2_SRAM_3[0]/A_RWL<5> RM_IHPSG13_1P_COLUMN_256_0[6]/RM_IHPSG13_1P_BITKIT_16x2_SRAM_3[1]/A_LWL<4>
+ RM_IHPSG13_1P_COLUMN_256_0[6]/RM_IHPSG13_1P_BITKIT_16x2_SRAM_2[3]/A_RWL<13> RM_IHPSG13_1P_COLUMN_256_0[6]/RM_IHPSG13_1P_BITKIT_16x2_SRAM_2[1]/A_RWL<12>
+ RM_IHPSG13_1P_COLUMN_256_0[6]/RM_IHPSG13_1P_BITKIT_16x2_SRAM_2[1]/A_LWL<5> RM_IHPSG13_1P_COLUMN_256_0[6]/RM_IHPSG13_1P_BITKIT_16x2_SRAM_0[3]/A_RWL<10>
+ RM_IHPSG13_1P_COLUMN_256_0[6]/RM_IHPSG13_1P_BITKIT_16x2_SRAM_1[1]/A_LWL<12> RM_IHPSG13_1P_COLUMN_256_0[6]/RM_IHPSG13_1P_BITKIT_16x2_SRAM_2[2]/A_RWL<10>
+ RM_IHPSG13_1P_COLUMN_256_0[6]/RM_IHPSG13_1P_BITKIT_16x2_SRAM_1[1]/A_LWL<6> RM_IHPSG13_1P_COLUMN_256_0[6]/RM_IHPSG13_1P_BITKIT_16x2_SRAM_3[2]/A_RWL<1>
+ RM_IHPSG13_1P_COLUMN_256_0[6]/RM_IHPSG13_1P_BITKIT_16x2_SRAM_0[1]/A_LWL<13> RM_IHPSG13_1P_COLUMN_256_0[6]/RM_IHPSG13_1P_BITKIT_16x2_SRAM_1[3]/A_RWL<7>
+ RM_IHPSG13_1P_COLUMN_256_0[6]/RM_IHPSG13_1P_BITKIT_16x2_SRAM_0[1]/A_LWL<7> RM_IHPSG13_1P_COLUMN_256_0[6]/RM_IHPSG13_1P_BITKIT_16x2_SRAM_2[2]/A_RWL<2>
+ RM_IHPSG13_1P_COLUMN_256_0[6]/RM_IHPSG13_1P_BITKIT_16x2_SRAM_1[1]/A_RWL<2> RM_IHPSG13_1P_COLUMN_256_0[6]/RM_IHPSG13_1P_BITKIT_16x2_SRAM_1[2]/A_RWL<0>
+ RM_IHPSG13_1P_COLUMN_256_0[6]/RM_IHPSG13_1P_BITKIT_16x2_SRAM_1[0]/A_RWL<15> RM_IHPSG13_1P_COLUMN_256_0[6]/RM_IHPSG13_1P_BITKIT_16x2_SRAM_3[2]/A_LWL<9>
+ RM_IHPSG13_1P_COLUMN_256_0[6]/RM_IHPSG13_1P_BITKIT_16x2_SRAM_1[3]/A_LWL<14> RM_IHPSG13_1P_COLUMN_256_0[6]/RM_IHPSG13_1P_BITKIT_16x2_SRAM_3[1]/A_RWL<0>
+ RM_IHPSG13_1P_COLUMN_256_0[6]/RM_IHPSG13_1P_BITKIT_16x2_SRAM_3[1]/A_RWL<3> RM_IHPSG13_1P_COLUMN_256_0[6]/RM_IHPSG13_1P_BITKIT_16x2_SRAM_0[0]/A_LWL<3>
+ RM_IHPSG13_1P_COLUMN_256_0[6]/RM_IHPSG13_1P_BITKIT_16x2_SRAM_1[2]/A_RWL<3> RM_IHPSG13_1P_COLUMN_256_0[6]/RM_IHPSG13_1P_BITKIT_16x2_SRAM_0[2]/A_LWL<10>
+ RM_IHPSG13_1P_COLUMN_256_0[6]/RM_IHPSG13_1P_BITKIT_16x2_SRAM_1[3]/A_LWL<2> RM_IHPSG13_1P_COLUMN_256_0[6]/RM_IHPSG13_1P_BITKIT_16x2_SRAM_0[2]/A_RWL<4>
+ RM_IHPSG13_1P_COLUMN_256_0[6]/RM_IHPSG13_1P_BITKIT_16x2_SRAM_0[0]/A_RWL<9> RM_IHPSG13_1P_COLUMN_256_0[6]/RM_IHPSG13_1P_BITKIT_16x2_SRAM_2[1]/A_LWL<6>
+ RM_IHPSG13_1P_COLUMN_256_0[6]/RM_IHPSG13_1P_BITKIT_16x2_SRAM_1[2]/A_RWL<10> RM_IHPSG13_1P_COLUMN_256_0[6]/RM_IHPSG13_1P_BITKIT_16x2_SRAM_2[3]/A_LWL<11>
+ RM_IHPSG13_1P_COLUMN_256_0[6]/RM_IHPSG13_1P_BITKIT_16x2_SRAM_3[2]/A_RWL<2> RM_IHPSG13_1P_COLUMN_256_0[6]/RM_IHPSG13_1P_BITKIT_16x2_SRAM_1[0]/A_LWL<15>
+ RM_IHPSG13_1P_COLUMN_256_0[6]/RM_IHPSG13_1P_BITKIT_16x2_SRAM_0[3]/A_LWL<0> RM_IHPSG13_1P_COLUMN_256_0[6]/RM_IHPSG13_1P_BITKIT_16x2_SRAM_2[3]/A_LWL<14>
+ RM_IHPSG13_1P_COLUMN_256_0[6]/RM_IHPSG13_1P_BITKIT_16x2_SRAM_2[2]/A_RWL<3> RM_IHPSG13_1P_COLUMN_256_0[6]/RM_IHPSG13_1P_BITKIT_16x2_SRAM_0[0]/A_LWL<5>
+ RM_IHPSG13_1P_COLUMN_256_0[6]/RM_IHPSG13_1P_BITKIT_16x2_SRAM_1[3]/A_LWL<15> RM_IHPSG13_1P_COLUMN_256_0[6]/RM_IHPSG13_1P_BITKIT_16x2_SRAM_1[0]/A_RWL<5>
+ RM_IHPSG13_1P_COLUMN_256_0[6]/RM_IHPSG13_1P_BITKIT_16x2_SRAM_2[1]/A_LWL<13> RM_IHPSG13_1P_COLUMN_256_0[6]/RM_IHPSG13_1P_BITKIT_16x2_SRAM_0[3]/A_LWL<9>
+ RM_IHPSG13_1P_COLUMN_256_0[6]/RM_IHPSG13_1P_BITKIT_16x2_SRAM_0[2]/A_RWL<3> RM_IHPSG13_1P_COLUMN_256_0[6]/RM_IHPSG13_1P_BITKIT_16x2_SRAM_3[3]/A_LWL<7>
+ RM_IHPSG13_1P_COLUMN_256_0[6]/RM_IHPSG13_1P_BITKIT_16x2_SRAM_2[0]/A_LWL<4> RM_IHPSG13_1P_COLUMN_256_0[6]/RM_IHPSG13_1P_BITKIT_16x2_SRAM_1[1]/A_RWL<14>
+ RM_IHPSG13_1P_COLUMN_256_0[6]/RM_IHPSG13_1P_BITKIT_16x2_SRAM_0[2]/A_RWL<5> RM_IHPSG13_1P_COLUMN_256_0[6]/RM_IHPSG13_1P_BITKIT_16x2_SRAM_2[3]/A_LWL<8>
+ RM_IHPSG13_1P_COLUMN_256_0[6]/RM_IHPSG13_1P_BITKIT_16x2_SRAM_3[1]/A_LWL<6> RM_IHPSG13_1P_COLUMN_256_0[6]/RM_IHPSG13_1P_BITKIT_16x2_SRAM_2[0]/A_RWL<12>
+ RM_IHPSG13_1P_COLUMN_256_0[6]/RM_IHPSG13_1P_BITKIT_16x2_SRAM_2[3]/A_RWL<15> RM_IHPSG13_1P_COLUMN_256_0[6]/RM_IHPSG13_1P_BITKIT_16x2_SRAM_1[2]/A_RWL<11>
+ RM_IHPSG13_1P_COLUMN_256_0[6]/RM_IHPSG13_1P_BITKIT_16x2_SRAM_2[1]/A_LWL<7> RM_IHPSG13_1P_COLUMN_256_0[6]/RM_IHPSG13_1P_BITKIT_16x2_SRAM_2[0]/A_RWL<14>
+ RM_IHPSG13_1P_COLUMN_256_0[6]/RM_IHPSG13_1P_BITKIT_16x2_SRAM_3[3]/A_RWL<13> RM_IHPSG13_1P_COLUMN_256_0[6]/RM_IHPSG13_1P_BITKIT_16x2_SRAM_0[2]/A_LWL<0>
+ RM_IHPSG13_1P_COLUMN_256_0[6]/RM_IHPSG13_1P_BITKIT_16x2_SRAM_2[1]/A_RWL<10> RM_IHPSG13_1P_COLUMN_256_0[6]/RM_IHPSG13_1P_BITKIT_16x2_SRAM_1[1]/A_LWL<8>
+ RM_IHPSG13_1P_COLUMN_256_0[6]/RM_IHPSG13_1P_BITKIT_16x2_SRAM_0[1]/A_LWL<15> RM_IHPSG13_1P_COLUMN_256_0[6]/RM_IHPSG13_1P_BITKIT_16x2_SRAM_0[1]/A_LWL<9>
+ RM_IHPSG13_1P_COLUMN_256_0[6]/RM_IHPSG13_1P_BITKIT_16x2_SRAM_2[2]/A_RWL<4> RM_IHPSG13_1P_COLUMN_256_0[6]/RM_IHPSG13_1P_BITKIT_16x2_SRAM_1[1]/A_RWL<0>
+ RM_IHPSG13_1P_COLUMN_256_0[6]/RM_IHPSG13_1P_BITKIT_16x2_SRAM_3[1]/A_RWL<7> RM_IHPSG13_1P_COLUMN_256_0[6]/RM_IHPSG13_1P_BITKIT_16x2_SRAM_3[0]/A_RWL<0>
+ RM_IHPSG13_1P_COLUMN_256_0[6]/RM_IHPSG13_1P_BITKIT_16x2_SRAM_1[2]/A_RWL<5> RM_IHPSG13_1P_COLUMN_256_0[6]/RM_IHPSG13_1P_BITKIT_16x2_SRAM_0[2]/A_LWL<12>
+ RM_IHPSG13_1P_COLUMN_256_0[6]/RM_IHPSG13_1P_BITKIT_16x2_SRAM_0[0]/A_RWL<11> RM_IHPSG13_1P_COLUMN_256_0[6]/RM_IHPSG13_1P_BITKIT_16x2_SRAM_1[3]/A_LWL<1>
+ RM_IHPSG13_1P_COLUMN_256_0[6]/RM_IHPSG13_1P_BITKIT_16x2_SRAM_3[1]/A_LWL<2> RM_IHPSG13_1P_COLUMN_256_0[6]/RM_IHPSG13_1P_BITKIT_16x2_SRAM_1[2]/A_LWL<12>
+ RM_IHPSG13_1P_COLUMN_256_0[6]/RM_IHPSG13_1P_BITKIT_16x2_SRAM_1[2]/A_LWL<0> RM_IHPSG13_1P_COLUMN_256_0[6]/RM_IHPSG13_1P_BITKIT_16x2_SRAM_3[3]/A_LWL<0>
+ RM_IHPSG13_1P_COLUMN_256_0[6]/RM_IHPSG13_1P_BITKIT_16x2_SRAM_1[2]/A_RWL<12> RM_IHPSG13_1P_COLUMN_256_0[6]/RM_IHPSG13_1P_BITKIT_16x2_SRAM_2[1]/A_LWL<8>
+ RM_IHPSG13_1P_COLUMN_256_0[6]/RM_IHPSG13_1P_BITKIT_16x2_SRAM_2[2]/A_LWL<11> RM_IHPSG13_1P_COLUMN_256_0[6]/RM_IHPSG13_1P_BITKIT_16x2_SRAM_0[2]/A_LWL<1>
+ RM_IHPSG13_1P_COLUMN_256_0[6]/RM_IHPSG13_1P_BITKIT_16x2_SRAM_1[2]/A_RWL<2> RM_IHPSG13_1P_COLUMN_256_0[6]/RM_IHPSG13_1P_BITKIT_16x2_SRAM_3[0]/A_LWL<5>
+ RM_IHPSG13_1P_COLUMN_256_0[6]/RM_IHPSG13_1P_BITKIT_16x2_SRAM_1[1]/A_RWL<15> RM_IHPSG13_1P_COLUMN_256_0[6]/RM_IHPSG13_1P_BITKIT_16x2_SRAM_3[3]/A_LWL<9>
+ RM_IHPSG13_1P_COLUMN_256_0[6]/RM_IHPSG13_1P_BITKIT_16x2_SRAM_2[2]/A_LWL<14> RM_IHPSG13_1P_COLUMN_256_0[6]/RM_IHPSG13_1P_BITKIT_16x2_SRAM_3[2]/A_RWL<3>
+ RM_IHPSG13_1P_COLUMN_256_0[6]/RM_IHPSG13_1P_BITKIT_16x2_SRAM_2[2]/A_RWL<5> RM_IHPSG13_1P_COLUMN_256_0[6]/RM_IHPSG13_1P_BITKIT_16x2_SRAM_1[3]/A_LWL<7>
+ RM_IHPSG13_1P_COLUMN_256_0[6]/RM_IHPSG13_1P_BITKIT_16x2_SRAM_1[2]/A_RWL<6> RM_IHPSG13_1P_COLUMN_256_0[6]/RM_IHPSG13_1P_BITKIT_16x2_SRAM_0[2]/A_LWL<13>
+ RM_IHPSG13_1P_COLUMN_256_0[6]/RM_IHPSG13_1P_BITKIT_16x2_SRAM_3[2]/A_LWL<7> RM_IHPSG13_1P_COLUMN_256_0[6]/RM_IHPSG13_1P_BITKIT_16x2_SRAM_2[2]/A_LWL<0>
+ RM_IHPSG13_1P_COLUMN_256_0[6]/RM_IHPSG13_1P_BITKIT_16x2_SRAM_0[0]/A_RWL<12> RM_IHPSG13_1P_COLUMN_256_0[6]/RM_IHPSG13_1P_BITKIT_16x2_SRAM_0[2]/A_RWL<7>
+ RM_IHPSG13_1P_COLUMN_256_0[6]/RM_IHPSG13_1P_BITKIT_16x2_SRAM_0[3]/A_LWL<10> RM_IHPSG13_1P_COLUMN_256_0[6]/RM_IHPSG13_1P_BITKIT_16x2_SRAM_1[2]/A_LWL<1>
+ RM_IHPSG13_1P_COLUMN_256_0[6]/RM_IHPSG13_1P_BITKIT_16x2_SRAM_3[2]/A_RWL<13> RM_IHPSG13_1P_COLUMN_256_0[6]/RM_IHPSG13_1P_BITKIT_16x2_SRAM_2[1]/A_LWL<9>
+ RM_IHPSG13_1P_COLUMN_256_0[6]/RM_IHPSG13_1P_BITKIT_16x2_SRAM_2[0]/A_RWL<10> RM_IHPSG13_1P_COLUMN_256_0[6]/RM_IHPSG13_1P_BITKIT_16x2_SRAM_0[2]/A_LWL<2>
+ RM_IHPSG13_1P_COLUMN_256_0[6]/RM_IHPSG13_1P_BITKIT_16x2_SRAM_2[3]/A_RWL<8> RM_IHPSG13_1P_COLUMN_256_0[6]/RM_IHPSG13_1P_BITKIT_16x2_SRAM_3[2]/A_RWL<5>
+ RM_IHPSG13_1P_COLUMN_256_0[6]/RM_IHPSG13_1P_BITKIT_16x2_SRAM_1[3]/A_RWL<10> RM_IHPSG13_1P_COLUMN_256_0[6]/RM_IHPSG13_1P_BITKIT_16x2_SRAM_0[1]/A_LWL<5>
+ RM_IHPSG13_1P_COLUMN_256_0[6]/RM_IHPSG13_1P_BITKIT_16x2_SRAM_0[0]/A_LWL<8> RM_IHPSG13_1P_COLUMN_256_0[6]/RM_IHPSG13_1P_BITKIT_16x2_SRAM_1[1]/A_RWL<7>
+ RM_IHPSG13_1P_COLUMN_256_0[6]/RM_IHPSG13_1P_BITKIT_16x2_SRAM_2[2]/A_LWL<13> RM_IHPSG13_1P_COLUMN_256_0[6]/RM_IHPSG13_1P_BITKIT_16x2_SRAM_1[0]/A_RWL<0>
+ RM_IHPSG13_1P_COLUMN_256_0[6]/RM_IHPSG13_1P_BITKIT_16x2_SRAM_2[1]/A_LWL<4> RM_IHPSG13_1P_COLUMN_256_0[6]/RM_IHPSG13_1P_BITKIT_16x2_SRAM_3[0]/A_RWL<7>
+ RM_IHPSG13_1P_COLUMN_256_0[6]/RM_IHPSG13_1P_BITKIT_16x2_SRAM_3[2]/A_LWL<0> RM_IHPSG13_1P_COLUMN_256_0[6]/RM_IHPSG13_1P_BITKIT_16x2_SRAM_1[2]/A_RWL<7>
+ RM_IHPSG13_1P_COLUMN_256_0[6]/RM_IHPSG13_1P_BITKIT_16x2_SRAM_1[1]/A_LWL<2> RM_IHPSG13_1P_COLUMN_256_0[6]/RM_IHPSG13_1P_BITKIT_16x2_SRAM_0[0]/A_RWL<13>
+ RM_IHPSG13_1P_COLUMN_256_0[6]/RM_IHPSG13_1P_BITKIT_16x2_SRAM_2[1]/A_RWL<14> RM_IHPSG13_1P_COLUMN_256_0[6]/RM_IHPSG13_1P_BITKIT_16x2_SRAM_2[2]/A_LWL<1>
+ RM_IHPSG13_1P_COLUMN_256_0[6]/RM_IHPSG13_1P_BITKIT_16x2_SRAM_3[1]/A_LWL<9> RM_IHPSG13_1P_COLUMN_256_0[6]/RM_IHPSG13_1P_BITKIT_16x2_SRAM_3[0]/A_LWL<2>
+ RM_IHPSG13_1P_COLUMN_256_0[6]/RM_IHPSG13_1P_BITKIT_16x2_SRAM_3[3]/A_RWL<4> RM_IHPSG13_1P_COLUMN_256_0[6]/RM_IHPSG13_1P_BITKIT_16x2_SRAM_0[2]/A_LWL<11>
+ RM_IHPSG13_1P_COLUMN_256_0[6]/RM_IHPSG13_1P_BITKIT_16x2_SRAM_0[3]/A_LWL<11> RM_IHPSG13_1P_COLUMN_256_0[6]/RM_IHPSG13_1P_BITKIT_16x2_SRAM_1[2]/A_LWL<2>
+ RM_IHPSG13_1P_COLUMN_256_0[6]/RM_IHPSG13_1P_BITKIT_16x2_SRAM_1[2]/A_RWL<14> RM_IHPSG13_1P_COLUMN_256_0[6]/RM_IHPSG13_1P_BITKIT_16x2_SRAM_2[1]/A_LWL<11>
+ RM_IHPSG13_1P_COLUMN_256_0[6]/RM_IHPSG13_1P_BITKIT_16x2_SRAM_0[1]/A_RWL<10> RM_IHPSG13_1P_COLUMN_256_0[6]/RM_IHPSG13_1P_BITKIT_16x2_SRAM_0[2]/A_LWL<3>
+ RM_IHPSG13_1P_COLUMN_256_0[6]/RM_IHPSG13_1P_BITKIT_16x2_SRAM_0[2]/A_LWL<14> RM_IHPSG13_1P_COLUMN_256_0[6]/RM_IHPSG13_1P_BITKIT_16x2_SRAM_3[2]/A_RWL<6>
+ RM_IHPSG13_1P_COLUMN_256_0[6]/RM_IHPSG13_1P_BITKIT_16x2_SRAM_1[3]/A_RWL<11> RM_IHPSG13_1P_COLUMN_256_0[6]/RM_IHPSG13_1P_BITKIT_16x2_SRAM_2[1]/A_LWL<14>
+ RM_IHPSG13_1P_COLUMN_256_0[6]/RM_IHPSG13_1P_BITKIT_16x2_SRAM_2[2]/A_RWL<7> RM_IHPSG13_1P_COLUMN_256_0[6]/RM_IHPSG13_1P_BITKIT_16x2_SRAM_0[3]/A_RWL<0>
+ RM_IHPSG13_1P_COLUMN_256_0[6]/RM_IHPSG13_1P_BITKIT_16x2_SRAM_1[0]/A_LWL<0> RM_IHPSG13_1P_COLUMN_256_0[6]/RM_IHPSG13_1P_BITKIT_16x2_SRAM_1[2]/A_RWL<8>
+ RM_IHPSG13_1P_COLUMN_256_0[6]/RM_IHPSG13_1P_BITKIT_16x2_SRAM_3[2]/A_LWL<1> RM_IHPSG13_1P_COLUMN_256_0[6]/RM_IHPSG13_1P_BITKIT_16x2_SRAM_0[2]/A_LWL<15>
+ RM_IHPSG13_1P_COLUMN_256_0[6]/RM_IHPSG13_1P_BITKIT_16x2_SRAM_1[3]/A_LWL<12> RM_IHPSG13_1P_COLUMN_256_0[6]/RM_IHPSG13_1P_BITKIT_16x2_SRAM_3[1]/A_LWL<7>
+ RM_IHPSG13_1P_COLUMN_256_0[6]/RM_IHPSG13_1P_BITKIT_16x2_SRAM_0[2]/A_RWL<9> RM_IHPSG13_1P_COLUMN_256_0[6]/RM_IHPSG13_1P_BITKIT_16x2_SRAM_0[0]/A_RWL<14>
+ RM_IHPSG13_1P_COLUMN_256_0[6]/RM_IHPSG13_1P_BITKIT_16x2_SRAM_2[2]/A_LWL<2> RM_IHPSG13_1P_COLUMN_256_0[6]/RM_IHPSG13_1P_BITKIT_16x2_SRAM_1[2]/A_RWL<13>
+ RM_IHPSG13_1P_COLUMN_256_0[6]/RM_IHPSG13_1P_BITKIT_16x2_SRAM_1[0]/A_LWL<9> RM_IHPSG13_1P_COLUMN_256_0[6]/RM_IHPSG13_1P_BITKIT_16x2_SRAM_0[3]/A_LWL<12>
+ RM_IHPSG13_1P_COLUMN_256_0[6]/RM_IHPSG13_1P_BITKIT_16x2_SRAM_1[2]/A_LWL<3> RM_IHPSG13_1P_COLUMN_256_0[6]/RM_IHPSG13_1P_BITKIT_16x2_SRAM_3[1]/A_RWL<13>
+ RM_IHPSG13_1P_COLUMN_256_0[6]/RM_IHPSG13_1P_BITKIT_16x2_SRAM_3[1]/A_LWL<5> RM_IHPSG13_1P_COLUMN_256_0[6]/RM_IHPSG13_1P_BITKIT_16x2_SRAM_0[0]/A_RWL<10>
+ RM_IHPSG13_1P_COLUMN_256_0[6]/RM_IHPSG13_1P_BITKIT_16x2_SRAM_0[3]/A_RWL<8> RM_IHPSG13_1P_COLUMN_256_0[6]/RM_IHPSG13_1P_BITKIT_16x2_SRAM_1[2]/A_RWL<15>
+ RM_IHPSG13_1P_COLUMN_256_0[6]/RM_IHPSG13_1P_BITKIT_16x2_SRAM_3[0]/A_LWL<8> RM_IHPSG13_1P_COLUMN_256_0[6]/RM_IHPSG13_1P_BITKIT_16x2_SRAM_0[1]/A_RWL<11>
+ RM_IHPSG13_1P_COLUMN_256_0[6]/RM_IHPSG13_1P_BITKIT_16x2_SRAM_3[3]/A_RWL<3> RM_IHPSG13_1P_COLUMN_256_0[6]/RM_IHPSG13_1P_BITKIT_16x2_SRAM_0[2]/A_LWL<4>
+ RM_IHPSG13_1P_COLUMN_256_0[6]/RM_IHPSG13_1P_BITKIT_16x2_SRAM_3[2]/A_RWL<7> RM_IHPSG13_1P_COLUMN_256_0[6]/RM_IHPSG13_1P_BITKIT_16x2_SRAM_1[3]/A_RWL<12>
+ RM_IHPSG13_1P_COLUMN_256_0[6]/RM_IHPSG13_1P_BITKIT_16x2_SRAM_1[0]/A_RWL<7> RM_IHPSG13_1P_COLUMN_256_0[6]/RM_IHPSG13_1P_BITKIT_16x2_SRAM_1[3]/A_RWL<0>
+ RM_IHPSG13_1P_COLUMN_256_0[6]/RM_IHPSG13_1P_BITKIT_16x2_SRAM_2[2]/A_RWL<8> RM_IHPSG13_1P_COLUMN_256_0[6]/RM_IHPSG13_1P_BITKIT_16x2_SRAM_2[3]/A_RWL<6>
+ RM_IHPSG13_1P_COLUMN_256_0[6]/RM_IHPSG13_1P_BITKIT_16x2_SRAM_2[2]/A_RWL<1> RM_IHPSG13_1P_COLUMN_256_0[6]/RM_IHPSG13_1P_BITKIT_16x2_SRAM_0[3]/A_RWL<1>
+ RM_IHPSG13_1P_COLUMN_256_0[6]/RM_IHPSG13_1P_BITKIT_16x2_SRAM_3[2]/A_LWL<2> RM_IHPSG13_1P_COLUMN_256_0[6]/RM_IHPSG13_1P_BITKIT_16x2_SRAM_1[2]/A_RWL<9>
+ RM_IHPSG13_1P_COLUMN_256_0[6]/RM_IHPSG13_1P_BITKIT_16x2_SRAM_1[0]/A_LWL<2> RM_IHPSG13_1P_COLUMN_256_0[6]/RM_IHPSG13_1P_BITKIT_16x2_SRAM_2[2]/A_LWL<3>
+ RM_IHPSG13_1P_COLUMN_256_0[6]/RM_IHPSG13_1P_BITKIT_16x2_SRAM_0[0]/A_RWL<15> RM_IHPSG13_1P_COLUMN_256_0[6]/RM_IHPSG13_1P_BITKIT_16x2_SRAM_0[1]/A_LWL<11>
+ RM_IHPSG13_1P_COLUMN_256_0[6]/RM_IHPSG13_1P_BITKIT_16x2_SRAM_3[2]/A_RWL<4> RM_IHPSG13_1P_COLUMN_256_0[6]/RM_IHPSG13_1P_BITKIT_16x2_SRAM_0[3]/A_LWL<13>
+ RM_IHPSG13_1P_COLUMN_256_0[6]/RM_IHPSG13_1P_BITKIT_16x2_SRAM_1[2]/A_LWL<4> RM_IHPSG13_1P_COLUMN_256_0[6]/RM_IHPSG13_1P_BITKIT_16x2_SRAM_2[0]/A_LWL<11>
+ RM_IHPSG13_1P_COLUMN_256_0[6]/RM_IHPSG13_1P_BITKIT_16x2_SRAM_0[1]/A_RWL<12> RM_IHPSG13_1P_COLUMN_256_0[6]/RM_IHPSG13_1P_BITKIT_16x2_SRAM_3[3]/A_LWL<10>
+ RM_IHPSG13_1P_COLUMN_256_0[6]/RM_IHPSG13_1P_BITKIT_16x2_SRAM_2[0]/A_LWL<1> RM_IHPSG13_1P_COLUMN_256_0[6]/RM_IHPSG13_1P_BITKIT_16x2_SRAM_0[1]/A_LWL<8>
+ RM_IHPSG13_1P_COLUMN_256_0[6]/RM_IHPSG13_1P_BITKIT_16x2_SRAM_0[1]/A_LWL<14> RM_IHPSG13_1P_COLUMN_256_0[6]/RM_IHPSG13_1P_BITKIT_16x2_SRAM_0[2]/A_LWL<5>
+ RM_IHPSG13_1P_COLUMN_256_0[6]/RM_IHPSG13_1P_BITKIT_16x2_SRAM_2[3]/A_RWL<0> RM_IHPSG13_1P_COLUMN_256_0[6]/RM_IHPSG13_1P_BITKIT_16x2_SRAM_2[3]/A_LWL<13>
+ RM_IHPSG13_1P_COLUMN_256_0[6]/RM_IHPSG13_1P_BITKIT_16x2_SRAM_3[2]/A_RWL<8> RM_IHPSG13_1P_COLUMN_256_0[6]/RM_IHPSG13_1P_BITKIT_16x2_SRAM_1[3]/A_RWL<13>
+ RM_IHPSG13_1P_COLUMN_256_0[6]/RM_IHPSG13_1P_BITKIT_16x2_SRAM_2[0]/A_LWL<14> RM_IHPSG13_1P_COLUMN_256_0[6]/RM_IHPSG13_1P_BITKIT_16x2_SRAM_1[3]/A_RWL<1>
+ RM_IHPSG13_1P_COLUMN_256_0[6]/RM_IHPSG13_1P_BITKIT_16x2_SRAM_2[2]/A_RWL<9> RM_IHPSG13_1P_COLUMN_256_0[6]/RM_IHPSG13_1P_BITKIT_16x2_SRAM_1[1]/A_LWL<7>
+ RM_IHPSG13_1P_COLUMN_256_0[6]/RM_IHPSG13_1P_BITKIT_16x2_SRAM_2[2]/A_RWL<14> RM_IHPSG13_1P_COLUMN_256_0[6]/RM_IHPSG13_1P_BITKIT_16x2_SRAM_0[3]/A_RWL<2>
+ RM_IHPSG13_1P_COLUMN_256_0[6]/RM_IHPSG13_1P_BITKIT_16x2_SRAM_3[2]/A_LWL<3> RM_IHPSG13_1P_COLUMN_256_0[6]/RM_IHPSG13_1P_BITKIT_16x2_SRAM_3[0]/A_LWL<7>
+ RM_IHPSG13_1P_COLUMN_256_0[6]/RM_IHPSG13_1P_BITKIT_16x2_SRAM_2[2]/A_LWL<4> RM_IHPSG13_1P_COLUMN_256_0[6]/RM_IHPSG13_1P_BITKIT_16x2_SRAM_1[1]/A_RWL<13>
+ RM_IHPSG13_1P_COLUMN_256_0[6]/RM_IHPSG13_1P_BITKIT_16x2_SRAM_0[3]/A_LWL<14> RM_IHPSG13_1P_COLUMN_256_0[6]/RM_IHPSG13_1P_BITKIT_16x2_SRAM_3[0]/A_RWL<13>
+ RM_IHPSG13_1P_COLUMN_256_0[6]/RM_IHPSG13_1P_BITKIT_16x2_SRAM_1[2]/A_LWL<5> RM_IHPSG13_1P_COLUMN_256_0[6]/RM_IHPSG13_1P_BITKIT_16x2_SRAM_3[3]/A_RWL<0>
+ RM_IHPSG13_1P_COLUMN_256_0[6]/RM_IHPSG13_1P_BITKIT_16x2_SRAM_0[2]/A_RWL<8> RM_IHPSG13_1P_COLUMN_256_0[6]/RM_IHPSG13_1P_BITKIT_16x2_SRAM_0[1]/A_RWL<13>
+ RM_IHPSG13_1P_COLUMN_256_0[6]/RM_IHPSG13_1P_BITKIT_16x2_SRAM_3[0]/A_LWL<10> RM_IHPSG13_1P_COLUMN_256_0[6]/RM_IHPSG13_1P_BITKIT_16x2_SRAM_2[1]/A_RWL<8>
+ RM_IHPSG13_1P_COLUMN_256_0[6]/RM_IHPSG13_1P_BITKIT_16x2_SRAM_0[2]/A_LWL<6> RM_IHPSG13_1P_COLUMN_256_0[6]/RM_IHPSG13_1P_BITKIT_16x2_SRAM_2[3]/A_RWL<1>
+ RM_IHPSG13_1P_COLUMN_256_0[6]/RM_IHPSG13_1P_BITKIT_16x2_SRAM_3[2]/A_RWL<9> RM_IHPSG13_1P_COLUMN_256_0[6]/RM_IHPSG13_1P_BITKIT_16x2_SRAM_0[3]/A_RWL<6>
+ RM_IHPSG13_1P_COLUMN_256_0[6]/RM_IHPSG13_1P_BITKIT_16x2_SRAM_1[3]/A_RWL<14> RM_IHPSG13_1P_COLUMN_256_0[6]/RM_IHPSG13_1P_BITKIT_16x2_SRAM_0[2]/A_RWL<1>
+ RM_IHPSG13_1P_COLUMN_256_0[6]/RM_IHPSG13_1P_BITKIT_16x2_SRAM_1[1]/A_LWL<0> RM_IHPSG13_1P_COLUMN_256_0[6]/RM_IHPSG13_1P_BITKIT_16x2_SRAM_0[2]/A_RWL<10>
+ RM_IHPSG13_1P_COLUMN_256_0[6]/RM_IHPSG13_1P_BITKIT_16x2_SRAM_1[3]/A_RWL<2> RM_IHPSG13_1P_COLUMN_256_0[6]/RM_IHPSG13_1P_BITKIT_16x2_SRAM_2[2]/A_RWL<6>
+ RM_IHPSG13_1P_COLUMN_256_0[6]/RM_IHPSG13_1P_BITKIT_16x2_SRAM_2[1]/A_RWL<1> RM_IHPSG13_1P_COLUMN_256_0[6]/RM_IHPSG13_1P_BITKIT_16x2_SRAM_0[3]/A_RWL<3>
+ RM_IHPSG13_1P_COLUMN_256_0[6]/RM_IHPSG13_1P_BITKIT_16x2_SRAM_3[2]/A_LWL<4> RM_IHPSG13_1P_COLUMN_256_0[6]/RM_IHPSG13_1P_BITKIT_16x2_SRAM_1[1]/A_LWL<9>
+ RM_IHPSG13_1P_COLUMN_256_0[6]/RM_IHPSG13_1P_BITKIT_16x2_SRAM_1[2]/A_RWL<4> RM_IHPSG13_1P_COLUMN_256_0[6]/RM_IHPSG13_1P_BITKIT_16x2_SRAM_1[0]/A_RWL<3>
+ RM_IHPSG13_1P_COLUMN_256_0[6]/RM_IHPSG13_1P_BITKIT_16x2_SRAM_2[2]/A_LWL<5> RM_IHPSG13_1P_COLUMN_256_0[6]/RM_IHPSG13_1P_BITKIT_16x2_SRAM_3[1]/A_LWL<8>
+ RM_IHPSG13_1P_COLUMN_256_0[6]/RM_IHPSG13_1P_BITKIT_16x2_SRAM_0[0]/A_LWL<11> RM_IHPSG13_1P_COLUMN_256_0[6]/RM_IHPSG13_1P_BITKIT_16x2_SRAM_3[1]/A_RWL<4>
+ RM_IHPSG13_1P_COLUMN_256_0[6]/RM_IHPSG13_1P_BITKIT_16x2_SRAM_0[3]/A_LWL<15> RM_IHPSG13_1P_COLUMN_256_0[6]/RM_IHPSG13_1P_BITKIT_16x2_SRAM_1[3]/A_LWL<10>
+ RM_IHPSG13_1P_COLUMN_256_0[6]/RM_IHPSG13_1P_BITKIT_16x2_SRAM_1[2]/A_LWL<6> RM_IHPSG13_1P_COLUMN_256_0[6]/RM_IHPSG13_1P_BITKIT_16x2_SRAM_3[3]/A_RWL<1>
+ RM_IHPSG13_1P_COLUMN_256_0[6]/RM_IHPSG13_1P_BITKIT_16x2_SRAM_0[1]/A_RWL<14> RM_IHPSG13_1P_COLUMN_256_0[6]/RM_IHPSG13_1P_BITKIT_16x2_SRAM_3[2]/A_LWL<10>
+ RM_IHPSG13_1P_COLUMN_256_0[6]/RM_IHPSG13_1P_BITKIT_16x2_SRAM_3[0]/A_LWL<11> RM_IHPSG13_1P_COLUMN_256_0[6]/RM_IHPSG13_1P_BITKIT_16x2_SRAM_0[0]/A_LWL<14>
+ RM_IHPSG13_1P_COLUMN_256_0[6]/RM_IHPSG13_1P_BITKIT_16x2_SRAM_0[2]/A_LWL<7> RM_IHPSG13_1P_COLUMN_256_0[6]/RM_IHPSG13_1P_BITKIT_16x2_SRAM_2[3]/A_RWL<2>
+ RM_IHPSG13_1P_COLUMN_256_0[6]/RM_IHPSG13_1P_BITKIT_16x2_SRAM_2[3]/A_RWL<11> RM_IHPSG13_1P_COLUMN_256_0[6]/RM_IHPSG13_1P_BITKIT_16x2_SRAM_1[3]/A_RWL<15>
+ RM_IHPSG13_1P_COLUMN_256_0[6]/RM_IHPSG13_1P_BITKIT_16x2_SRAM_0[2]/A_RWL<11> RM_IHPSG13_1P_COLUMN_256_0[6]/RM_IHPSG13_1P_BITKIT_16x2_SRAM_1[3]/A_RWL<3>
+ RM_IHPSG13_1P_COLUMN_256_0[6]/RM_IHPSG13_1P_BITKIT_16x2_SRAM_1[0]/A_LWL<7> RM_IHPSG13_1P_COLUMN_256_0[6]/RM_IHPSG13_1P_BITKIT_16x2_SRAM_0[3]/A_RWL<4>
+ RM_IHPSG13_1P_COLUMN_256_0[6]/RM_IHPSG13_1P_BITKIT_16x2_SRAM_2[3]/A_LWL<6> RM_IHPSG13_1P_COLUMN_256_0[6]/RM_IHPSG13_1P_BITKIT_16x2_SRAM_3[2]/A_LWL<5>
+ RM_IHPSG13_1P_COLUMN_256_0[6]/RM_IHPSG13_1P_BITKIT_16x2_SRAM_0[0]/A_LWL<13> RM_IHPSG13_1P_COLUMN_256_0[6]/RM_IHPSG13_1P_BITKIT_16x2_SRAM_2[2]/A_LWL<6>
+ RM_IHPSG13_1P_COLUMN_256_0[6]/RM_IHPSG13_1P_BITKIT_16x2_SRAM_1[0]/A_RWL<13> RM_IHPSG13_1P_COLUMN_256_0[6]/RM_IHPSG13_1P_BITKIT_16x2_SRAM_2[1]/A_LWL<1>
+ RM_IHPSG13_1P_COLUMN_256_0[6]/RM_IHPSG13_1P_BITKIT_16x2_SRAM_0[3]/A_LWL<5> RM_IHPSG13_1P_COLUMN_256_0[6]/RM_IHPSG13_1P_BITKIT_16x2_SRAM_2[0]/A_LWL<12>
+ RM_IHPSG13_1P_COLUMN_256_0[6]/RM_IHPSG13_1P_BITKIT_16x2_SRAM_3[3]/A_LWL<3> RM_IHPSG13_1P_COLUMN_256_0[6]/RM_IHPSG13_1P_BITKIT_16x2_SRAM_1[2]/A_LWL<7>
+ RM_IHPSG13_1P_COLUMN_256_0[6]/RM_IHPSG13_1P_BITKIT_16x2_SRAM_3[3]/A_RWL<2> RM_IHPSG13_1P_COLUMN_256_0[6]/RM_IHPSG13_1P_BITKIT_16x2_SRAM_0[1]/A_RWL<8>
+ RM_IHPSG13_1P_COLUMN_256_0[6]/RM_IHPSG13_1P_BITKIT_16x2_SRAM_2[3]/A_LWL<4> RM_IHPSG13_1P_COLUMN_256_0[6]/RM_IHPSG13_1P_BITKIT_16x2_SRAM_0[1]/A_RWL<15>
+ RM_IHPSG13_1P_COLUMN_256_0[6]/RM_IHPSG13_1P_BITKIT_16x2_SRAM_3[0]/A_LWL<12> RM_IHPSG13_1P_COLUMN_256_0[6]/RM_IHPSG13_1P_BITKIT_16x2_SRAM_2[0]/A_RWL<8>
+ RM_IHPSG13_1P_COLUMN_256_0[6]/RM_IHPSG13_1P_BITKIT_16x2_SRAM_0[2]/A_LWL<8> RM_IHPSG13_1P_COLUMN_256_0[6]/RM_IHPSG13_1P_BITKIT_16x2_SRAM_2[3]/A_RWL<3>
+ RM_IHPSG13_1P_COLUMN_256_0[6]/RM_IHPSG13_1P_BITKIT_16x2_SRAM_2[0]/A_RWL<2> RM_IHPSG13_1P_COLUMN_256_0[6]/RM_IHPSG13_1P_BITKIT_16x2_SRAM_3[3]/A_RWL<9>
+ RM_IHPSG13_1P_COLUMN_256_0[6]/RM_IHPSG13_1P_BITKIT_16x2_SRAM_0[2]/A_RWL<6> RM_IHPSG13_1P_COLUMN_256_0[6]/RM_IHPSG13_1P_BITKIT_16x2_SRAM_0[1]/A_RWL<1>
+ RM_IHPSG13_1P_COLUMN_256_0[6]/RM_IHPSG13_1P_BITKIT_16x2_SRAM_2[3]/A_RWL<14> RM_IHPSG13_1P_COLUMN_256_0[6]/RM_IHPSG13_1P_BITKIT_16x2_SRAM_0[2]/A_RWL<12>
+ RM_IHPSG13_1P_COLUMN_256_0[6]/RM_IHPSG13_1P_BITKIT_16x2_SRAM_1[3]/A_RWL<4> RM_IHPSG13_1P_COLUMN_256_0[6]/RM_IHPSG13_1P_BITKIT_16x2_SRAM_2[1]/A_RWL<6>
+ RM_IHPSG13_1P_COLUMN_256_0[6]/RM_IHPSG13_1P_BITKIT_16x2_SRAM_2[0]/A_RWL<1> RM_IHPSG13_1P_COLUMN_256_0[7]/RM_IHPSG13_1P_BITKIT_16x2_SRAM_3[3]/VSS
+ RM_IHPSG13_1P_COLUMN_256_0[7]/RM_IHPSG13_1P_BITKIT_16x2_SRAM_3[3]/VDD RM_IHPSG13_1P_COLUMN_256_0[6]/RM_IHPSG13_1P_BITKIT_16x2_SRAM_0[3]/A_RWL<5>
+ RM_IHPSG13_1P_COLUMN_256_0[6]/RM_IHPSG13_1P_BITKIT_16x2_SRAM_3[2]/A_LWL<6> RM_IHPSG13_1P_COLUMN_256
XRM_IHPSG13_1P_COLUMN_256_0[7] RM_IHPSG13_1P_COLUMN_256_0[7]/RM_IHPSG13_1P_BITKIT_16x2_SRAM_0[0]/A_BLT_BOT<0>
+ RM_IHPSG13_1P_COLUMN_256_0[7]/RM_IHPSG13_1P_BITKIT_16x2_SRAM_3[1]/A_LWL<10> RM_IHPSG13_1P_COLUMN_256_0[7]/RM_IHPSG13_1P_BITKIT_16x2_SRAM_3[0]/A_LWL<13>
+ RM_IHPSG13_1P_COLUMN_256_0[7]/RM_IHPSG13_1P_BITKIT_16x2_SRAM_0[0]/A_BLT_BOT<1> RM_IHPSG13_1P_COLUMN_256_0[7]/RM_IHPSG13_1P_BITKIT_16x2_SRAM_1[2]/A_LWL<9>
+ RM_IHPSG13_1P_COLUMN_256_0[7]/RM_IHPSG13_1P_BITKIT_16x2_SRAM_0[0]/A_BLC_BOT<0> RM_IHPSG13_1P_COLUMN_256_0[7]/RM_IHPSG13_1P_BITKIT_16x2_SRAM_3[2]/A_LWL<8>
+ RM_IHPSG13_1P_BITKIT_16x2_EDGE_LR_0[3]/LWL<11> RM_IHPSG13_1P_BITKIT_16x2_EDGE_LR_1[3]/LWL<5>
+ RM_IHPSG13_1P_COLUMN_256_0[7]/RM_IHPSG13_1P_BITKIT_16x2_SRAM_0[0]/A_BLC_BOT<1> RM_IHPSG13_1P_COLUMN_256_0[7]/RM_IHPSG13_1P_BITKIT_16x2_SRAM_1[3]/A_LWL<0>
+ RM_IHPSG13_1P_COLUMN_256_0[7]/RM_IHPSG13_1P_BITKIT_16x2_SRAM_3[1]/A_LWL<13> RM_IHPSG13_1P_COLUMN_256_0[7]/RM_IHPSG13_1P_BITKIT_16x2_SRAM_1[3]/A_LWL<3>
+ RM_IHPSG13_1P_BITKIT_16x2_EDGE_LR_3[3]/LWL<9> RM_IHPSG13_1P_COLUMN_256_0[7]/RM_IHPSG13_1P_BITKIT_16x2_SRAM_2[3]/A_LWL<1>
+ RM_IHPSG13_1P_BITKIT_16x2_EDGE_LR_0[0]/LWL<1> RM_IHPSG13_1P_COLUMN_256_0[7]/RM_IHPSG13_1P_BITKIT_16x2_SRAM_0[3]/A_LWL<6>
+ RM_IHPSG13_1P_BITKIT_16x2_EDGE_LR_1[3]/LWL<7> RM_IHPSG13_1P_COLUMN_256_0[7]/RM_IHPSG13_1P_BITKIT_16x2_SRAM_3[2]/A_LWL<13>
+ RM_IHPSG13_1P_COLUMN_256_0[7]/RM_IHPSG13_1P_BITKIT_16x2_SRAM_2[3]/A_LWL<2> RM_IHPSG13_1P_COLUMN_256_0[7]/RM_IHPSG13_1P_BITKIT_16x2_SRAM_3[3]/A_LWL<5>
+ RM_IHPSG13_1P_BITKIT_16x2_EDGE_LR_0[2]/LWL<14> RM_IHPSG13_1P_COLUMN_256_0[7]/RM_IHPSG13_1P_BITKIT_16x2_SRAM_0[3]/A_LWL<8>
+ RM_IHPSG13_1P_COLUMN_256_0[7]/RM_IHPSG13_1P_BITKIT_16x2_SRAM_3[3]/A_LWL<11> RM_IHPSG13_1P_BITKIT_16x2_EDGE_LR_2[0]/LWL<12>
+ RM_IHPSG13_1P_BITKIT_16x2_EDGE_LR_2[1]/LWL<10> RM_IHPSG13_1P_BITKIT_16x2_EDGE_LR_0[3]/LWL<7>
+ RM_IHPSG13_1P_COLUMN_256_0[7]/RM_IHPSG13_1P_BITKIT_16x2_SRAM_0[3]/A_LWL<2> RM_IHPSG13_1P_BITKIT_16x2_EDGE_LR_2[0]/LWL<14>
+ RM_IHPSG13_1P_BITKIT_16x2_EDGE_LR_3[0]/LWL<4> RM_IHPSG13_1P_COLUMN_256_0[7]/RM_IHPSG13_1P_BITKIT_16x2_SRAM_3[2]/A_LWL<11>
+ RM_IHPSG13_1P_COLUMN_256_0[7]/RM_IHPSG13_1P_BITKIT_16x2_SRAM_3[2]/A_LWL<14> RM_IHPSG13_1P_COLUMN_256_0[7]/RM_IHPSG13_1P_BITKIT_16x2_SRAM_2[0]/A_LWL<15>
+ RM_IHPSG13_1P_BITKIT_16x2_EDGE_LR_0[0]/LWL<5> RM_IHPSG13_1P_COLUMN_256_0[7]/RM_IHPSG13_1P_BITKIT_16x2_SRAM_2[3]/A_LWL<7>
+ RM_IHPSG13_1P_COLUMN_256_0[7]/RM_IHPSG13_1P_BITKIT_16x2_SRAM_1[3]/A_LWL<9> RM_IHPSG13_1P_COLUMN_256_0[7]/RM_IHPSG13_1P_BITKIT_16x2_SRAM_2[1]/A_LWL<12>
+ RM_IHPSG13_1P_COLUMN_256_0[7]/RM_IHPSG13_1P_BITKIT_16x2_SRAM_0[3]/A_LWL<4> RM_IHPSG13_1P_COLUMN_256_0[7]/RM_IHPSG13_1P_BITKIT_16x2_SRAM_3[3]/A_LWL<13>
+ RM_IHPSG13_1P_BITKIT_16x2_EDGE_LR_2[1]/LWL<12> RM_IHPSG13_1P_BITKIT_16x2_EDGE_LR_0[0]/LWL<2>
+ RM_IHPSG13_1P_BITKIT_16x2_EDGE_LR_0[3]/LWL<14> RM_IHPSG13_1P_BITKIT_16x2_EDGE_LR_2[0]/LWL<10>
+ RM_IHPSG13_1P_BITKIT_16x2_EDGE_LR_1[0]/LWL<3> RM_IHPSG13_1P_BITKIT_16x2_EDGE_LR_2[3]/LWL<8>
+ RM_IHPSG13_1P_BITKIT_16x2_EDGE_LR_0[0]/LWL<6> RM_IHPSG13_1P_COLUMN_256_0[7]/RM_IHPSG13_1P_BITKIT_16x2_SRAM_3[3]/A_LWL<8>
+ RM_IHPSG13_1P_BITKIT_16x2_EDGE_LR_1[0]/LWL<0> RM_IHPSG13_1P_COLUMN_256_0[7]/RM_IHPSG13_1P_BITKIT_16x2_SRAM_0[0]/A_LWL<1>
+ RM_IHPSG13_1P_BITKIT_16x2_EDGE_LR_2[0]/LWL<4> RM_IHPSG13_1P_BITKIT_16x2_EDGE_LR_1[0]/LWL<5>
+ RM_IHPSG13_1P_COLUMN_256_0[7]/RM_IHPSG13_1P_BITKIT_16x2_SRAM_3[3]/A_LWL<14> RM_IHPSG13_1P_COLUMN_256_0[7]/RM_IHPSG13_1P_BITKIT_16x2_SRAM_3[1]/A_LWL<11>
+ RM_IHPSG13_1P_COLUMN_256_0[7]/RM_IHPSG13_1P_BITKIT_16x2_SRAM_2[0]/A_LWL<0> RM_IHPSG13_1P_BITKIT_16x2_EDGE_LR_2[2]/LWL<10>
+ RM_IHPSG13_1P_COLUMN_256_0[7]/RM_IHPSG13_1P_BITKIT_16x2_SRAM_1[3]/A_LWL<5> RM_IHPSG13_1P_COLUMN_256_0[7]/RM_IHPSG13_1P_BITKIT_16x2_SRAM_3[1]/A_LWL<14>
+ RM_IHPSG13_1P_COLUMN_256_0[7]/RM_IHPSG13_1P_BITKIT_16x2_SRAM_0[3]/A_LWL<7> RM_IHPSG13_1P_COLUMN_256_0[7]/RM_IHPSG13_1P_BITKIT_16x2_SRAM_1[2]/A_LWL<8>
+ RM_IHPSG13_1P_COLUMN_256_0[7]/RM_IHPSG13_1P_BITKIT_16x2_SRAM_3[3]/A_LWL<4> RM_IHPSG13_1P_COLUMN_256_0[7]/RM_IHPSG13_1P_BITKIT_16x2_SRAM_2[2]/A_LWL<7>
+ RM_IHPSG13_1P_BITKIT_16x2_EDGE_LR_0[3]/LWL<13> RM_IHPSG13_1P_COLUMN_256_0[7]/RM_IHPSG13_1P_BITKIT_16x2_SRAM_1[0]/A_LWL<10>
+ RM_IHPSG13_1P_BITKIT_16x2_EDGE_LR_2[0]/LWL<2> RM_IHPSG13_1P_BITKIT_16x2_EDGE_LR_1[0]/LWL<6>
+ RM_IHPSG13_1P_BITKIT_16x2_EDGE_LR_2[1]/LWL<14> RM_IHPSG13_1P_BITKIT_16x2_EDGE_LR_3[3]/LWL<8>
+ RM_IHPSG13_1P_BITKIT_16x2_EDGE_LR_0[0]/LWL<8> RM_IHPSG13_1P_BITKIT_16x2_EDGE_LR_0[0]/LWL<0>
+ RM_IHPSG13_1P_BITKIT_16x2_EDGE_LR_2[3]/LWL<6> RM_IHPSG13_1P_COLUMN_256_0[7]/RM_IHPSG13_1P_BITKIT_16x2_SRAM_2[1]/A_LWL<15>
+ RM_IHPSG13_1P_BITKIT_16x2_EDGE_LR_1[3]/LWL<4> RM_IHPSG13_1P_BITKIT_16x2_EDGE_LR_1[0]/LWL<7>
+ RM_IHPSG13_1P_COLUMN_256_0[7]/RM_IHPSG13_1P_BITKIT_16x2_SRAM_2[2]/A_LWL<9> RM_IHPSG13_1P_COLUMN_256_0[7]/RM_IHPSG13_1P_BITKIT_16x2_SRAM_2[2]/A_LWL<12>
+ RM_IHPSG13_1P_BITKIT_16x2_EDGE_LR_0[1]/LWL<0> RM_IHPSG13_1P_COLUMN_256_0[7]/RM_IHPSG13_1P_BITKIT_16x2_SRAM_3[0]/A_LWL<1>
+ RM_IHPSG13_1P_BITKIT_16x2_EDGE_LR_1[0]/LWL<11> RM_IHPSG13_1P_COLUMN_256_0[7]/RM_IHPSG13_1P_BITKIT_16x2_SRAM_2[0]/A_LWL<2>
+ RM_IHPSG13_1P_BITKIT_16x2_EDGE_LR_2[2]/LWL<12> RM_IHPSG13_1P_COLUMN_256_0[7]/RM_IHPSG13_1P_BITKIT_16x2_SRAM_3[0]/A_LWL<14>
+ RM_IHPSG13_1P_COLUMN_256_0[7]/RM_IHPSG13_1P_BITKIT_16x2_SRAM_1[0]/A_LWL<3> RM_IHPSG13_1P_COLUMN_256_0[7]/RM_IHPSG13_1P_BITKIT_16x2_SRAM_0[0]/A_LWL<4>
+ RM_IHPSG13_1P_BITKIT_16x2_EDGE_LR_0[2]/LWL<13> RM_IHPSG13_1P_BITKIT_16x2_EDGE_LR_3[0]/LWL<9>
+ RM_IHPSG13_1P_COLUMN_256_0[7]/RM_IHPSG13_1P_BITKIT_16x2_SRAM_1[3]/A_LWL<8> RM_IHPSG13_1P_COLUMN_256_0[7]/RM_IHPSG13_1P_BITKIT_16x2_SRAM_3[1]/A_LWL<12>
+ RM_IHPSG13_1P_BITKIT_16x2_EDGE_LR_0[0]/LWL<7> RM_IHPSG13_1P_BITKIT_16x2_EDGE_LR_3[3]/LWL<6>
+ RM_IHPSG13_1P_COLUMN_256_0[7]/RM_IHPSG13_1P_BITKIT_16x2_SRAM_1[0]/A_LWL<4> RM_IHPSG13_1P_COLUMN_256_0[7]/RM_IHPSG13_1P_BITKIT_16x2_SRAM_0[0]/A_LWL<2>
+ RM_IHPSG13_1P_BITKIT_16x2_EDGE_LR_2[0]/LWL<15> RM_IHPSG13_1P_BITKIT_16x2_EDGE_LR_2[3]/LWL<10>
+ RM_IHPSG13_1P_BITKIT_16x2_EDGE_LR_1[1]/LWL<0> RM_IHPSG13_1P_COLUMN_256_0[7]/RM_IHPSG13_1P_BITKIT_16x2_SRAM_1[0]/A_LWL<13>
+ RM_IHPSG13_1P_COLUMN_256_0[7]/RM_IHPSG13_1P_BITKIT_16x2_SRAM_1[0]/A_LWL<11> RM_IHPSG13_1P_COLUMN_256_0[7]/RM_IHPSG13_1P_BITKIT_16x2_SRAM_2[3]/A_LWL<10>
+ RM_IHPSG13_1P_COLUMN_256_0[7]/RM_IHPSG13_1P_BITKIT_16x2_SRAM_1[1]/A_LWL<10> RM_IHPSG13_1P_BITKIT_16x2_EDGE_LR_0[1]/LWL<2>
+ RM_IHPSG13_1P_COLUMN_256_0[7]/RM_IHPSG13_1P_BITKIT_16x2_SRAM_3[0]/A_LWL<3> RM_IHPSG13_1P_COLUMN_256_0[7]/RM_IHPSG13_1P_BITKIT_16x2_SRAM_0[3]/A_LWL<1>
+ RM_IHPSG13_1P_BITKIT_16x2_EDGE_LR_2[2]/LWL<14> RM_IHPSG13_1P_COLUMN_256_0[7]/RM_IHPSG13_1P_BITKIT_16x2_SRAM_2[3]/A_LWL<0>
+ RM_IHPSG13_1P_COLUMN_256_0[7]/RM_IHPSG13_1P_BITKIT_16x2_SRAM_1[0]/A_LWL<5> RM_IHPSG13_1P_BITKIT_16x2_EDGE_LR_2[3]/LWL<11>
+ RM_IHPSG13_1P_COLUMN_256_0[7]/RM_IHPSG13_1P_BITKIT_16x2_SRAM_3[3]/A_LWL<6> RM_IHPSG13_1P_COLUMN_256_0[7]/RM_IHPSG13_1P_BITKIT_16x2_SRAM_0[0]/A_LWL<6>
+ RM_IHPSG13_1P_BITKIT_16x2_EDGE_LR_2[0]/LWL<9> RM_IHPSG13_1P_COLUMN_256_0[7]/RM_IHPSG13_1P_BITKIT_16x2_SRAM_2[3]/A_LWL<9>
+ RM_IHPSG13_1P_COLUMN_256_0[7]/RM_IHPSG13_1P_BITKIT_16x2_SRAM_1[0]/A_LWL<14> RM_IHPSG13_1P_BITKIT_16x2_EDGE_LR_1[0]/LWL<13>
+ RM_IHPSG13_1P_COLUMN_256_0[7]/RM_IHPSG13_1P_BITKIT_16x2_SRAM_2[2]/A_LWL<15> RM_IHPSG13_1P_COLUMN_256_0[7]/RM_IHPSG13_1P_BITKIT_16x2_SRAM_1[1]/A_LWL<11>
+ RM_IHPSG13_1P_COLUMN_256_0[7]/RM_IHPSG13_1P_BITKIT_16x2_SRAM_3[0]/A_LWL<4> RM_IHPSG13_1P_BITKIT_16x2_EDGE_LR_2[0]/LWL<8>
+ RM_IHPSG13_1P_COLUMN_256_0[7]/RM_IHPSG13_1P_BITKIT_16x2_SRAM_2[3]/A_LWL<12> RM_IHPSG13_1P_COLUMN_256_0[7]/RM_IHPSG13_1P_BITKIT_16x2_SRAM_2[0]/A_LWL<5>
+ RM_IHPSG13_1P_BITKIT_16x2_EDGE_LR_3[1]/LWL<1> RM_IHPSG13_1P_BITKIT_16x2_EDGE_LR_1[1]/LWL<11>
+ RM_IHPSG13_1P_BITKIT_16x2_EDGE_LR_2[1]/LWL<1> RM_IHPSG13_1P_BITKIT_16x2_EDGE_LR_2[0]/LWL<1>
+ RM_IHPSG13_1P_BITKIT_16x2_EDGE_LR_2[3]/LWL<12> RM_IHPSG13_1P_BITKIT_16x2_EDGE_LR_1[1]/LWL<2>
+ RM_IHPSG13_1P_BITKIT_16x2_EDGE_LR_3[1]/LWL<3> RM_IHPSG13_1P_COLUMN_256_0[7]/RM_IHPSG13_1P_BITKIT_16x2_SRAM_3[3]/A_LWL<1>
+ RM_IHPSG13_1P_COLUMN_256_0[7]/RM_IHPSG13_1P_BITKIT_16x2_SRAM_2[2]/A_LWL<10> RM_IHPSG13_1P_COLUMN_256_0[7]/RM_IHPSG13_1P_BITKIT_16x2_SRAM_3[2]/A_LWL<12>
+ RM_IHPSG13_1P_BITKIT_16x2_EDGE_LR_1[0]/LWL<15> RM_IHPSG13_1P_COLUMN_256_0[7]/RM_IHPSG13_1P_BITKIT_16x2_SRAM_2[0]/A_LWL<6>
+ RM_IHPSG13_1P_BITKIT_16x2_EDGE_LR_2[2]/LWL<11> RM_IHPSG13_1P_BITKIT_16x2_EDGE_LR_2[1]/LWL<15>
+ RM_IHPSG13_1P_COLUMN_256_0[7]/RM_IHPSG13_1P_BITKIT_16x2_SRAM_0[0]/A_LWL<7> RM_IHPSG13_1P_COLUMN_256_0[7]/RM_IHPSG13_1P_BITKIT_16x2_SRAM_1[3]/A_LWL<6>
+ RM_IHPSG13_1P_BITKIT_16x2_EDGE_LR_2[1]/LWL<2> RM_IHPSG13_1P_BITKIT_16x2_EDGE_LR_1[1]/LWL<3>
+ RM_IHPSG13_1P_COLUMN_256_0[7]/RM_IHPSG13_1P_BITKIT_16x2_SRAM_2[3]/A_LWL<3> RM_IHPSG13_1P_BITKIT_16x2_EDGE_LR_3[1]/LWL<4>
+ RM_IHPSG13_1P_COLUMN_256_0[7]/RM_IHPSG13_1P_BITKIT_16x2_SRAM_0[0]/A_LWL<0> RM_IHPSG13_1P_COLUMN_256_0[7]/RM_IHPSG13_1P_BITKIT_16x2_SRAM_1[1]/A_LWL<13>
+ RM_IHPSG13_1P_BITKIT_16x2_EDGE_LR_3[0]/LWL<8> RM_IHPSG13_1P_BITKIT_16x2_EDGE_LR_0[1]/LWL<5>
+ RM_IHPSG13_1P_BITKIT_16x2_EDGE_LR_1[3]/LWL<9> RM_IHPSG13_1P_COLUMN_256_0[7]/RM_IHPSG13_1P_BITKIT_16x2_SRAM_2[0]/A_LWL<7>
+ RM_IHPSG13_1P_COLUMN_256_0[7]/RM_IHPSG13_1P_BITKIT_16x2_SRAM_1[2]/A_LWL<10> RM_IHPSG13_1P_BITKIT_16x2_EDGE_LR_3[0]/LWL<1>
+ RM_IHPSG13_1P_BITKIT_16x2_EDGE_LR_1[1]/LWL<13> RM_IHPSG13_1P_BITKIT_16x2_EDGE_LR_2[0]/LWL<6>
+ RM_IHPSG13_1P_COLUMN_256_0[7]/RM_IHPSG13_1P_BITKIT_16x2_SRAM_1[0]/A_LWL<8> RM_IHPSG13_1P_BITKIT_16x2_EDGE_LR_0[2]/LWL<15>
+ RM_IHPSG13_1P_COLUMN_256_0[7]/RM_IHPSG13_1P_BITKIT_16x2_SRAM_3[3]/A_LWL<15> RM_IHPSG13_1P_BITKIT_16x2_EDGE_LR_0[1]/LWL<4>
+ RM_IHPSG13_1P_BITKIT_16x2_EDGE_LR_2[3]/LWL<14> RM_IHPSG13_1P_COLUMN_256_0[7]/RM_IHPSG13_1P_BITKIT_16x2_SRAM_0[0]/A_LWL<9>
+ RM_IHPSG13_1P_BITKIT_16x2_EDGE_LR_1[1]/LWL<4> RM_IHPSG13_1P_BITKIT_16x2_EDGE_LR_1[0]/LWL<4>
+ RM_IHPSG13_1P_BITKIT_16x2_EDGE_LR_2[3]/LWL<5> RM_IHPSG13_1P_COLUMN_256_0[7]/RM_IHPSG13_1P_BITKIT_16x2_SRAM_2[1]/A_LWL<10>
+ RM_IHPSG13_1P_COLUMN_256_0[7]/RM_IHPSG13_1P_BITKIT_16x2_SRAM_1[1]/A_LWL<14> RM_IHPSG13_1P_BITKIT_16x2_EDGE_LR_0[1]/LWL<6>
+ RM_IHPSG13_1P_COLUMN_256_0[7]/RM_IHPSG13_1P_BITKIT_16x2_SRAM_2[3]/A_LWL<15> RM_IHPSG13_1P_COLUMN_256_0[7]/RM_IHPSG13_1P_BITKIT_16x2_SRAM_2[0]/A_LWL<8>
+ RM_IHPSG13_1P_BITKIT_16x2_EDGE_LR_2[1]/LWL<11> RM_IHPSG13_1P_COLUMN_256_0[7]/RM_IHPSG13_1P_BITKIT_16x2_SRAM_1[2]/A_LWL<11>
+ RM_IHPSG13_1P_COLUMN_256_0[7]/RM_IHPSG13_1P_BITKIT_16x2_SRAM_0[1]/A_LWL<1> RM_IHPSG13_1P_BITKIT_16x2_EDGE_LR_3[0]/LWL<10>
+ RM_IHPSG13_1P_COLUMN_256_0[7]/RM_IHPSG13_1P_BITKIT_16x2_SRAM_1[0]/A_LWL<1> RM_IHPSG13_1P_COLUMN_256_0[7]/RM_IHPSG13_1P_BITKIT_16x2_SRAM_0[3]/A_LWL<3>
+ RM_IHPSG13_1P_BITKIT_16x2_EDGE_LR_1[1]/LWL<5> RM_IHPSG13_1P_COLUMN_256_0[7]/RM_IHPSG13_1P_BITKIT_16x2_SRAM_3[0]/A_LWL<0>
+ RM_IHPSG13_1P_BITKIT_16x2_EDGE_LR_1[2]/LWL<11> RM_IHPSG13_1P_COLUMN_256_0[7]/RM_IHPSG13_1P_BITKIT_16x2_SRAM_3[3]/A_LWL<12>
+ RM_IHPSG13_1P_BITKIT_16x2_EDGE_LR_3[1]/LWL<6> RM_IHPSG13_1P_BITKIT_16x2_EDGE_LR_0[3]/LWL<9>
+ RM_IHPSG13_1P_COLUMN_256_0[7]/RM_IHPSG13_1P_BITKIT_16x2_SRAM_2[1]/A_LWL<0> RM_IHPSG13_1P_BITKIT_16x2_EDGE_LR_0[1]/LWL<7>
+ RM_IHPSG13_1P_BITKIT_16x2_EDGE_LR_2[2]/LWL<15> RM_IHPSG13_1P_COLUMN_256_0[7]/RM_IHPSG13_1P_BITKIT_16x2_SRAM_2[0]/A_LWL<9>
+ RM_IHPSG13_1P_BITKIT_16x2_EDGE_LR_3[0]/LWL<6> RM_IHPSG13_1P_BITKIT_16x2_EDGE_LR_1[1]/LWL<15>
+ RM_IHPSG13_1P_COLUMN_256_0[7]/RM_IHPSG13_1P_BITKIT_16x2_SRAM_0[1]/A_LWL<2> RM_IHPSG13_1P_COLUMN_256_0[7]/RM_IHPSG13_1P_BITKIT_16x2_SRAM_3[2]/A_LWL<15>
+ RM_IHPSG13_1P_BITKIT_16x2_EDGE_LR_0[0]/LWL<4> RM_IHPSG13_1P_BITKIT_16x2_EDGE_LR_3[3]/LWL<5>
+ RM_IHPSG13_1P_COLUMN_256_0[7]/RM_IHPSG13_1P_BITKIT_16x2_SRAM_0[1]/A_LWL<0> RM_IHPSG13_1P_COLUMN_256_0[7]/RM_IHPSG13_1P_BITKIT_16x2_SRAM_2[0]/A_LWL<10>
+ RM_IHPSG13_1P_COLUMN_256_0[7]/RM_IHPSG13_1P_BITKIT_16x2_SRAM_3[0]/A_LWL<9> RM_IHPSG13_1P_COLUMN_256_0[7]/RM_IHPSG13_1P_BITKIT_16x2_SRAM_0[0]/A_LWL<12>
+ RM_IHPSG13_1P_BITKIT_16x2_EDGE_LR_0[0]/LWL<3> RM_IHPSG13_1P_BITKIT_16x2_EDGE_LR_0[3]/LWL<15>
+ RM_IHPSG13_1P_BITKIT_16x2_EDGE_LR_2[0]/LWL<11> RM_IHPSG13_1P_COLUMN_256_0[7]/RM_IHPSG13_1P_BITKIT_16x2_SRAM_1[2]/A_LWL<13>
+ RM_IHPSG13_1P_BITKIT_16x2_EDGE_LR_3[0]/LWL<12> RM_IHPSG13_1P_BITKIT_16x2_EDGE_LR_2[1]/LWL<6>
+ RM_IHPSG13_1P_COLUMN_256_0[7]/RM_IHPSG13_1P_BITKIT_16x2_SRAM_3[0]/A_LWL<6> RM_IHPSG13_1P_BITKIT_16x2_EDGE_LR_1[1]/LWL<7>
+ RM_IHPSG13_1P_BITKIT_16x2_EDGE_LR_1[2]/LWL<13> RM_IHPSG13_1P_BITKIT_16x2_EDGE_LR_0[2]/LWL<0>
+ RM_IHPSG13_1P_COLUMN_256_0[7]/RM_IHPSG13_1P_BITKIT_16x2_SRAM_3[1]/A_LWL<1> RM_IHPSG13_1P_BITKIT_16x2_EDGE_LR_3[1]/LWL<8>
+ RM_IHPSG13_1P_COLUMN_256_0[7]/RM_IHPSG13_1P_BITKIT_16x2_SRAM_2[1]/A_LWL<2> RM_IHPSG13_1P_COLUMN_256_0[7]/RM_IHPSG13_1P_BITKIT_16x2_SRAM_1[1]/A_LWL<3>
+ RM_IHPSG13_1P_COLUMN_256_0[7]/RM_IHPSG13_1P_BITKIT_16x2_SRAM_1[1]/A_LWL<1> RM_IHPSG13_1P_COLUMN_256_0[7]/RM_IHPSG13_1P_BITKIT_16x2_SRAM_1[2]/A_LWL<14>
+ RM_IHPSG13_1P_COLUMN_256_0[7]/RM_IHPSG13_1P_BITKIT_16x2_SRAM_1[0]/A_LWL<12> RM_IHPSG13_1P_COLUMN_256_0[7]/RM_IHPSG13_1P_BITKIT_16x2_SRAM_0[1]/A_LWL<10>
+ RM_IHPSG13_1P_COLUMN_256_0[7]/RM_IHPSG13_1P_BITKIT_16x2_SRAM_0[1]/A_LWL<4> RM_IHPSG13_1P_COLUMN_256_0[7]/RM_IHPSG13_1P_BITKIT_16x2_SRAM_1[3]/A_LWL<4>
+ RM_IHPSG13_1P_COLUMN_256_0[7]/RM_IHPSG13_1P_BITKIT_16x2_SRAM_3[1]/A_LWL<0> RM_IHPSG13_1P_COLUMN_256_0[7]/RM_IHPSG13_1P_BITKIT_16x2_SRAM_3[1]/A_LWL<15>
+ RM_IHPSG13_1P_COLUMN_256_0[7]/RM_IHPSG13_1P_BITKIT_16x2_SRAM_1[3]/A_LWL<11> RM_IHPSG13_1P_BITKIT_16x2_EDGE_LR_3[0]/LWL<2>
+ RM_IHPSG13_1P_BITKIT_16x2_EDGE_LR_3[1]/LWL<10> RM_IHPSG13_1P_BITKIT_16x2_EDGE_LR_2[1]/LWL<5>
+ RM_IHPSG13_1P_COLUMN_256_0[7]/RM_IHPSG13_1P_BITKIT_16x2_SRAM_0[0]/A_LWL<10> RM_IHPSG13_1P_BITKIT_16x2_EDGE_LR_0[3]/LWL<12>
+ RM_IHPSG13_1P_BITKIT_16x2_EDGE_LR_2[0]/LWL<3> RM_IHPSG13_1P_BITKIT_16x2_EDGE_LR_3[1]/LWL<9>
+ RM_IHPSG13_1P_BITKIT_16x2_EDGE_LR_2[3]/LWL<15> RM_IHPSG13_1P_BITKIT_16x2_EDGE_LR_1[2]/LWL<12>
+ RM_IHPSG13_1P_COLUMN_256_0[7]/RM_IHPSG13_1P_BITKIT_16x2_SRAM_2[1]/A_LWL<3> RM_IHPSG13_1P_BITKIT_16x2_EDGE_LR_3[0]/LWL<11>
+ RM_IHPSG13_1P_BITKIT_16x2_EDGE_LR_1[3]/LWL<10> RM_IHPSG13_1P_COLUMN_256_0[7]/RM_IHPSG13_1P_BITKIT_16x2_SRAM_1[1]/A_LWL<4>
+ RM_IHPSG13_1P_COLUMN_256_0[7]/RM_IHPSG13_1P_BITKIT_16x2_SRAM_1[2]/A_LWL<15> RM_IHPSG13_1P_BITKIT_16x2_EDGE_LR_1[2]/LWL<0>
+ RM_IHPSG13_1P_COLUMN_256_0[7]/RM_IHPSG13_1P_BITKIT_16x2_SRAM_1[0]/A_LWL<6> RM_IHPSG13_1P_BITKIT_16x2_EDGE_LR_3[0]/LWL<14>
+ RM_IHPSG13_1P_BITKIT_16x2_EDGE_LR_2[1]/LWL<8> RM_IHPSG13_1P_BITKIT_16x2_EDGE_LR_2[3]/LWL<7>
+ RM_IHPSG13_1P_BITKIT_16x2_EDGE_LR_3[2]/LWL<1> RM_IHPSG13_1P_COLUMN_256_0[7]/RM_IHPSG13_1P_BITKIT_16x2_SRAM_0[1]/A_LWL<3>
+ RM_IHPSG13_1P_BITKIT_16x2_EDGE_LR_1[1]/LWL<9> RM_IHPSG13_1P_BITKIT_16x2_EDGE_LR_1[2]/LWL<15>
+ RM_IHPSG13_1P_BITKIT_16x2_EDGE_LR_3[1]/LWL<11> RM_IHPSG13_1P_COLUMN_256_0[7]/RM_IHPSG13_1P_BITKIT_16x2_SRAM_2[0]/A_LWL<3>
+ RM_IHPSG13_1P_BITKIT_16x2_EDGE_LR_0[2]/LWL<2> RM_IHPSG13_1P_COLUMN_256_0[7]/RM_IHPSG13_1P_BITKIT_16x2_SRAM_3[1]/A_LWL<3>
+ RM_IHPSG13_1P_COLUMN_256_0[7]/RM_IHPSG13_1P_BITKIT_16x2_SRAM_0[2]/A_LWL<9> RM_IHPSG13_1P_COLUMN_256_0[7]/RM_IHPSG13_1P_BITKIT_16x2_SRAM_2[0]/A_LWL<13>
+ RM_IHPSG13_1P_COLUMN_256_0[7]/RM_IHPSG13_1P_BITKIT_16x2_SRAM_3[3]/A_LWL<2> RM_IHPSG13_1P_BITKIT_16x2_EDGE_LR_0[1]/LWL<3>
+ RM_IHPSG13_1P_BITKIT_16x2_EDGE_LR_0[1]/LWL<9> RM_IHPSG13_1P_BITKIT_16x2_EDGE_LR_1[3]/LWL<12>
+ RM_IHPSG13_1P_COLUMN_256_0[7]/RM_IHPSG13_1P_BITKIT_16x2_SRAM_2[3]/A_LWL<5> RM_IHPSG13_1P_COLUMN_256_0[7]/RM_IHPSG13_1P_BITKIT_16x2_SRAM_2[2]/A_LWL<8>
+ RM_IHPSG13_1P_COLUMN_256_0[7]/RM_IHPSG13_1P_BITKIT_16x2_SRAM_0[0]/A_LWL<15> RM_IHPSG13_1P_BITKIT_16x2_EDGE_LR_1[0]/LWL<9>
+ RM_IHPSG13_1P_COLUMN_256_0[7]/RM_IHPSG13_1P_BITKIT_16x2_SRAM_1[1]/A_LWL<5> RM_IHPSG13_1P_BITKIT_16x2_EDGE_LR_2[2]/LWL<0>
+ RM_IHPSG13_1P_COLUMN_256_0[7]/RM_IHPSG13_1P_BITKIT_16x2_SRAM_1[1]/A_LWL<15> RM_IHPSG13_1P_COLUMN_256_0[7]/RM_IHPSG13_1P_BITKIT_16x2_SRAM_0[1]/A_LWL<12>
+ RM_IHPSG13_1P_COLUMN_256_0[7]/RM_IHPSG13_1P_BITKIT_16x2_SRAM_0[1]/A_LWL<6> RM_IHPSG13_1P_COLUMN_256_0[7]/RM_IHPSG13_1P_BITKIT_16x2_SRAM_3[0]/A_LWL<15>
+ RM_IHPSG13_1P_BITKIT_16x2_EDGE_LR_2[1]/LWL<9> RM_IHPSG13_1P_COLUMN_256_0[7]/RM_IHPSG13_1P_BITKIT_16x2_SRAM_1[3]/A_LWL<13>
+ RM_IHPSG13_1P_BITKIT_16x2_EDGE_LR_3[1]/LWL<5> RM_IHPSG13_1P_BITKIT_16x2_EDGE_LR_3[1]/LWL<12>
+ RM_IHPSG13_1P_BITKIT_16x2_EDGE_LR_2[0]/LWL<5> RM_IHPSG13_1P_COLUMN_256_0[7]/RM_IHPSG13_1P_BITKIT_16x2_SRAM_3[1]/A_LWL<4>
+ RM_IHPSG13_1P_BITKIT_16x2_EDGE_LR_1[3]/LWL<13> RM_IHPSG13_1P_BITKIT_16x2_EDGE_LR_1[1]/LWL<12>
+ RM_IHPSG13_1P_COLUMN_256_0[7]/RM_IHPSG13_1P_BITKIT_16x2_SRAM_2[1]/A_LWL<5> RM_IHPSG13_1P_BITKIT_16x2_EDGE_LR_0[3]/LWL<10>
+ RM_IHPSG13_1P_COLUMN_256_0[7]/RM_IHPSG13_1P_BITKIT_16x2_SRAM_1[1]/A_LWL<12> RM_IHPSG13_1P_BITKIT_16x2_EDGE_LR_1[2]/LWL<10>
+ RM_IHPSG13_1P_COLUMN_256_0[7]/RM_IHPSG13_1P_BITKIT_16x2_SRAM_1[1]/A_LWL<6> RM_IHPSG13_1P_BITKIT_16x2_EDGE_LR_2[2]/LWL<1>
+ RM_IHPSG13_1P_COLUMN_256_0[7]/RM_IHPSG13_1P_BITKIT_16x2_SRAM_0[1]/A_LWL<13> RM_IHPSG13_1P_BITKIT_16x2_EDGE_LR_3[3]/LWL<7>
+ RM_IHPSG13_1P_COLUMN_256_0[7]/RM_IHPSG13_1P_BITKIT_16x2_SRAM_0[1]/A_LWL<7> RM_IHPSG13_1P_BITKIT_16x2_EDGE_LR_1[2]/LWL<2>
+ RM_IHPSG13_1P_BITKIT_16x2_EDGE_LR_3[1]/LWL<2> RM_IHPSG13_1P_BITKIT_16x2_EDGE_LR_3[2]/LWL<0>
+ RM_IHPSG13_1P_BITKIT_16x2_EDGE_LR_3[0]/LWL<15> RM_IHPSG13_1P_COLUMN_256_0[7]/RM_IHPSG13_1P_BITKIT_16x2_SRAM_3[2]/A_LWL<9>
+ RM_IHPSG13_1P_COLUMN_256_0[7]/RM_IHPSG13_1P_BITKIT_16x2_SRAM_1[3]/A_LWL<14> RM_IHPSG13_1P_BITKIT_16x2_EDGE_LR_2[1]/LWL<0>
+ RM_IHPSG13_1P_BITKIT_16x2_EDGE_LR_2[1]/LWL<3> RM_IHPSG13_1P_COLUMN_256_0[7]/RM_IHPSG13_1P_BITKIT_16x2_SRAM_0[0]/A_LWL<3>
+ RM_IHPSG13_1P_BITKIT_16x2_EDGE_LR_3[2]/LWL<3> RM_IHPSG13_1P_COLUMN_256_0[7]/RM_IHPSG13_1P_BITKIT_16x2_SRAM_0[2]/A_LWL<10>
+ RM_IHPSG13_1P_COLUMN_256_0[7]/RM_IHPSG13_1P_BITKIT_16x2_SRAM_1[3]/A_LWL<2> RM_IHPSG13_1P_BITKIT_16x2_EDGE_LR_0[2]/LWL<4>
+ RM_IHPSG13_1P_BITKIT_16x2_EDGE_LR_0[0]/LWL<9> RM_IHPSG13_1P_COLUMN_256_0[7]/RM_IHPSG13_1P_BITKIT_16x2_SRAM_2[1]/A_LWL<6>
+ RM_IHPSG13_1P_BITKIT_16x2_EDGE_LR_3[2]/LWL<10> RM_IHPSG13_1P_COLUMN_256_0[7]/RM_IHPSG13_1P_BITKIT_16x2_SRAM_2[3]/A_LWL<11>
+ RM_IHPSG13_1P_BITKIT_16x2_EDGE_LR_2[2]/LWL<2> RM_IHPSG13_1P_COLUMN_256_0[7]/RM_IHPSG13_1P_BITKIT_16x2_SRAM_1[0]/A_LWL<15>
+ RM_IHPSG13_1P_COLUMN_256_0[7]/RM_IHPSG13_1P_BITKIT_16x2_SRAM_0[3]/A_LWL<0> RM_IHPSG13_1P_COLUMN_256_0[7]/RM_IHPSG13_1P_BITKIT_16x2_SRAM_2[3]/A_LWL<14>
+ RM_IHPSG13_1P_BITKIT_16x2_EDGE_LR_1[2]/LWL<3> RM_IHPSG13_1P_COLUMN_256_0[7]/RM_IHPSG13_1P_BITKIT_16x2_SRAM_0[0]/A_LWL<5>
+ RM_IHPSG13_1P_COLUMN_256_0[7]/RM_IHPSG13_1P_BITKIT_16x2_SRAM_1[3]/A_LWL<15> RM_IHPSG13_1P_BITKIT_16x2_EDGE_LR_3[0]/LWL<5>
+ RM_IHPSG13_1P_COLUMN_256_0[7]/RM_IHPSG13_1P_BITKIT_16x2_SRAM_2[1]/A_LWL<13> RM_IHPSG13_1P_COLUMN_256_0[7]/RM_IHPSG13_1P_BITKIT_16x2_SRAM_0[3]/A_LWL<9>
+ RM_IHPSG13_1P_BITKIT_16x2_EDGE_LR_0[2]/LWL<3> RM_IHPSG13_1P_COLUMN_256_0[7]/RM_IHPSG13_1P_BITKIT_16x2_SRAM_3[3]/A_LWL<7>
+ RM_IHPSG13_1P_COLUMN_256_0[7]/RM_IHPSG13_1P_BITKIT_16x2_SRAM_2[0]/A_LWL<4> RM_IHPSG13_1P_BITKIT_16x2_EDGE_LR_3[1]/LWL<14>
+ RM_IHPSG13_1P_BITKIT_16x2_EDGE_LR_0[2]/LWL<5> RM_IHPSG13_1P_COLUMN_256_0[7]/RM_IHPSG13_1P_BITKIT_16x2_SRAM_2[3]/A_LWL<8>
+ RM_IHPSG13_1P_COLUMN_256_0[7]/RM_IHPSG13_1P_BITKIT_16x2_SRAM_3[1]/A_LWL<6> RM_IHPSG13_1P_BITKIT_16x2_EDGE_LR_1[0]/LWL<12>
+ RM_IHPSG13_1P_BITKIT_16x2_EDGE_LR_1[3]/LWL<15> RM_IHPSG13_1P_BITKIT_16x2_EDGE_LR_3[2]/LWL<11>
+ RM_IHPSG13_1P_COLUMN_256_0[7]/RM_IHPSG13_1P_BITKIT_16x2_SRAM_2[1]/A_LWL<7> RM_IHPSG13_1P_BITKIT_16x2_EDGE_LR_1[0]/LWL<14>
+ RM_IHPSG13_1P_BITKIT_16x2_EDGE_LR_2[3]/LWL<13> RM_IHPSG13_1P_COLUMN_256_0[7]/RM_IHPSG13_1P_BITKIT_16x2_SRAM_0[2]/A_LWL<0>
+ RM_IHPSG13_1P_BITKIT_16x2_EDGE_LR_1[1]/LWL<10> RM_IHPSG13_1P_COLUMN_256_0[7]/RM_IHPSG13_1P_BITKIT_16x2_SRAM_1[1]/A_LWL<8>
+ RM_IHPSG13_1P_COLUMN_256_0[7]/RM_IHPSG13_1P_BITKIT_16x2_SRAM_0[1]/A_LWL<15> RM_IHPSG13_1P_COLUMN_256_0[7]/RM_IHPSG13_1P_BITKIT_16x2_SRAM_0[1]/A_LWL<9>
+ RM_IHPSG13_1P_BITKIT_16x2_EDGE_LR_1[2]/LWL<4> RM_IHPSG13_1P_BITKIT_16x2_EDGE_LR_3[1]/LWL<0>
+ RM_IHPSG13_1P_BITKIT_16x2_EDGE_LR_2[1]/LWL<7> RM_IHPSG13_1P_BITKIT_16x2_EDGE_LR_2[0]/LWL<0>
+ RM_IHPSG13_1P_BITKIT_16x2_EDGE_LR_3[2]/LWL<5> RM_IHPSG13_1P_COLUMN_256_0[7]/RM_IHPSG13_1P_BITKIT_16x2_SRAM_0[2]/A_LWL<12>
+ RM_IHPSG13_1P_BITKIT_16x2_EDGE_LR_0[0]/LWL<11> RM_IHPSG13_1P_COLUMN_256_0[7]/RM_IHPSG13_1P_BITKIT_16x2_SRAM_1[3]/A_LWL<1>
+ RM_IHPSG13_1P_COLUMN_256_0[7]/RM_IHPSG13_1P_BITKIT_16x2_SRAM_3[1]/A_LWL<2> RM_IHPSG13_1P_COLUMN_256_0[7]/RM_IHPSG13_1P_BITKIT_16x2_SRAM_1[2]/A_LWL<12>
+ RM_IHPSG13_1P_COLUMN_256_0[7]/RM_IHPSG13_1P_BITKIT_16x2_SRAM_1[2]/A_LWL<0> RM_IHPSG13_1P_COLUMN_256_0[7]/RM_IHPSG13_1P_BITKIT_16x2_SRAM_3[3]/A_LWL<0>
+ RM_IHPSG13_1P_BITKIT_16x2_EDGE_LR_3[2]/LWL<12> RM_IHPSG13_1P_COLUMN_256_0[7]/RM_IHPSG13_1P_BITKIT_16x2_SRAM_2[1]/A_LWL<8>
+ RM_IHPSG13_1P_COLUMN_256_0[7]/RM_IHPSG13_1P_BITKIT_16x2_SRAM_2[2]/A_LWL<11> RM_IHPSG13_1P_COLUMN_256_0[7]/RM_IHPSG13_1P_BITKIT_16x2_SRAM_0[2]/A_LWL<1>
+ RM_IHPSG13_1P_BITKIT_16x2_EDGE_LR_3[2]/LWL<2> RM_IHPSG13_1P_COLUMN_256_0[7]/RM_IHPSG13_1P_BITKIT_16x2_SRAM_3[0]/A_LWL<5>
+ RM_IHPSG13_1P_BITKIT_16x2_EDGE_LR_3[1]/LWL<15> RM_IHPSG13_1P_COLUMN_256_0[7]/RM_IHPSG13_1P_BITKIT_16x2_SRAM_3[3]/A_LWL<9>
+ RM_IHPSG13_1P_COLUMN_256_0[7]/RM_IHPSG13_1P_BITKIT_16x2_SRAM_2[2]/A_LWL<14> RM_IHPSG13_1P_BITKIT_16x2_EDGE_LR_2[2]/LWL<3>
+ RM_IHPSG13_1P_BITKIT_16x2_EDGE_LR_1[2]/LWL<5> RM_IHPSG13_1P_COLUMN_256_0[7]/RM_IHPSG13_1P_BITKIT_16x2_SRAM_1[3]/A_LWL<7>
+ RM_IHPSG13_1P_BITKIT_16x2_EDGE_LR_3[2]/LWL<6> RM_IHPSG13_1P_COLUMN_256_0[7]/RM_IHPSG13_1P_BITKIT_16x2_SRAM_0[2]/A_LWL<13>
+ RM_IHPSG13_1P_COLUMN_256_0[7]/RM_IHPSG13_1P_BITKIT_16x2_SRAM_3[2]/A_LWL<7> RM_IHPSG13_1P_COLUMN_256_0[7]/RM_IHPSG13_1P_BITKIT_16x2_SRAM_2[2]/A_LWL<0>
+ RM_IHPSG13_1P_BITKIT_16x2_EDGE_LR_0[0]/LWL<12> RM_IHPSG13_1P_BITKIT_16x2_EDGE_LR_0[2]/LWL<7>
+ RM_IHPSG13_1P_COLUMN_256_0[7]/RM_IHPSG13_1P_BITKIT_16x2_SRAM_0[3]/A_LWL<10> RM_IHPSG13_1P_COLUMN_256_0[7]/RM_IHPSG13_1P_BITKIT_16x2_SRAM_1[2]/A_LWL<1>
+ RM_IHPSG13_1P_BITKIT_16x2_EDGE_LR_2[2]/LWL<13> RM_IHPSG13_1P_COLUMN_256_0[7]/RM_IHPSG13_1P_BITKIT_16x2_SRAM_2[1]/A_LWL<9>
+ RM_IHPSG13_1P_BITKIT_16x2_EDGE_LR_1[0]/LWL<10> RM_IHPSG13_1P_COLUMN_256_0[7]/RM_IHPSG13_1P_BITKIT_16x2_SRAM_0[2]/A_LWL<2>
+ RM_IHPSG13_1P_BITKIT_16x2_EDGE_LR_1[3]/LWL<8> RM_IHPSG13_1P_BITKIT_16x2_EDGE_LR_2[2]/LWL<5>
+ RM_IHPSG13_1P_BITKIT_16x2_EDGE_LR_3[3]/LWL<10> RM_IHPSG13_1P_COLUMN_256_0[7]/RM_IHPSG13_1P_BITKIT_16x2_SRAM_0[1]/A_LWL<5>
+ RM_IHPSG13_1P_COLUMN_256_0[7]/RM_IHPSG13_1P_BITKIT_16x2_SRAM_0[0]/A_LWL<8> RM_IHPSG13_1P_BITKIT_16x2_EDGE_LR_3[1]/LWL<7>
+ RM_IHPSG13_1P_COLUMN_256_0[7]/RM_IHPSG13_1P_BITKIT_16x2_SRAM_2[2]/A_LWL<13> RM_IHPSG13_1P_BITKIT_16x2_EDGE_LR_3[0]/LWL<0>
+ RM_IHPSG13_1P_COLUMN_256_0[7]/RM_IHPSG13_1P_BITKIT_16x2_SRAM_2[1]/A_LWL<4> RM_IHPSG13_1P_BITKIT_16x2_EDGE_LR_2[0]/LWL<7>
+ RM_IHPSG13_1P_COLUMN_256_0[7]/RM_IHPSG13_1P_BITKIT_16x2_SRAM_3[2]/A_LWL<0> RM_IHPSG13_1P_BITKIT_16x2_EDGE_LR_3[2]/LWL<7>
+ RM_IHPSG13_1P_COLUMN_256_0[7]/RM_IHPSG13_1P_BITKIT_16x2_SRAM_1[1]/A_LWL<2> RM_IHPSG13_1P_BITKIT_16x2_EDGE_LR_0[0]/LWL<13>
+ RM_IHPSG13_1P_BITKIT_16x2_EDGE_LR_1[1]/LWL<14> RM_IHPSG13_1P_COLUMN_256_0[7]/RM_IHPSG13_1P_BITKIT_16x2_SRAM_2[2]/A_LWL<1>
+ RM_IHPSG13_1P_COLUMN_256_0[7]/RM_IHPSG13_1P_BITKIT_16x2_SRAM_3[1]/A_LWL<9> RM_IHPSG13_1P_COLUMN_256_0[7]/RM_IHPSG13_1P_BITKIT_16x2_SRAM_3[0]/A_LWL<2>
+ RM_IHPSG13_1P_BITKIT_16x2_EDGE_LR_2[3]/LWL<4> RM_IHPSG13_1P_COLUMN_256_0[7]/RM_IHPSG13_1P_BITKIT_16x2_SRAM_0[2]/A_LWL<11>
+ RM_IHPSG13_1P_COLUMN_256_0[7]/RM_IHPSG13_1P_BITKIT_16x2_SRAM_0[3]/A_LWL<11> RM_IHPSG13_1P_COLUMN_256_0[7]/RM_IHPSG13_1P_BITKIT_16x2_SRAM_1[2]/A_LWL<2>
+ RM_IHPSG13_1P_BITKIT_16x2_EDGE_LR_3[2]/LWL<14> RM_IHPSG13_1P_COLUMN_256_0[7]/RM_IHPSG13_1P_BITKIT_16x2_SRAM_2[1]/A_LWL<11>
+ RM_IHPSG13_1P_BITKIT_16x2_EDGE_LR_0[1]/LWL<10> RM_IHPSG13_1P_COLUMN_256_0[7]/RM_IHPSG13_1P_BITKIT_16x2_SRAM_0[2]/A_LWL<3>
+ RM_IHPSG13_1P_COLUMN_256_0[7]/RM_IHPSG13_1P_BITKIT_16x2_SRAM_0[2]/A_LWL<14> RM_IHPSG13_1P_BITKIT_16x2_EDGE_LR_2[2]/LWL<6>
+ RM_IHPSG13_1P_BITKIT_16x2_EDGE_LR_3[3]/LWL<11> RM_IHPSG13_1P_COLUMN_256_0[7]/RM_IHPSG13_1P_BITKIT_16x2_SRAM_2[1]/A_LWL<14>
+ RM_IHPSG13_1P_BITKIT_16x2_EDGE_LR_1[2]/LWL<7> RM_IHPSG13_1P_BITKIT_16x2_EDGE_LR_0[3]/LWL<0>
+ RM_IHPSG13_1P_COLUMN_256_0[7]/RM_IHPSG13_1P_BITKIT_16x2_SRAM_1[0]/A_LWL<0> RM_IHPSG13_1P_BITKIT_16x2_EDGE_LR_3[2]/LWL<8>
+ RM_IHPSG13_1P_COLUMN_256_0[7]/RM_IHPSG13_1P_BITKIT_16x2_SRAM_3[2]/A_LWL<1> RM_IHPSG13_1P_COLUMN_256_0[7]/RM_IHPSG13_1P_BITKIT_16x2_SRAM_0[2]/A_LWL<15>
+ RM_IHPSG13_1P_COLUMN_256_0[7]/RM_IHPSG13_1P_BITKIT_16x2_SRAM_1[3]/A_LWL<12> RM_IHPSG13_1P_COLUMN_256_0[7]/RM_IHPSG13_1P_BITKIT_16x2_SRAM_3[1]/A_LWL<7>
+ RM_IHPSG13_1P_BITKIT_16x2_EDGE_LR_0[2]/LWL<9> RM_IHPSG13_1P_BITKIT_16x2_EDGE_LR_0[0]/LWL<14>
+ RM_IHPSG13_1P_COLUMN_256_0[7]/RM_IHPSG13_1P_BITKIT_16x2_SRAM_2[2]/A_LWL<2> RM_IHPSG13_1P_BITKIT_16x2_EDGE_LR_3[2]/LWL<13>
+ RM_IHPSG13_1P_COLUMN_256_0[7]/RM_IHPSG13_1P_BITKIT_16x2_SRAM_1[0]/A_LWL<9> RM_IHPSG13_1P_COLUMN_256_0[7]/RM_IHPSG13_1P_BITKIT_16x2_SRAM_0[3]/A_LWL<12>
+ RM_IHPSG13_1P_COLUMN_256_0[7]/RM_IHPSG13_1P_BITKIT_16x2_SRAM_1[2]/A_LWL<3> RM_IHPSG13_1P_BITKIT_16x2_EDGE_LR_2[1]/LWL<13>
+ RM_IHPSG13_1P_COLUMN_256_0[7]/RM_IHPSG13_1P_BITKIT_16x2_SRAM_3[1]/A_LWL<5> RM_IHPSG13_1P_BITKIT_16x2_EDGE_LR_0[0]/LWL<10>
+ RM_IHPSG13_1P_BITKIT_16x2_EDGE_LR_0[3]/LWL<8> RM_IHPSG13_1P_BITKIT_16x2_EDGE_LR_3[2]/LWL<15>
+ RM_IHPSG13_1P_COLUMN_256_0[7]/RM_IHPSG13_1P_BITKIT_16x2_SRAM_3[0]/A_LWL<8> RM_IHPSG13_1P_BITKIT_16x2_EDGE_LR_0[1]/LWL<11>
+ RM_IHPSG13_1P_BITKIT_16x2_EDGE_LR_2[3]/LWL<3> RM_IHPSG13_1P_COLUMN_256_0[7]/RM_IHPSG13_1P_BITKIT_16x2_SRAM_0[2]/A_LWL<4>
+ RM_IHPSG13_1P_BITKIT_16x2_EDGE_LR_2[2]/LWL<7> RM_IHPSG13_1P_BITKIT_16x2_EDGE_LR_3[3]/LWL<12>
+ RM_IHPSG13_1P_BITKIT_16x2_EDGE_LR_3[0]/LWL<7> RM_IHPSG13_1P_BITKIT_16x2_EDGE_LR_3[3]/LWL<0>
+ RM_IHPSG13_1P_BITKIT_16x2_EDGE_LR_1[2]/LWL<8> RM_IHPSG13_1P_BITKIT_16x2_EDGE_LR_1[3]/LWL<6>
+ RM_IHPSG13_1P_BITKIT_16x2_EDGE_LR_1[2]/LWL<1> RM_IHPSG13_1P_BITKIT_16x2_EDGE_LR_0[3]/LWL<1>
+ RM_IHPSG13_1P_COLUMN_256_0[7]/RM_IHPSG13_1P_BITKIT_16x2_SRAM_3[2]/A_LWL<2> RM_IHPSG13_1P_BITKIT_16x2_EDGE_LR_3[2]/LWL<9>
+ RM_IHPSG13_1P_COLUMN_256_0[7]/RM_IHPSG13_1P_BITKIT_16x2_SRAM_1[0]/A_LWL<2> RM_IHPSG13_1P_COLUMN_256_0[7]/RM_IHPSG13_1P_BITKIT_16x2_SRAM_2[2]/A_LWL<3>
+ RM_IHPSG13_1P_BITKIT_16x2_EDGE_LR_0[0]/LWL<15> RM_IHPSG13_1P_COLUMN_256_0[7]/RM_IHPSG13_1P_BITKIT_16x2_SRAM_0[1]/A_LWL<11>
+ RM_IHPSG13_1P_BITKIT_16x2_EDGE_LR_2[2]/LWL<4> RM_IHPSG13_1P_COLUMN_256_0[7]/RM_IHPSG13_1P_BITKIT_16x2_SRAM_0[3]/A_LWL<13>
+ RM_IHPSG13_1P_COLUMN_256_0[7]/RM_IHPSG13_1P_BITKIT_16x2_SRAM_1[2]/A_LWL<4> RM_IHPSG13_1P_COLUMN_256_0[7]/RM_IHPSG13_1P_BITKIT_16x2_SRAM_2[0]/A_LWL<11>
+ RM_IHPSG13_1P_BITKIT_16x2_EDGE_LR_0[1]/LWL<12> RM_IHPSG13_1P_COLUMN_256_0[7]/RM_IHPSG13_1P_BITKIT_16x2_SRAM_3[3]/A_LWL<10>
+ RM_IHPSG13_1P_COLUMN_256_0[7]/RM_IHPSG13_1P_BITKIT_16x2_SRAM_2[0]/A_LWL<1> RM_IHPSG13_1P_COLUMN_256_0[7]/RM_IHPSG13_1P_BITKIT_16x2_SRAM_0[1]/A_LWL<8>
+ RM_IHPSG13_1P_COLUMN_256_0[7]/RM_IHPSG13_1P_BITKIT_16x2_SRAM_0[1]/A_LWL<14> RM_IHPSG13_1P_COLUMN_256_0[7]/RM_IHPSG13_1P_BITKIT_16x2_SRAM_0[2]/A_LWL<5>
+ RM_IHPSG13_1P_BITKIT_16x2_EDGE_LR_1[3]/LWL<0> RM_IHPSG13_1P_COLUMN_256_0[7]/RM_IHPSG13_1P_BITKIT_16x2_SRAM_2[3]/A_LWL<13>
+ RM_IHPSG13_1P_BITKIT_16x2_EDGE_LR_2[2]/LWL<8> RM_IHPSG13_1P_BITKIT_16x2_EDGE_LR_3[3]/LWL<13>
+ RM_IHPSG13_1P_COLUMN_256_0[7]/RM_IHPSG13_1P_BITKIT_16x2_SRAM_2[0]/A_LWL<14> RM_IHPSG13_1P_BITKIT_16x2_EDGE_LR_3[3]/LWL<1>
+ RM_IHPSG13_1P_BITKIT_16x2_EDGE_LR_1[2]/LWL<9> RM_IHPSG13_1P_COLUMN_256_0[7]/RM_IHPSG13_1P_BITKIT_16x2_SRAM_1[1]/A_LWL<7>
+ RM_IHPSG13_1P_BITKIT_16x2_EDGE_LR_1[2]/LWL<14> RM_IHPSG13_1P_BITKIT_16x2_EDGE_LR_0[3]/LWL<2>
+ RM_IHPSG13_1P_COLUMN_256_0[7]/RM_IHPSG13_1P_BITKIT_16x2_SRAM_3[2]/A_LWL<3> RM_IHPSG13_1P_COLUMN_256_0[7]/RM_IHPSG13_1P_BITKIT_16x2_SRAM_3[0]/A_LWL<7>
+ RM_IHPSG13_1P_COLUMN_256_0[7]/RM_IHPSG13_1P_BITKIT_16x2_SRAM_2[2]/A_LWL<4> RM_IHPSG13_1P_BITKIT_16x2_EDGE_LR_3[1]/LWL<13>
+ RM_IHPSG13_1P_COLUMN_256_0[7]/RM_IHPSG13_1P_BITKIT_16x2_SRAM_0[3]/A_LWL<14> RM_IHPSG13_1P_BITKIT_16x2_EDGE_LR_2[0]/LWL<13>
+ RM_IHPSG13_1P_COLUMN_256_0[7]/RM_IHPSG13_1P_BITKIT_16x2_SRAM_1[2]/A_LWL<5> RM_IHPSG13_1P_BITKIT_16x2_EDGE_LR_2[3]/LWL<0>
+ RM_IHPSG13_1P_BITKIT_16x2_EDGE_LR_0[2]/LWL<8> RM_IHPSG13_1P_BITKIT_16x2_EDGE_LR_0[1]/LWL<13>
+ RM_IHPSG13_1P_COLUMN_256_0[7]/RM_IHPSG13_1P_BITKIT_16x2_SRAM_3[0]/A_LWL<10> RM_IHPSG13_1P_BITKIT_16x2_EDGE_LR_1[1]/LWL<8>
+ RM_IHPSG13_1P_COLUMN_256_0[7]/RM_IHPSG13_1P_BITKIT_16x2_SRAM_0[2]/A_LWL<6> RM_IHPSG13_1P_BITKIT_16x2_EDGE_LR_1[3]/LWL<1>
+ RM_IHPSG13_1P_BITKIT_16x2_EDGE_LR_2[2]/LWL<9> RM_IHPSG13_1P_BITKIT_16x2_EDGE_LR_0[3]/LWL<6>
+ RM_IHPSG13_1P_BITKIT_16x2_EDGE_LR_3[3]/LWL<14> RM_IHPSG13_1P_BITKIT_16x2_EDGE_LR_0[2]/LWL<1>
+ RM_IHPSG13_1P_COLUMN_256_0[7]/RM_IHPSG13_1P_BITKIT_16x2_SRAM_1[1]/A_LWL<0> RM_IHPSG13_1P_BITKIT_16x2_EDGE_LR_0[2]/LWL<10>
+ RM_IHPSG13_1P_BITKIT_16x2_EDGE_LR_3[3]/LWL<2> RM_IHPSG13_1P_BITKIT_16x2_EDGE_LR_1[2]/LWL<6>
+ RM_IHPSG13_1P_BITKIT_16x2_EDGE_LR_1[1]/LWL<1> RM_IHPSG13_1P_BITKIT_16x2_EDGE_LR_0[3]/LWL<3>
+ RM_IHPSG13_1P_COLUMN_256_0[7]/RM_IHPSG13_1P_BITKIT_16x2_SRAM_3[2]/A_LWL<4> RM_IHPSG13_1P_COLUMN_256_0[7]/RM_IHPSG13_1P_BITKIT_16x2_SRAM_1[1]/A_LWL<9>
+ RM_IHPSG13_1P_BITKIT_16x2_EDGE_LR_3[2]/LWL<4> RM_IHPSG13_1P_BITKIT_16x2_EDGE_LR_3[0]/LWL<3>
+ RM_IHPSG13_1P_COLUMN_256_0[7]/RM_IHPSG13_1P_BITKIT_16x2_SRAM_2[2]/A_LWL<5> RM_IHPSG13_1P_COLUMN_256_0[7]/RM_IHPSG13_1P_BITKIT_16x2_SRAM_3[1]/A_LWL<8>
+ RM_IHPSG13_1P_COLUMN_256_0[7]/RM_IHPSG13_1P_BITKIT_16x2_SRAM_0[0]/A_LWL<11> RM_IHPSG13_1P_BITKIT_16x2_EDGE_LR_2[1]/LWL<4>
+ RM_IHPSG13_1P_COLUMN_256_0[7]/RM_IHPSG13_1P_BITKIT_16x2_SRAM_0[3]/A_LWL<15> RM_IHPSG13_1P_COLUMN_256_0[7]/RM_IHPSG13_1P_BITKIT_16x2_SRAM_1[3]/A_LWL<10>
+ RM_IHPSG13_1P_COLUMN_256_0[7]/RM_IHPSG13_1P_BITKIT_16x2_SRAM_1[2]/A_LWL<6> RM_IHPSG13_1P_BITKIT_16x2_EDGE_LR_2[3]/LWL<1>
+ RM_IHPSG13_1P_BITKIT_16x2_EDGE_LR_0[1]/LWL<14> RM_IHPSG13_1P_COLUMN_256_0[7]/RM_IHPSG13_1P_BITKIT_16x2_SRAM_3[2]/A_LWL<10>
+ RM_IHPSG13_1P_COLUMN_256_0[7]/RM_IHPSG13_1P_BITKIT_16x2_SRAM_3[0]/A_LWL<11> RM_IHPSG13_1P_COLUMN_256_0[7]/RM_IHPSG13_1P_BITKIT_16x2_SRAM_0[0]/A_LWL<14>
+ RM_IHPSG13_1P_COLUMN_256_0[7]/RM_IHPSG13_1P_BITKIT_16x2_SRAM_0[2]/A_LWL<7> RM_IHPSG13_1P_BITKIT_16x2_EDGE_LR_1[3]/LWL<2>
+ RM_IHPSG13_1P_BITKIT_16x2_EDGE_LR_1[3]/LWL<11> RM_IHPSG13_1P_BITKIT_16x2_EDGE_LR_3[3]/LWL<15>
+ RM_IHPSG13_1P_BITKIT_16x2_EDGE_LR_0[2]/LWL<11> RM_IHPSG13_1P_BITKIT_16x2_EDGE_LR_3[3]/LWL<3>
+ RM_IHPSG13_1P_COLUMN_256_0[7]/RM_IHPSG13_1P_BITKIT_16x2_SRAM_1[0]/A_LWL<7> RM_IHPSG13_1P_BITKIT_16x2_EDGE_LR_0[3]/LWL<4>
+ RM_IHPSG13_1P_COLUMN_256_0[7]/RM_IHPSG13_1P_BITKIT_16x2_SRAM_2[3]/A_LWL<6> RM_IHPSG13_1P_COLUMN_256_0[7]/RM_IHPSG13_1P_BITKIT_16x2_SRAM_3[2]/A_LWL<5>
+ RM_IHPSG13_1P_COLUMN_256_0[7]/RM_IHPSG13_1P_BITKIT_16x2_SRAM_0[0]/A_LWL<13> RM_IHPSG13_1P_COLUMN_256_0[7]/RM_IHPSG13_1P_BITKIT_16x2_SRAM_2[2]/A_LWL<6>
+ RM_IHPSG13_1P_BITKIT_16x2_EDGE_LR_3[0]/LWL<13> RM_IHPSG13_1P_COLUMN_256_0[7]/RM_IHPSG13_1P_BITKIT_16x2_SRAM_2[1]/A_LWL<1>
+ RM_IHPSG13_1P_COLUMN_256_0[7]/RM_IHPSG13_1P_BITKIT_16x2_SRAM_0[3]/A_LWL<5> RM_IHPSG13_1P_COLUMN_256_0[7]/RM_IHPSG13_1P_BITKIT_16x2_SRAM_2[0]/A_LWL<12>
+ RM_IHPSG13_1P_COLUMN_256_0[7]/RM_IHPSG13_1P_BITKIT_16x2_SRAM_3[3]/A_LWL<3> RM_IHPSG13_1P_COLUMN_256_0[7]/RM_IHPSG13_1P_BITKIT_16x2_SRAM_1[2]/A_LWL<7>
+ RM_IHPSG13_1P_BITKIT_16x2_EDGE_LR_2[3]/LWL<2> RM_IHPSG13_1P_BITKIT_16x2_EDGE_LR_0[1]/LWL<8>
+ RM_IHPSG13_1P_COLUMN_256_0[7]/RM_IHPSG13_1P_BITKIT_16x2_SRAM_2[3]/A_LWL<4> RM_IHPSG13_1P_BITKIT_16x2_EDGE_LR_0[1]/LWL<15>
+ RM_IHPSG13_1P_COLUMN_256_0[7]/RM_IHPSG13_1P_BITKIT_16x2_SRAM_3[0]/A_LWL<12> RM_IHPSG13_1P_BITKIT_16x2_EDGE_LR_1[0]/LWL<8>
+ RM_IHPSG13_1P_COLUMN_256_0[7]/RM_IHPSG13_1P_BITKIT_16x2_SRAM_0[2]/A_LWL<8> RM_IHPSG13_1P_BITKIT_16x2_EDGE_LR_1[3]/LWL<3>
+ RM_IHPSG13_1P_BITKIT_16x2_EDGE_LR_1[0]/LWL<2> RM_IHPSG13_1P_BITKIT_16x2_EDGE_LR_2[3]/LWL<9>
+ RM_IHPSG13_1P_BITKIT_16x2_EDGE_LR_0[2]/LWL<6> RM_IHPSG13_1P_BITKIT_16x2_EDGE_LR_0[1]/LWL<1>
+ RM_IHPSG13_1P_BITKIT_16x2_EDGE_LR_1[3]/LWL<14> RM_IHPSG13_1P_BITKIT_16x2_EDGE_LR_0[2]/LWL<12>
+ RM_IHPSG13_1P_BITKIT_16x2_EDGE_LR_3[3]/LWL<4> RM_IHPSG13_1P_BITKIT_16x2_EDGE_LR_1[1]/LWL<6>
+ RM_IHPSG13_1P_BITKIT_16x2_EDGE_LR_1[0]/LWL<1> RM_IHPSG13_1P_COLUMN_256_0[7]/RM_IHPSG13_1P_BITKIT_16x2_SRAM_3[3]/VSS
+ RM_IHPSG13_1P_COLUMN_256_0[7]/RM_IHPSG13_1P_BITKIT_16x2_SRAM_3[3]/VDD RM_IHPSG13_1P_BITKIT_16x2_EDGE_LR_0[3]/LWL<5>
+ RM_IHPSG13_1P_COLUMN_256_0[7]/RM_IHPSG13_1P_BITKIT_16x2_SRAM_3[2]/A_LWL<6> RM_IHPSG13_1P_COLUMN_256
XRM_IHPSG13_1P_BITKIT_16x2_EDGE_LR_6[0] RM_IHPSG13_1P_BITKIT_16x2_EDGE_LR_6[0]/LWL<15>
+ RM_IHPSG13_1P_BITKIT_16x2_EDGE_LR_6[0]/LWL<14> RM_IHPSG13_1P_BITKIT_16x2_EDGE_LR_6[0]/LWL<12>
+ RM_IHPSG13_1P_BITKIT_16x2_EDGE_LR_6[0]/LWL<10> RM_IHPSG13_1P_BITKIT_16x2_EDGE_LR_6[0]/LWL<9>
+ RM_IHPSG13_1P_BITKIT_16x2_EDGE_LR_6[0]/LWL<8> RM_IHPSG13_1P_BITKIT_16x2_EDGE_LR_6[0]/LWL<7>
+ RM_IHPSG13_1P_BITKIT_16x2_EDGE_LR_6[0]/LWL<6> RM_IHPSG13_1P_BITKIT_16x2_EDGE_LR_6[0]/LWL<4>
+ RM_IHPSG13_1P_BITKIT_16x2_EDGE_LR_6[0]/LWL<3> RM_IHPSG13_1P_BITKIT_16x2_EDGE_LR_6[0]/LWL<1>
+ RM_IHPSG13_1P_BITKIT_16x2_EDGE_LR_6[0]/LWL<0> RM_IHPSG13_1P_BITKIT_16x2_EDGE_LR_6[0]/LWL<11>
+ RM_IHPSG13_1P_BITKIT_16x2_EDGE_LR_6[0]/LWL<13> RM_IHPSG13_1P_COLUMN_256_0[7]/RM_IHPSG13_1P_BITKIT_16x2_SRAM_3[3]/VSS
+ RM_IHPSG13_1P_BITKIT_16x2_EDGE_LR_6[0]/LWL<5> RM_IHPSG13_1P_BITKIT_16x2_EDGE_LR_6[0]/LWL<2>
+ RM_IHPSG13_1P_COLUMN_256_0[7]/RM_IHPSG13_1P_BITKIT_16x2_SRAM_3[3]/VDD RM_IHPSG13_1P_BITKIT_16x2_EDGE_LR
XRM_IHPSG13_1P_BITKIT_16x2_EDGE_LR_6[1] RM_IHPSG13_1P_BITKIT_16x2_EDGE_LR_6[1]/LWL<15>
+ RM_IHPSG13_1P_BITKIT_16x2_EDGE_LR_6[1]/LWL<14> RM_IHPSG13_1P_BITKIT_16x2_EDGE_LR_6[1]/LWL<12>
+ RM_IHPSG13_1P_BITKIT_16x2_EDGE_LR_6[1]/LWL<10> RM_IHPSG13_1P_BITKIT_16x2_EDGE_LR_6[1]/LWL<9>
+ RM_IHPSG13_1P_BITKIT_16x2_EDGE_LR_6[1]/LWL<8> RM_IHPSG13_1P_BITKIT_16x2_EDGE_LR_6[1]/LWL<7>
+ RM_IHPSG13_1P_BITKIT_16x2_EDGE_LR_6[1]/LWL<6> RM_IHPSG13_1P_BITKIT_16x2_EDGE_LR_6[1]/LWL<4>
+ RM_IHPSG13_1P_BITKIT_16x2_EDGE_LR_6[1]/LWL<3> RM_IHPSG13_1P_BITKIT_16x2_EDGE_LR_6[1]/LWL<1>
+ RM_IHPSG13_1P_BITKIT_16x2_EDGE_LR_6[1]/LWL<0> RM_IHPSG13_1P_BITKIT_16x2_EDGE_LR_6[1]/LWL<11>
+ RM_IHPSG13_1P_BITKIT_16x2_EDGE_LR_6[1]/LWL<13> RM_IHPSG13_1P_COLUMN_256_0[7]/RM_IHPSG13_1P_BITKIT_16x2_SRAM_3[3]/VSS
+ RM_IHPSG13_1P_BITKIT_16x2_EDGE_LR_6[1]/LWL<5> RM_IHPSG13_1P_BITKIT_16x2_EDGE_LR_6[1]/LWL<2>
+ RM_IHPSG13_1P_COLUMN_256_0[7]/RM_IHPSG13_1P_BITKIT_16x2_SRAM_3[3]/VDD RM_IHPSG13_1P_BITKIT_16x2_EDGE_LR
XRM_IHPSG13_1P_BITKIT_16x2_EDGE_LR_6[2] RM_IHPSG13_1P_BITKIT_16x2_EDGE_LR_6[2]/LWL<15>
+ RM_IHPSG13_1P_BITKIT_16x2_EDGE_LR_6[2]/LWL<14> RM_IHPSG13_1P_BITKIT_16x2_EDGE_LR_6[2]/LWL<12>
+ RM_IHPSG13_1P_BITKIT_16x2_EDGE_LR_6[2]/LWL<10> RM_IHPSG13_1P_BITKIT_16x2_EDGE_LR_6[2]/LWL<9>
+ RM_IHPSG13_1P_BITKIT_16x2_EDGE_LR_6[2]/LWL<8> RM_IHPSG13_1P_BITKIT_16x2_EDGE_LR_6[2]/LWL<7>
+ RM_IHPSG13_1P_BITKIT_16x2_EDGE_LR_6[2]/LWL<6> RM_IHPSG13_1P_BITKIT_16x2_EDGE_LR_6[2]/LWL<4>
+ RM_IHPSG13_1P_BITKIT_16x2_EDGE_LR_6[2]/LWL<3> RM_IHPSG13_1P_BITKIT_16x2_EDGE_LR_6[2]/LWL<1>
+ RM_IHPSG13_1P_BITKIT_16x2_EDGE_LR_6[2]/LWL<0> RM_IHPSG13_1P_BITKIT_16x2_EDGE_LR_6[2]/LWL<11>
+ RM_IHPSG13_1P_BITKIT_16x2_EDGE_LR_6[2]/LWL<13> RM_IHPSG13_1P_COLUMN_256_0[7]/RM_IHPSG13_1P_BITKIT_16x2_SRAM_3[3]/VSS
+ RM_IHPSG13_1P_BITKIT_16x2_EDGE_LR_6[2]/LWL<5> RM_IHPSG13_1P_BITKIT_16x2_EDGE_LR_6[2]/LWL<2>
+ RM_IHPSG13_1P_COLUMN_256_0[7]/RM_IHPSG13_1P_BITKIT_16x2_SRAM_3[3]/VDD RM_IHPSG13_1P_BITKIT_16x2_EDGE_LR
XRM_IHPSG13_1P_BITKIT_16x2_EDGE_LR_6[3] RM_IHPSG13_1P_BITKIT_16x2_EDGE_LR_6[3]/LWL<15>
+ RM_IHPSG13_1P_BITKIT_16x2_EDGE_LR_6[3]/LWL<14> RM_IHPSG13_1P_BITKIT_16x2_EDGE_LR_6[3]/LWL<12>
+ RM_IHPSG13_1P_BITKIT_16x2_EDGE_LR_6[3]/LWL<10> RM_IHPSG13_1P_BITKIT_16x2_EDGE_LR_6[3]/LWL<9>
+ RM_IHPSG13_1P_BITKIT_16x2_EDGE_LR_6[3]/LWL<8> RM_IHPSG13_1P_BITKIT_16x2_EDGE_LR_6[3]/LWL<7>
+ RM_IHPSG13_1P_BITKIT_16x2_EDGE_LR_6[3]/LWL<6> RM_IHPSG13_1P_BITKIT_16x2_EDGE_LR_6[3]/LWL<4>
+ RM_IHPSG13_1P_BITKIT_16x2_EDGE_LR_6[3]/LWL<3> RM_IHPSG13_1P_BITKIT_16x2_EDGE_LR_6[3]/LWL<1>
+ RM_IHPSG13_1P_BITKIT_16x2_EDGE_LR_6[3]/LWL<0> RM_IHPSG13_1P_BITKIT_16x2_EDGE_LR_6[3]/LWL<11>
+ RM_IHPSG13_1P_BITKIT_16x2_EDGE_LR_6[3]/LWL<13> RM_IHPSG13_1P_COLUMN_256_0[7]/RM_IHPSG13_1P_BITKIT_16x2_SRAM_3[3]/VSS
+ RM_IHPSG13_1P_BITKIT_16x2_EDGE_LR_6[3]/LWL<5> RM_IHPSG13_1P_BITKIT_16x2_EDGE_LR_6[3]/LWL<2>
+ RM_IHPSG13_1P_COLUMN_256_0[7]/RM_IHPSG13_1P_BITKIT_16x2_SRAM_3[3]/VDD RM_IHPSG13_1P_BITKIT_16x2_EDGE_LR
XRM_IHPSG13_1P_BITKIT_16x2_EDGE_LR_7[0] RM_IHPSG13_1P_BITKIT_16x2_EDGE_LR_7[0]/LWL<15>
+ RM_IHPSG13_1P_BITKIT_16x2_EDGE_LR_7[0]/LWL<14> RM_IHPSG13_1P_BITKIT_16x2_EDGE_LR_7[0]/LWL<12>
+ RM_IHPSG13_1P_BITKIT_16x2_EDGE_LR_7[0]/LWL<10> RM_IHPSG13_1P_BITKIT_16x2_EDGE_LR_7[0]/LWL<9>
+ RM_IHPSG13_1P_BITKIT_16x2_EDGE_LR_7[0]/LWL<8> RM_IHPSG13_1P_BITKIT_16x2_EDGE_LR_7[0]/LWL<7>
+ RM_IHPSG13_1P_BITKIT_16x2_EDGE_LR_7[0]/LWL<6> RM_IHPSG13_1P_BITKIT_16x2_EDGE_LR_7[0]/LWL<4>
+ RM_IHPSG13_1P_BITKIT_16x2_EDGE_LR_7[0]/LWL<3> RM_IHPSG13_1P_BITKIT_16x2_EDGE_LR_7[0]/LWL<1>
+ RM_IHPSG13_1P_BITKIT_16x2_EDGE_LR_7[0]/LWL<0> RM_IHPSG13_1P_BITKIT_16x2_EDGE_LR_7[0]/LWL<11>
+ RM_IHPSG13_1P_BITKIT_16x2_EDGE_LR_7[0]/LWL<13> RM_IHPSG13_1P_COLUMN_256_0[7]/RM_IHPSG13_1P_BITKIT_16x2_SRAM_3[3]/VSS
+ RM_IHPSG13_1P_BITKIT_16x2_EDGE_LR_7[0]/LWL<5> RM_IHPSG13_1P_BITKIT_16x2_EDGE_LR_7[0]/LWL<2>
+ RM_IHPSG13_1P_COLUMN_256_0[7]/RM_IHPSG13_1P_BITKIT_16x2_SRAM_3[3]/VDD RM_IHPSG13_1P_BITKIT_16x2_EDGE_LR
XRM_IHPSG13_1P_BITKIT_16x2_EDGE_LR_7[1] RM_IHPSG13_1P_BITKIT_16x2_EDGE_LR_7[1]/LWL<15>
+ RM_IHPSG13_1P_BITKIT_16x2_EDGE_LR_7[1]/LWL<14> RM_IHPSG13_1P_BITKIT_16x2_EDGE_LR_7[1]/LWL<12>
+ RM_IHPSG13_1P_BITKIT_16x2_EDGE_LR_7[1]/LWL<10> RM_IHPSG13_1P_BITKIT_16x2_EDGE_LR_7[1]/LWL<9>
+ RM_IHPSG13_1P_BITKIT_16x2_EDGE_LR_7[1]/LWL<8> RM_IHPSG13_1P_BITKIT_16x2_EDGE_LR_7[1]/LWL<7>
+ RM_IHPSG13_1P_BITKIT_16x2_EDGE_LR_7[1]/LWL<6> RM_IHPSG13_1P_BITKIT_16x2_EDGE_LR_7[1]/LWL<4>
+ RM_IHPSG13_1P_BITKIT_16x2_EDGE_LR_7[1]/LWL<3> RM_IHPSG13_1P_BITKIT_16x2_EDGE_LR_7[1]/LWL<1>
+ RM_IHPSG13_1P_BITKIT_16x2_EDGE_LR_7[1]/LWL<0> RM_IHPSG13_1P_BITKIT_16x2_EDGE_LR_7[1]/LWL<11>
+ RM_IHPSG13_1P_BITKIT_16x2_EDGE_LR_7[1]/LWL<13> RM_IHPSG13_1P_COLUMN_256_0[7]/RM_IHPSG13_1P_BITKIT_16x2_SRAM_3[3]/VSS
+ RM_IHPSG13_1P_BITKIT_16x2_EDGE_LR_7[1]/LWL<5> RM_IHPSG13_1P_BITKIT_16x2_EDGE_LR_7[1]/LWL<2>
+ RM_IHPSG13_1P_COLUMN_256_0[7]/RM_IHPSG13_1P_BITKIT_16x2_SRAM_3[3]/VDD RM_IHPSG13_1P_BITKIT_16x2_EDGE_LR
XRM_IHPSG13_1P_BITKIT_16x2_EDGE_LR_7[2] RM_IHPSG13_1P_BITKIT_16x2_EDGE_LR_7[2]/LWL<15>
+ RM_IHPSG13_1P_BITKIT_16x2_EDGE_LR_7[2]/LWL<14> RM_IHPSG13_1P_BITKIT_16x2_EDGE_LR_7[2]/LWL<12>
+ RM_IHPSG13_1P_BITKIT_16x2_EDGE_LR_7[2]/LWL<10> RM_IHPSG13_1P_BITKIT_16x2_EDGE_LR_7[2]/LWL<9>
+ RM_IHPSG13_1P_BITKIT_16x2_EDGE_LR_7[2]/LWL<8> RM_IHPSG13_1P_BITKIT_16x2_EDGE_LR_7[2]/LWL<7>
+ RM_IHPSG13_1P_BITKIT_16x2_EDGE_LR_7[2]/LWL<6> RM_IHPSG13_1P_BITKIT_16x2_EDGE_LR_7[2]/LWL<4>
+ RM_IHPSG13_1P_BITKIT_16x2_EDGE_LR_7[2]/LWL<3> RM_IHPSG13_1P_BITKIT_16x2_EDGE_LR_7[2]/LWL<1>
+ RM_IHPSG13_1P_BITKIT_16x2_EDGE_LR_7[2]/LWL<0> RM_IHPSG13_1P_BITKIT_16x2_EDGE_LR_7[2]/LWL<11>
+ RM_IHPSG13_1P_BITKIT_16x2_EDGE_LR_7[2]/LWL<13> RM_IHPSG13_1P_COLUMN_256_0[7]/RM_IHPSG13_1P_BITKIT_16x2_SRAM_3[3]/VSS
+ RM_IHPSG13_1P_BITKIT_16x2_EDGE_LR_7[2]/LWL<5> RM_IHPSG13_1P_BITKIT_16x2_EDGE_LR_7[2]/LWL<2>
+ RM_IHPSG13_1P_COLUMN_256_0[7]/RM_IHPSG13_1P_BITKIT_16x2_SRAM_3[3]/VDD RM_IHPSG13_1P_BITKIT_16x2_EDGE_LR
XRM_IHPSG13_1P_BITKIT_16x2_EDGE_LR_7[3] RM_IHPSG13_1P_BITKIT_16x2_EDGE_LR_7[3]/LWL<15>
+ RM_IHPSG13_1P_BITKIT_16x2_EDGE_LR_7[3]/LWL<14> RM_IHPSG13_1P_BITKIT_16x2_EDGE_LR_7[3]/LWL<12>
+ RM_IHPSG13_1P_BITKIT_16x2_EDGE_LR_7[3]/LWL<10> RM_IHPSG13_1P_BITKIT_16x2_EDGE_LR_7[3]/LWL<9>
+ RM_IHPSG13_1P_BITKIT_16x2_EDGE_LR_7[3]/LWL<8> RM_IHPSG13_1P_BITKIT_16x2_EDGE_LR_7[3]/LWL<7>
+ RM_IHPSG13_1P_BITKIT_16x2_EDGE_LR_7[3]/LWL<6> RM_IHPSG13_1P_BITKIT_16x2_EDGE_LR_7[3]/LWL<4>
+ RM_IHPSG13_1P_BITKIT_16x2_EDGE_LR_7[3]/LWL<3> RM_IHPSG13_1P_BITKIT_16x2_EDGE_LR_7[3]/LWL<1>
+ RM_IHPSG13_1P_BITKIT_16x2_EDGE_LR_7[3]/LWL<0> RM_IHPSG13_1P_BITKIT_16x2_EDGE_LR_7[3]/LWL<11>
+ RM_IHPSG13_1P_BITKIT_16x2_EDGE_LR_7[3]/LWL<13> RM_IHPSG13_1P_COLUMN_256_0[7]/RM_IHPSG13_1P_BITKIT_16x2_SRAM_3[3]/VSS
+ RM_IHPSG13_1P_BITKIT_16x2_EDGE_LR_7[3]/LWL<5> RM_IHPSG13_1P_BITKIT_16x2_EDGE_LR_7[3]/LWL<2>
+ RM_IHPSG13_1P_COLUMN_256_0[7]/RM_IHPSG13_1P_BITKIT_16x2_SRAM_3[3]/VDD RM_IHPSG13_1P_BITKIT_16x2_EDGE_LR
.ends

.subckt RM_IHPSG13_1P_DEC_LE_l1empty m2_1178_0# w_n102_735# dw_0_780#
X0 a_293_1380# a_293_894# w_n102_735# w_n102_735# sg13_lv_pmos ad=0.3078p pd=2u as=0.3078p ps=2u w=1.62u l=0.385u
X1 a_905_894# a_905_1380# dw_0_780# dw_0_780# sg13_lv_nmos ad=0.1577p pd=1.21u as=0.1577p ps=1.21u w=0.83u l=0.13u
X2 dw_0_780# a_905_1380# a_905_894# dw_0_780# sg13_lv_nmos ad=0.2822p pd=2.34u as=0.1577p ps=1.21u w=0.83u l=0.13u
X3 w_n102_735# a_293_894# a_293_1380# w_n102_735# sg13_lv_pmos ad=0.3078p pd=2u as=0.3078p ps=2u w=1.62u l=0.385u
X4 a_293_894# a_293_1380# dw_0_780# dw_0_780# sg13_lv_nmos ad=0.1577p pd=1.21u as=0.2822p ps=2.34u w=0.83u l=0.13u
X5 a_293_894# a_293_1380# dw_0_780# dw_0_780# sg13_lv_nmos ad=0.1577p pd=1.21u as=0.1577p ps=1.21u w=0.83u l=0.13u
X6 w_n102_735# a_293_894# a_293_1380# w_n102_735# sg13_lv_pmos ad=0.3078p pd=2u as=0.3078p ps=2u w=1.62u l=0.385u
X7 dw_0_780# a_293_1380# a_293_894# dw_0_780# sg13_lv_nmos ad=0.1577p pd=1.21u as=0.1577p ps=1.21u w=0.83u l=0.13u
X8 dw_0_780# a_293_1380# a_293_894# dw_0_780# sg13_lv_nmos ad=0.1577p pd=1.21u as=0.1577p ps=1.21u w=0.83u l=0.13u
X9 a_905_1380# a_905_894# w_n102_735# w_n102_735# sg13_lv_pmos ad=0.3078p pd=2u as=0.3078p ps=2u w=1.62u l=0.385u
X10 w_n102_735# a_905_894# a_905_1380# w_n102_735# sg13_lv_pmos ad=0.3078p pd=2u as=0.3078p ps=2u w=1.62u l=0.385u
X11 dw_0_780# a_905_1380# a_905_894# dw_0_780# sg13_lv_nmos ad=0.1577p pd=1.21u as=0.1577p ps=1.21u w=0.83u l=0.13u
X12 a_905_894# a_905_1380# dw_0_780# dw_0_780# sg13_lv_nmos ad=0.1577p pd=1.21u as=0.1577p ps=1.21u w=0.83u l=0.13u
X13 w_n102_735# a_905_894# a_905_1380# w_n102_735# sg13_lv_pmos ad=0.5508p pd=3.92u as=0.3078p ps=2u w=1.62u l=0.385u
X14 a_293_894# a_293_1380# dw_0_780# dw_0_780# sg13_lv_nmos ad=0.1577p pd=1.21u as=0.1577p ps=1.21u w=0.83u l=0.13u
X15 a_905_1380# a_905_894# w_n102_735# w_n102_735# sg13_lv_pmos ad=0.3078p pd=2u as=0.3078p ps=2u w=1.62u l=0.385u
X16 dw_0_780# a_905_1380# a_905_894# dw_0_780# sg13_lv_nmos ad=0.1577p pd=1.21u as=0.1577p ps=1.21u w=0.83u l=0.13u
X17 a_905_894# a_905_1380# dw_0_780# dw_0_780# sg13_lv_nmos ad=0.1577p pd=1.21u as=0.1577p ps=1.21u w=0.83u l=0.13u
X18 dw_0_780# a_293_1380# a_293_894# dw_0_780# sg13_lv_nmos ad=0.1577p pd=1.21u as=0.1577p ps=1.21u w=0.83u l=0.13u
X19 a_293_1380# a_293_894# w_n102_735# w_n102_735# sg13_lv_pmos ad=0.3078p pd=2u as=0.5508p ps=3.92u w=1.62u l=0.385u
.ends

.subckt RM_IHPSG13_1P_DEC_LE_l2empty w_n102_2037# m2_1280_0# dw_0_1620#
X0 a_293_2016# a_293_1738# dw_0_1620# dw_0_1620# sg13_lv_nmos ad=0.1577p pd=1.21u as=0.2822p ps=2.34u w=0.83u l=0.13u
X1 a_293_2016# a_293_1738# dw_0_1620# dw_0_1620# sg13_lv_nmos ad=0.1577p pd=1.21u as=0.1577p ps=1.21u w=0.83u l=0.13u
X2 a_293_1738# a_293_2016# w_n102_2037# w_n102_2037# sg13_lv_pmos ad=0.3078p pd=2u as=0.3078p ps=2u w=1.62u l=0.385u
X3 w_n102_2037# a_905_2016# a_905_1738# w_n102_2037# sg13_lv_pmos ad=0.3078p pd=2u as=0.3078p ps=2u w=1.62u l=0.385u
X4 w_n102_2037# a_905_2016# a_905_1738# w_n102_2037# sg13_lv_pmos ad=0.5508p pd=3.92u as=0.3078p ps=2u w=1.62u l=0.385u
X5 dw_0_1620# a_293_1738# a_293_2016# dw_0_1620# sg13_lv_nmos ad=0.1577p pd=1.21u as=0.1577p ps=1.21u w=0.83u l=0.13u
X6 dw_0_1620# a_293_1738# a_293_2016# dw_0_1620# sg13_lv_nmos ad=0.1577p pd=1.21u as=0.1577p ps=1.21u w=0.83u l=0.13u
X7 a_293_1738# a_293_2016# w_n102_2037# w_n102_2037# sg13_lv_pmos ad=0.3078p pd=2u as=0.5508p ps=3.92u w=1.62u l=0.385u
X8 dw_0_1620# a_905_1738# a_905_2016# dw_0_1620# sg13_lv_nmos ad=0.1577p pd=1.21u as=0.1577p ps=1.21u w=0.83u l=0.13u
X9 a_293_2016# a_293_1738# dw_0_1620# dw_0_1620# sg13_lv_nmos ad=0.1577p pd=1.21u as=0.1577p ps=1.21u w=0.83u l=0.13u
X10 a_905_2016# a_905_1738# dw_0_1620# dw_0_1620# sg13_lv_nmos ad=0.1577p pd=1.21u as=0.1577p ps=1.21u w=0.83u l=0.13u
X11 w_n102_2037# a_293_2016# a_293_1738# w_n102_2037# sg13_lv_pmos ad=0.3078p pd=2u as=0.3078p ps=2u w=1.62u l=0.385u
X12 w_n102_2037# a_293_2016# a_293_1738# w_n102_2037# sg13_lv_pmos ad=0.3078p pd=2u as=0.3078p ps=2u w=1.62u l=0.385u
X13 a_905_2016# a_905_1738# dw_0_1620# dw_0_1620# sg13_lv_nmos ad=0.1577p pd=1.21u as=0.1577p ps=1.21u w=0.83u l=0.13u
X14 a_905_1738# a_905_2016# w_n102_2037# w_n102_2037# sg13_lv_pmos ad=0.3078p pd=2u as=0.3078p ps=2u w=1.62u l=0.385u
X15 dw_0_1620# a_905_1738# a_905_2016# dw_0_1620# sg13_lv_nmos ad=0.1577p pd=1.21u as=0.1577p ps=1.21u w=0.83u l=0.13u
X16 a_905_1738# a_905_2016# w_n102_2037# w_n102_2037# sg13_lv_pmos ad=0.3078p pd=2u as=0.3078p ps=2u w=1.62u l=0.385u
X17 dw_0_1620# a_293_1738# a_293_2016# dw_0_1620# sg13_lv_nmos ad=0.1577p pd=1.21u as=0.1577p ps=1.21u w=0.83u l=0.13u
X18 a_905_2016# a_905_1738# dw_0_1620# dw_0_1620# sg13_lv_nmos ad=0.1577p pd=1.21u as=0.1577p ps=1.21u w=0.83u l=0.13u
X19 dw_0_1620# a_905_1738# a_905_2016# dw_0_1620# sg13_lv_nmos ad=0.2822p pd=2.34u as=0.1577p ps=1.21u w=0.83u l=0.13u
.ends

.subckt RM_IHPSG13_1P_DEC04 ADDR<0> ADDR<1> ADDR<2> ADDR<3> ECLK_L_BOT ECLK_H_BOT
+ ECLK_H_TOP ECLK_L_TOP CS WL<15> WL<14> WL<13> WL<12> WL<11> WL<10> WL<9> WL<8> WL<7>
+ WL<6> WL<5> WL<4> WL<3> WL<2> WL<1> WL<0> VSS VDD m2_1382_0# m2_260_840# m2_770_840#
+ m2_362_840# m2_56_840# m2_872_840# m2_158_840#
X0 VSS a_4445_278# a_4407_98# VSS sg13_lv_nmos ad=0.1577p pd=1.21u as=0.2822p ps=2.34u w=0.83u l=0.13u
X1 VSS a_3724_308# WL<6> VSS sg13_lv_nmos ad=0.16625p pd=1.255u as=0.16625p ps=1.255u w=0.875u l=0.13u
X2 VSS a_2027_60# a_1951_176# VSS sg13_lv_nmos ad=91.2f pd=0.86u as=91.2f ps=0.86u w=0.48u l=0.13u
X3 a_3111_1988# a_1849_1778# VSS VSS sg13_lv_nmos ad=0.3332p pd=2.64u as=0.3332p ps=2.64u w=0.98u l=0.13u
X4 a_1747_1408# ADDR<1> VSS VSS sg13_lv_nmos ad=0.1653p pd=1.25u as=0.13605p ps=1.25u w=0.87u l=0.13u
X5 a_3787_2616# a_3724_308# a_3685_2616# VDD sg13_lv_pmos ad=0.3078p pd=2u as=0.3078p ps=2u w=1.62u l=0.13u
X6 a_5253_2956# CS a_3277_3066# VSS sg13_lv_nmos ad=0.3332p pd=2.64u as=0.1862p ps=1.36u w=0.98u l=0.13u
X7 a_5253_2956# a_3111_1988# VDD VDD sg13_lv_pmos ad=0.3078p pd=2u as=0.5508p ps=3.92u w=1.62u l=0.13u
X8 a_2563_936# a_2359_936# VDD VDD sg13_lv_pmos ad=0.5508p pd=3.92u as=0.5508p ps=3.92u w=1.62u l=0.13u
X9 a_2027_2647# a_1849_2685# VSS VSS sg13_lv_nmos ad=0.1632p pd=1.64u as=91.2f ps=0.86u w=0.48u l=0.13u
X10 WL<1> a_5458_308# VSS VSS sg13_lv_nmos ad=0.2975p pd=2.43u as=0.16625p ps=1.255u w=0.875u l=0.13u
X11 a_1849_98# CS a_1747_98# VSS sg13_lv_nmos ad=0.13605p pd=1.25u as=0.1653p ps=1.25u w=0.87u l=0.13u
X12 a_1951_1856# a_1551_1778# a_1849_1778# VSS sg13_lv_nmos ad=91.2f pd=0.86u as=0.13605p ps=1.25u w=0.48u l=0.13u
X13 WL<14> a_5253_1988# VSS VSS sg13_lv_nmos ad=0.16625p pd=1.255u as=0.2975p ps=2.43u w=0.875u l=0.13u
X14 a_2027_60# a_1849_98# VSS VSS sg13_lv_nmos ad=0.1632p pd=1.64u as=91.2f ps=0.86u w=0.48u l=0.13u
X15 WL<7> a_5253_2956# VSS VSS sg13_lv_nmos ad=0.16625p pd=1.255u as=0.2975p ps=2.43u w=0.875u l=0.13u
X16 a_3277_1778# a_2359_2616# a_3175_1778# VSS sg13_lv_nmos ad=0.1862p pd=1.36u as=0.1862p ps=1.36u w=0.98u l=0.13u
X17 a_2027_967# a_1849_1005# VDD VDD sg13_lv_pmos ad=0.1632p pd=1.64u as=91.2f ps=0.86u w=0.48u l=0.13u
X18 WL<14> a_5458_308# a_3787_2100# VDD sg13_lv_pmos ad=0.5508p pd=3.92u as=0.3078p ps=2u w=1.62u l=0.13u
X19 VSS a_2027_967# a_1951_1408# VSS sg13_lv_nmos ad=91.2f pd=0.86u as=91.2f ps=0.86u w=0.48u l=0.13u
X20 a_4093_420# a_5253_308# VDD VDD sg13_lv_pmos ad=0.3078p pd=2u as=0.5508p ps=3.92u w=1.62u l=0.13u
X21 a_3175_936# a_3111_308# VDD VDD sg13_lv_pmos ad=0.3078p pd=2u as=0.5508p ps=3.92u w=1.62u l=0.13u
X22 a_4093_2616# a_5253_2956# VDD VDD sg13_lv_pmos ad=0.3078p pd=2u as=0.5508p ps=3.92u w=1.62u l=0.13u
X23 a_4948_308# a_2563_98# a_2767_98# VSS sg13_lv_nmos ad=0.3332p pd=2.64u as=0.1862p ps=1.36u w=0.98u l=0.13u
X24 VSS a_4948_308# WL<8> VSS sg13_lv_nmos ad=0.16625p pd=1.255u as=0.16625p ps=1.255u w=0.875u l=0.13u
X25 WL<12> a_5253_1988# VSS VSS sg13_lv_nmos ad=0.16625p pd=1.255u as=0.2975p ps=2.43u w=0.875u l=0.13u
X26 VDD a_2359_2616# a_3175_936# VDD sg13_lv_pmos ad=0.3078p pd=2u as=0.3078p ps=2u w=1.62u l=0.13u
X27 a_5356_308# a_2563_936# VDD VDD sg13_lv_pmos ad=0.3078p pd=2u as=0.5508p ps=3.92u w=1.62u l=0.13u
X28 WL<11> a_5458_308# VSS VSS sg13_lv_nmos ad=0.2975p pd=2.43u as=0.16625p ps=1.255u w=0.875u l=0.13u
X29 WL<5> a_5253_2956# VSS VSS sg13_lv_nmos ad=0.16625p pd=1.255u as=0.2975p ps=2.43u w=0.875u l=0.13u
X30 a_4195_2100# a_4132_308# a_4093_2100# VDD sg13_lv_pmos ad=0.3078p pd=2u as=0.3078p ps=2u w=1.62u l=0.13u
X31 WL<2> a_5458_308# VSS VSS sg13_lv_nmos ad=0.2975p pd=2.43u as=0.16625p ps=1.255u w=0.875u l=0.13u
X32 a_4195_420# a_4132_308# a_4093_420# VDD sg13_lv_pmos ad=0.3078p pd=2u as=0.3078p ps=2u w=1.62u l=0.13u
X33 a_3685_420# a_5253_308# VDD VDD sg13_lv_pmos ad=0.3078p pd=2u as=0.5508p ps=3.92u w=1.62u l=0.13u
X34 a_1849_2685# a_1551_2685# a_1747_2685# VDD sg13_lv_pmos ad=0.14887p pd=1.355u as=0.18525p ps=1.355u w=0.975u l=0.13u
X35 a_5317_2616# a_5253_2956# VDD VDD sg13_lv_pmos ad=0.3078p pd=2u as=0.5508p ps=3.92u w=1.62u l=0.13u
X36 VSS CS a_1551_98# VSS sg13_lv_nmos ad=0.13605p pd=1.25u as=0.1632p ps=1.64u w=0.48u l=0.13u
X37 WL<3> a_5458_308# a_4195_420# VDD sg13_lv_pmos ad=0.5508p pd=3.92u as=0.3078p ps=2u w=1.62u l=0.13u
X38 a_3787_420# a_3724_308# a_3685_420# VDD sg13_lv_pmos ad=0.3078p pd=2u as=0.3078p ps=2u w=1.62u l=0.13u
X39 a_3175_936# CS VDD VDD sg13_lv_pmos ad=0.5508p pd=3.92u as=0.3078p ps=2u w=1.62u l=0.13u
X40 VDD a_2359_98# a_5356_308# VDD sg13_lv_pmos ad=0.5508p pd=3.92u as=0.3078p ps=2u w=1.62u l=0.13u
X41 a_1849_1778# CS a_1747_1778# VSS sg13_lv_nmos ad=0.13605p pd=1.25u as=0.1653p ps=1.25u w=0.87u l=0.13u
X42 WL<13> a_5458_308# VSS VSS sg13_lv_nmos ad=0.2975p pd=2.43u as=0.16625p ps=1.255u w=0.875u l=0.13u
X43 a_2359_98# a_1849_98# VSS VSS sg13_lv_nmos ad=0.3332p pd=2.64u as=0.3332p ps=2.64u w=0.98u l=0.13u
X44 a_1951_176# a_1551_98# a_1849_98# VSS sg13_lv_nmos ad=91.2f pd=0.86u as=0.13605p ps=1.25u w=0.48u l=0.13u
X45 a_1951_3088# a_1551_2685# a_1849_2685# VSS sg13_lv_nmos ad=91.2f pd=0.86u as=0.13605p ps=1.25u w=0.48u l=0.13u
X46 a_2563_2616# a_2359_2616# VSS VSS sg13_lv_nmos ad=0.3332p pd=2.64u as=0.3332p ps=2.64u w=0.98u l=0.13u
X47 a_3724_308# a_2563_98# a_2767_3066# VSS sg13_lv_nmos ad=0.3332p pd=2.64u as=0.1862p ps=1.36u w=0.98u l=0.13u
X48 a_5419_2100# a_5356_308# a_5317_2100# VDD sg13_lv_pmos ad=0.3078p pd=2u as=0.3078p ps=2u w=1.62u l=0.13u
X49 WL<0> a_5253_308# VSS VSS sg13_lv_nmos ad=0.16625p pd=1.255u as=0.2975p ps=2.43u w=0.875u l=0.13u
X50 WL<12> a_5458_308# a_5011_2100# VDD sg13_lv_pmos ad=0.5508p pd=3.92u as=0.3078p ps=2u w=1.62u l=0.13u
X51 WL<2> a_5458_308# a_3787_420# VDD sg13_lv_pmos ad=0.5508p pd=3.92u as=0.3078p ps=2u w=1.62u l=0.13u
X52 WL<6> a_5458_308# VSS VSS sg13_lv_nmos ad=0.2975p pd=2.43u as=0.16625p ps=1.255u w=0.875u l=0.13u
X53 VDD a_2027_2647# a_1951_2746# VDD sg13_lv_pmos ad=91.2f pd=0.86u as=91.2f ps=0.86u w=0.48u l=0.13u
X54 VDD a_2027_1740# a_1951_2198# VDD sg13_lv_pmos ad=91.2f pd=0.86u as=91.2f ps=0.86u w=0.48u l=0.13u
X55 a_1951_1066# CS a_1849_1005# VDD sg13_lv_pmos ad=91.2f pd=0.86u as=0.14887p ps=1.355u w=0.48u l=0.13u
X56 a_2767_1778# a_2359_936# VSS VSS sg13_lv_nmos ad=0.1862p pd=1.36u as=0.3332p ps=2.64u w=0.98u l=0.13u
X57 a_1747_1005# ADDR<1> VDD VDD sg13_lv_pmos ad=0.18525p pd=1.355u as=0.14812p ps=1.355u w=0.975u l=0.13u
X58 a_5253_308# CS a_3277_98# VSS sg13_lv_nmos ad=0.3332p pd=2.64u as=0.1862p ps=1.36u w=0.98u l=0.13u
X59 a_1849_1005# CS a_1747_1408# VSS sg13_lv_nmos ad=0.13605p pd=1.25u as=0.1653p ps=1.25u w=0.87u l=0.13u
X60 a_2359_936# a_1849_1005# VSS VSS sg13_lv_nmos ad=0.3332p pd=2.64u as=0.3332p ps=2.64u w=0.98u l=0.13u
X61 WL<6> a_5458_308# a_3787_2616# VDD sg13_lv_pmos ad=0.5508p pd=3.92u as=0.3078p ps=2u w=1.62u l=0.13u
X62 WL<2> a_5253_308# VSS VSS sg13_lv_nmos ad=0.16625p pd=1.255u as=0.2975p ps=2.43u w=0.875u l=0.13u
X63 a_4093_936# a_3175_936# VDD VDD sg13_lv_pmos ad=0.3078p pd=2u as=0.5508p ps=3.92u w=1.62u l=0.13u
X64 a_3175_3066# a_3111_1988# VSS VSS sg13_lv_nmos ad=0.1862p pd=1.36u as=0.3332p ps=2.64u w=0.98u l=0.13u
X65 a_3111_1988# a_1849_1778# VDD VDD sg13_lv_pmos ad=0.5508p pd=3.92u as=0.5508p ps=3.92u w=1.62u l=0.13u
X66 a_4445_278# a_4407_98# VDD VDD sg13_lv_pmos ad=0.3078p pd=2u as=0.5508p ps=3.92u w=1.62u l=0.385u
X67 VSS a_3724_308# WL<10> VSS sg13_lv_nmos ad=0.16625p pd=1.255u as=0.16625p ps=1.255u w=0.875u l=0.13u
X68 VSS ECLK_L_BOT a_5458_308# VSS sg13_lv_nmos ad=0.2397p pd=2.09u as=0.2397p ps=2.09u w=0.705u l=0.13u
X69 a_5253_1988# CS a_3277_1778# VSS sg13_lv_nmos ad=0.3332p pd=2.64u as=0.1862p ps=1.36u w=0.98u l=0.13u
X70 VDD a_2027_60# a_1951_518# VDD sg13_lv_pmos ad=91.2f pd=0.86u as=91.2f ps=0.86u w=0.48u l=0.13u
X71 VSS a_4132_308# WL<7> VSS sg13_lv_nmos ad=0.16625p pd=1.255u as=0.16625p ps=1.255u w=0.875u l=0.13u
R0 ECLK_H_TOP ECLK_H_BOT 0.203077
X72 a_3277_1386# a_2359_2616# a_3175_1386# VSS sg13_lv_nmos ad=0.1862p pd=1.36u as=0.1862p ps=1.36u w=0.98u l=0.13u
X73 a_3685_2100# a_5253_1988# VDD VDD sg13_lv_pmos ad=0.3078p pd=2u as=0.5508p ps=3.92u w=1.62u l=0.13u
X74 a_2027_967# a_1849_1005# VSS VSS sg13_lv_nmos ad=0.1632p pd=1.64u as=91.2f ps=0.86u w=0.48u l=0.13u
X75 VSS a_4445_278# a_4407_98# VSS sg13_lv_nmos ad=0.2822p pd=2.34u as=0.1577p ps=1.21u w=0.83u l=0.13u
X76 a_4195_2616# a_4132_308# a_4093_2616# VDD sg13_lv_pmos ad=0.3078p pd=2u as=0.3078p ps=2u w=1.62u l=0.13u
X77 WL<0> a_5458_308# a_5011_420# VDD sg13_lv_pmos ad=0.5508p pd=3.92u as=0.3078p ps=2u w=1.62u l=0.13u
X78 a_4195_936# a_4132_308# a_4093_936# VDD sg13_lv_pmos ad=0.3078p pd=2u as=0.3078p ps=2u w=1.62u l=0.13u
X79 a_3685_936# a_3175_936# VDD VDD sg13_lv_pmos ad=0.3078p pd=2u as=0.5508p ps=3.92u w=1.62u l=0.13u
X80 VDD a_2359_2616# a_5253_1988# VDD sg13_lv_pmos ad=0.3078p pd=2u as=0.3078p ps=2u w=1.62u l=0.13u
X81 WL<11> a_5458_308# a_4195_936# VDD sg13_lv_pmos ad=0.5508p pd=3.92u as=0.3078p ps=2u w=1.62u l=0.13u
X82 a_3787_936# a_3724_308# a_3685_936# VDD sg13_lv_pmos ad=0.3078p pd=2u as=0.3078p ps=2u w=1.62u l=0.13u
X83 ECLK_L_BOT ECLK_H_BOT VSS VSS sg13_lv_nmos ad=0.2397p pd=2.09u as=0.2397p ps=2.09u w=0.705u l=0.13u
X84 VSS a_4948_308# WL<12> VSS sg13_lv_nmos ad=0.16625p pd=1.255u as=0.16625p ps=1.255u w=0.875u l=0.13u
X85 a_1747_2160# ADDR<2> VDD VDD sg13_lv_pmos ad=0.18525p pd=1.355u as=0.14812p ps=1.355u w=0.975u l=0.13u
X86 VSS CS a_1551_1005# VSS sg13_lv_nmos ad=0.13605p pd=1.25u as=0.1632p ps=1.64u w=0.48u l=0.13u
X87 VSS a_5356_308# WL<1> VSS sg13_lv_nmos ad=0.16625p pd=1.255u as=0.16625p ps=1.255u w=0.875u l=0.13u
X88 a_1747_98# ADDR<0> VSS VSS sg13_lv_nmos ad=0.1653p pd=1.25u as=0.13605p ps=1.25u w=0.87u l=0.13u
X89 a_2027_60# a_1849_98# VDD VDD sg13_lv_pmos ad=0.1632p pd=1.64u as=91.2f ps=0.86u w=0.48u l=0.13u
X90 WL<11> a_3175_936# VSS VSS sg13_lv_nmos ad=0.16625p pd=1.255u as=0.2975p ps=2.43u w=0.875u l=0.13u
X91 a_3175_98# a_3111_308# VSS VSS sg13_lv_nmos ad=0.1862p pd=1.36u as=0.3332p ps=2.64u w=0.98u l=0.13u
X92 WL<4> a_5458_308# VSS VSS sg13_lv_nmos ad=0.2975p pd=2.43u as=0.16625p ps=1.255u w=0.875u l=0.13u
X93 VSS a_5356_308# WL<5> VSS sg13_lv_nmos ad=0.16625p pd=1.255u as=0.16625p ps=1.255u w=0.875u l=0.13u
X94 WL<15> a_5458_308# VSS VSS sg13_lv_nmos ad=0.2975p pd=2.43u as=0.16625p ps=1.255u w=0.875u l=0.13u
X95 a_4909_2100# a_5253_1988# VDD VDD sg13_lv_pmos ad=0.3078p pd=2u as=0.5508p ps=3.92u w=1.62u l=0.13u
X96 a_5419_2616# a_5356_308# a_5317_2616# VDD sg13_lv_pmos ad=0.3078p pd=2u as=0.3078p ps=2u w=1.62u l=0.13u
X97 VDD CS a_1551_2685# VDD sg13_lv_pmos ad=0.14812p pd=1.355u as=0.1632p ps=1.64u w=0.48u l=0.13u
X98 WL<4> a_5458_308# a_5011_2616# VDD sg13_lv_pmos ad=0.5508p pd=3.92u as=0.3078p ps=2u w=1.62u l=0.13u
X99 a_5317_420# a_5253_308# VDD VDD sg13_lv_pmos ad=0.3078p pd=2u as=0.5508p ps=3.92u w=1.62u l=0.13u
X100 WL<10> a_5458_308# a_3787_936# VDD sg13_lv_pmos ad=0.5508p pd=3.92u as=0.3078p ps=2u w=1.62u l=0.13u
X101 a_2767_98# a_2563_936# VSS VSS sg13_lv_nmos ad=0.1862p pd=1.36u as=0.3332p ps=2.64u w=0.98u l=0.13u
X102 VSS CS a_1551_1778# VSS sg13_lv_nmos ad=0.13605p pd=1.25u as=0.1632p ps=1.64u w=0.48u l=0.13u
X103 VSS a_4132_308# WL<3> VSS sg13_lv_nmos ad=0.16625p pd=1.255u as=0.16625p ps=1.255u w=0.875u l=0.13u
X104 WL<9> a_3175_936# VSS VSS sg13_lv_nmos ad=0.16625p pd=1.255u as=0.2975p ps=2.43u w=0.875u l=0.13u
X105 WL<13> a_5458_308# a_5419_2100# VDD sg13_lv_pmos ad=0.5508p pd=3.92u as=0.3078p ps=2u w=1.62u l=0.13u
X106 a_2359_2616# a_1849_2685# VDD VDD sg13_lv_pmos ad=0.5508p pd=3.92u as=0.5508p ps=3.92u w=1.62u l=0.13u
X107 a_5419_420# a_5356_308# a_5317_420# VDD sg13_lv_pmos ad=0.3078p pd=2u as=0.3078p ps=2u w=1.62u l=0.13u
X108 a_4909_420# a_5253_308# VDD VDD sg13_lv_pmos ad=0.3078p pd=2u as=0.5508p ps=3.92u w=1.62u l=0.13u
X109 VSS a_3724_308# WL<2> VSS sg13_lv_nmos ad=0.16625p pd=1.255u as=0.16625p ps=1.255u w=0.875u l=0.13u
X110 a_2027_1740# a_1849_1778# VDD VDD sg13_lv_pmos ad=0.1632p pd=1.64u as=91.2f ps=0.86u w=0.48u l=0.13u
X111 WL<6> a_5253_2956# VSS VSS sg13_lv_nmos ad=0.16625p pd=1.255u as=0.2975p ps=2.43u w=0.875u l=0.13u
X112 a_2027_2647# a_1849_2685# VDD VDD sg13_lv_pmos ad=0.1632p pd=1.64u as=91.2f ps=0.86u w=0.48u l=0.13u
X113 a_4132_308# a_2359_98# a_2767_1778# VSS sg13_lv_nmos ad=0.3332p pd=2.64u as=0.1862p ps=1.36u w=0.98u l=0.13u
X114 a_2767_1386# a_2563_936# VSS VSS sg13_lv_nmos ad=0.1862p pd=1.36u as=0.3332p ps=2.64u w=0.98u l=0.13u
X115 VDD a_4407_98# a_4445_278# VDD sg13_lv_pmos ad=0.5508p pd=3.92u as=0.3078p ps=2u w=1.62u l=0.385u
X116 a_3111_308# a_3111_1988# VSS VSS sg13_lv_nmos ad=0.3332p pd=2.64u as=0.3332p ps=2.64u w=0.98u l=0.13u
X117 a_1951_1408# a_1551_1005# a_1849_1005# VSS sg13_lv_nmos ad=91.2f pd=0.86u as=0.13605p ps=1.25u w=0.48u l=0.13u
X118 a_1849_1005# a_1551_1005# a_1747_1005# VDD sg13_lv_pmos ad=0.14887p pd=1.355u as=0.18525p ps=1.355u w=0.975u l=0.13u
X119 a_1951_518# CS a_1849_98# VDD sg13_lv_pmos ad=91.2f pd=0.86u as=0.14887p ps=1.355u w=0.48u l=0.13u
X120 a_3685_2616# a_5253_2956# VDD VDD sg13_lv_pmos ad=0.3078p pd=2u as=0.5508p ps=3.92u w=1.62u l=0.13u
X121 a_4132_308# a_2359_936# VDD VDD sg13_lv_pmos ad=0.3078p pd=2u as=0.5508p ps=3.92u w=1.62u l=0.13u
X122 WL<1> a_5458_308# a_5419_420# VDD sg13_lv_pmos ad=0.5508p pd=3.92u as=0.3078p ps=2u w=1.62u l=0.13u
X123 WL<8> a_5458_308# a_5011_936# VDD sg13_lv_pmos ad=0.5508p pd=3.92u as=0.3078p ps=2u w=1.62u l=0.13u
X124 VDD a_2563_2616# a_5253_2956# VDD sg13_lv_pmos ad=0.3078p pd=2u as=0.3078p ps=2u w=1.62u l=0.13u
X125 a_5011_420# a_4948_308# a_4909_420# VDD sg13_lv_pmos ad=0.3078p pd=2u as=0.3078p ps=2u w=1.62u l=0.13u
X126 a_2563_98# a_2359_98# VSS VSS sg13_lv_nmos ad=0.3332p pd=2.64u as=0.3332p ps=2.64u w=0.98u l=0.13u
X127 WL<10> a_5458_308# VSS VSS sg13_lv_nmos ad=0.2975p pd=2.43u as=0.16625p ps=1.255u w=0.875u l=0.13u
X128 WL<4> a_5253_2956# VSS VSS sg13_lv_nmos ad=0.16625p pd=1.255u as=0.2975p ps=2.43u w=0.875u l=0.13u
X129 VSS a_3724_308# WL<14> VSS sg13_lv_nmos ad=0.16625p pd=1.255u as=0.16625p ps=1.255u w=0.875u l=0.13u
X130 a_3175_1778# a_3111_1988# VSS VSS sg13_lv_nmos ad=0.1862p pd=1.36u as=0.3332p ps=2.64u w=0.98u l=0.13u
X131 a_3175_936# CS a_3277_1386# VSS sg13_lv_nmos ad=0.3332p pd=2.64u as=0.1862p ps=1.36u w=0.98u l=0.13u
X132 a_4909_2616# a_5253_2956# VDD VDD sg13_lv_pmos ad=0.3078p pd=2u as=0.5508p ps=3.92u w=1.62u l=0.13u
X133 a_3277_98# a_2563_2616# a_3175_98# VSS sg13_lv_nmos ad=0.1862p pd=1.36u as=0.1862p ps=1.36u w=0.98u l=0.13u
X134 VDD ECLK_L_BOT a_5458_308# VDD sg13_lv_pmos ad=0.5508p pd=3.92u as=0.5508p ps=3.92u w=1.62u l=0.13u
X135 a_5253_1988# CS VDD VDD sg13_lv_pmos ad=0.5508p pd=3.92u as=0.3078p ps=2u w=1.62u l=0.13u
X136 a_5317_936# a_3175_936# VDD VDD sg13_lv_pmos ad=0.3078p pd=2u as=0.5508p ps=3.92u w=1.62u l=0.13u
X137 VSS a_4132_308# WL<11> VSS sg13_lv_nmos ad=0.16625p pd=1.255u as=0.16625p ps=1.255u w=0.875u l=0.13u
X138 a_1849_1778# a_1551_1778# a_1747_2160# VDD sg13_lv_pmos ad=0.14887p pd=1.355u as=0.18525p ps=1.355u w=0.975u l=0.13u
X139 WL<5> a_5458_308# VSS VSS sg13_lv_nmos ad=0.2975p pd=2.43u as=0.16625p ps=1.255u w=0.875u l=0.13u
X140 a_5011_2100# a_4948_308# a_4909_2100# VDD sg13_lv_pmos ad=0.3078p pd=2u as=0.3078p ps=2u w=1.62u l=0.13u
X141 VSS a_2027_1740# a_1951_1856# VSS sg13_lv_nmos ad=91.2f pd=0.86u as=91.2f ps=0.86u w=0.48u l=0.13u
X142 WL<15> a_5253_1988# VSS VSS sg13_lv_nmos ad=0.16625p pd=1.255u as=0.2975p ps=2.43u w=0.875u l=0.13u
X143 ECLK_L_BOT ECLK_H_BOT VDD VDD sg13_lv_pmos ad=0.5508p pd=3.92u as=0.5508p ps=3.92u w=1.62u l=0.13u
X144 WL<3> a_5458_308# VSS VSS sg13_lv_nmos ad=0.2975p pd=2.43u as=0.16625p ps=1.255u w=0.875u l=0.13u
X145 WL<5> a_5458_308# a_5419_2616# VDD sg13_lv_pmos ad=0.5508p pd=3.92u as=0.3078p ps=2u w=1.62u l=0.13u
X146 a_1951_2746# CS a_1849_2685# VDD sg13_lv_pmos ad=91.2f pd=0.86u as=0.14887p ps=1.355u w=0.48u l=0.13u
X147 a_1951_2198# CS a_1849_1778# VDD sg13_lv_pmos ad=91.2f pd=0.86u as=0.14887p ps=1.355u w=0.48u l=0.13u
X148 WL<15> a_5458_308# a_4195_2100# VDD sg13_lv_pmos ad=0.5508p pd=3.92u as=0.3078p ps=2u w=1.62u l=0.13u
X149 a_4407_98# a_4445_278# VSS VSS sg13_lv_nmos ad=0.1577p pd=1.21u as=0.1577p ps=1.21u w=0.83u l=0.13u
X150 a_5419_936# a_5356_308# a_5317_936# VDD sg13_lv_pmos ad=0.3078p pd=2u as=0.3078p ps=2u w=1.62u l=0.13u
X151 a_4909_936# a_3175_936# VDD VDD sg13_lv_pmos ad=0.3078p pd=2u as=0.5508p ps=3.92u w=1.62u l=0.13u
X152 VSS a_5356_308# WL<9> VSS sg13_lv_nmos ad=0.16625p pd=1.255u as=0.16625p ps=1.255u w=0.875u l=0.13u
X153 WL<8> a_5458_308# VSS VSS sg13_lv_nmos ad=0.2975p pd=2.43u as=0.16625p ps=1.255u w=0.875u l=0.13u
X154 WL<13> a_5253_1988# VSS VSS sg13_lv_nmos ad=0.16625p pd=1.255u as=0.2975p ps=2.43u w=0.875u l=0.13u
X155 WL<1> a_5253_308# VSS VSS sg13_lv_nmos ad=0.16625p pd=1.255u as=0.2975p ps=2.43u w=0.875u l=0.13u
X156 a_3724_308# a_2359_936# VDD VDD sg13_lv_pmos ad=0.3078p pd=2u as=0.5508p ps=3.92u w=1.62u l=0.13u
X157 WL<9> a_5458_308# a_5419_936# VDD sg13_lv_pmos ad=0.5508p pd=3.92u as=0.3078p ps=2u w=1.62u l=0.13u
X158 a_1747_3088# ADDR<3> VSS VSS sg13_lv_nmos ad=0.1653p pd=1.25u as=0.13605p ps=1.25u w=0.87u l=0.13u
X159 a_2359_2616# a_1849_2685# VSS VSS sg13_lv_nmos ad=0.3332p pd=2.64u as=0.3332p ps=2.64u w=0.98u l=0.13u
X160 a_5011_936# a_4948_308# a_4909_936# VDD sg13_lv_pmos ad=0.3078p pd=2u as=0.3078p ps=2u w=1.62u l=0.13u
X161 a_2359_98# a_1849_98# VDD VDD sg13_lv_pmos ad=0.5508p pd=3.92u as=0.5508p ps=3.92u w=1.62u l=0.13u
X162 a_2563_936# a_2359_936# VSS VSS sg13_lv_nmos ad=0.3332p pd=2.64u as=0.3332p ps=2.64u w=0.98u l=0.13u
X163 a_5356_308# a_2359_98# a_2767_1386# VSS sg13_lv_nmos ad=0.3332p pd=2.64u as=0.1862p ps=1.36u w=0.98u l=0.13u
X164 VDD CS a_1551_1005# VDD sg13_lv_pmos ad=0.14812p pd=1.355u as=0.1632p ps=1.64u w=0.48u l=0.13u
X165 WL<3> a_5253_308# VSS VSS sg13_lv_nmos ad=0.16625p pd=1.255u as=0.2975p ps=2.43u w=0.875u l=0.13u
X166 VDD a_2359_98# a_4132_308# VDD sg13_lv_pmos ad=0.5508p pd=3.92u as=0.3078p ps=2u w=1.62u l=0.13u
X167 a_3111_308# a_3111_1988# VDD VDD sg13_lv_pmos ad=0.5508p pd=3.92u as=0.5508p ps=3.92u w=1.62u l=0.13u
X168 a_5253_2956# CS VDD VDD sg13_lv_pmos ad=0.5508p pd=3.92u as=0.3078p ps=2u w=1.62u l=0.13u
X169 VSS a_2027_2647# a_1951_3088# VSS sg13_lv_nmos ad=91.2f pd=0.86u as=91.2f ps=0.86u w=0.48u l=0.13u
X170 a_3277_3066# a_2563_2616# a_3175_3066# VSS sg13_lv_nmos ad=0.1862p pd=1.36u as=0.1862p ps=1.36u w=0.98u l=0.13u
X171 WL<10> a_3175_936# VSS VSS sg13_lv_nmos ad=0.16625p pd=1.255u as=0.2975p ps=2.43u w=0.875u l=0.13u
X172 VSS a_4948_308# WL<4> VSS sg13_lv_nmos ad=0.16625p pd=1.255u as=0.16625p ps=1.255u w=0.875u l=0.13u
X173 WL<14> a_5458_308# VSS VSS sg13_lv_nmos ad=0.2975p pd=2.43u as=0.16625p ps=1.255u w=0.875u l=0.13u
X174 WL<0> a_5458_308# VSS VSS sg13_lv_nmos ad=0.2975p pd=2.43u as=0.16625p ps=1.255u w=0.875u l=0.13u
X175 a_3175_1386# a_3111_308# VSS VSS sg13_lv_nmos ad=0.1862p pd=1.36u as=0.3332p ps=2.64u w=0.98u l=0.13u
X176 WL<7> a_5458_308# VSS VSS sg13_lv_nmos ad=0.2975p pd=2.43u as=0.16625p ps=1.255u w=0.875u l=0.13u
X177 a_5011_2616# a_4948_308# a_4909_2616# VDD sg13_lv_pmos ad=0.3078p pd=2u as=0.3078p ps=2u w=1.62u l=0.13u
X178 VDD ECLK_L_BOT a_5458_308# VDD sg13_lv_pmos ad=0.5508p pd=3.92u as=0.5508p ps=3.92u w=1.62u l=0.13u
X179 a_3787_2100# a_3724_308# a_3685_2100# VDD sg13_lv_pmos ad=0.3078p pd=2u as=0.3078p ps=2u w=1.62u l=0.13u
X180 VDD a_2027_967# a_1951_1066# VDD sg13_lv_pmos ad=91.2f pd=0.86u as=91.2f ps=0.86u w=0.48u l=0.13u
X181 VSS CS a_1551_2685# VSS sg13_lv_nmos ad=0.13605p pd=1.25u as=0.1632p ps=1.64u w=0.48u l=0.13u
X182 a_1747_480# ADDR<0> VDD VDD sg13_lv_pmos ad=0.18525p pd=1.355u as=0.14812p ps=1.355u w=0.975u l=0.13u
X183 VSS ECLK_L_BOT a_5458_308# VSS sg13_lv_nmos ad=0.2397p pd=2.09u as=0.2397p ps=2.09u w=0.705u l=0.13u
X184 WL<7> a_5458_308# a_4195_2616# VDD sg13_lv_pmos ad=0.5508p pd=3.92u as=0.3078p ps=2u w=1.62u l=0.13u
X185 a_5253_1988# a_3111_1988# VDD VDD sg13_lv_pmos ad=0.3078p pd=2u as=0.5508p ps=3.92u w=1.62u l=0.13u
X186 a_2563_98# a_2359_98# VDD VDD sg13_lv_pmos ad=0.5508p pd=3.92u as=0.5508p ps=3.92u w=1.62u l=0.13u
X187 WL<8> a_3175_936# VSS VSS sg13_lv_nmos ad=0.16625p pd=1.255u as=0.2975p ps=2.43u w=0.875u l=0.13u
X188 VSS a_4132_308# WL<15> VSS sg13_lv_nmos ad=0.16625p pd=1.255u as=0.16625p ps=1.255u w=0.875u l=0.13u
X189 VDD CS a_1551_98# VDD sg13_lv_pmos ad=0.14812p pd=1.355u as=0.1632p ps=1.64u w=0.48u l=0.13u
X190 a_2027_1740# a_1849_1778# VSS VSS sg13_lv_nmos ad=0.1632p pd=1.64u as=91.2f ps=0.86u w=0.48u l=0.13u
X191 VSS a_4948_308# WL<0> VSS sg13_lv_nmos ad=0.16625p pd=1.255u as=0.16625p ps=1.255u w=0.875u l=0.13u
R1 ECLK_L_TOP ECLK_L_BOT 0.203077
X192 a_1849_98# a_1551_98# a_1747_480# VDD sg13_lv_pmos ad=0.14887p pd=1.355u as=0.18525p ps=1.355u w=0.975u l=0.13u
X193 a_5253_308# a_3111_308# VDD VDD sg13_lv_pmos ad=0.3078p pd=2u as=0.5508p ps=3.92u w=1.62u l=0.13u
X194 a_4093_2100# a_5253_1988# VDD VDD sg13_lv_pmos ad=0.3078p pd=2u as=0.5508p ps=3.92u w=1.62u l=0.13u
X195 a_1747_2685# ADDR<3> VDD VDD sg13_lv_pmos ad=0.18525p pd=1.355u as=0.14812p ps=1.355u w=0.975u l=0.13u
X196 WL<9> a_5458_308# VSS VSS sg13_lv_nmos ad=0.2975p pd=2.43u as=0.16625p ps=1.255u w=0.875u l=0.13u
X197 VDD CS a_1551_1778# VDD sg13_lv_pmos ad=0.14812p pd=1.355u as=0.1632p ps=1.64u w=0.48u l=0.13u
X198 VDD a_2563_2616# a_5253_308# VDD sg13_lv_pmos ad=0.3078p pd=2u as=0.3078p ps=2u w=1.62u l=0.13u
X199 a_4948_308# a_2563_936# VDD VDD sg13_lv_pmos ad=0.3078p pd=2u as=0.5508p ps=3.92u w=1.62u l=0.13u
X200 a_2359_936# a_1849_1005# VDD VDD sg13_lv_pmos ad=0.5508p pd=3.92u as=0.5508p ps=3.92u w=1.62u l=0.13u
X201 a_1747_1778# ADDR<2> VSS VSS sg13_lv_nmos ad=0.1653p pd=1.25u as=0.13605p ps=1.25u w=0.87u l=0.13u
X202 VSS a_5356_308# WL<13> VSS sg13_lv_nmos ad=0.16625p pd=1.255u as=0.16625p ps=1.255u w=0.875u l=0.13u
X203 WL<12> a_5458_308# VSS VSS sg13_lv_nmos ad=0.2975p pd=2.43u as=0.16625p ps=1.255u w=0.875u l=0.13u
X204 VDD a_2563_98# a_3724_308# VDD sg13_lv_pmos ad=0.5508p pd=3.92u as=0.3078p ps=2u w=1.62u l=0.13u
X205 a_1849_2685# CS a_1747_3088# VSS sg13_lv_nmos ad=0.13605p pd=1.25u as=0.1653p ps=1.25u w=0.87u l=0.13u
X206 a_2767_3066# a_2359_936# VSS VSS sg13_lv_nmos ad=0.1862p pd=1.36u as=0.3332p ps=2.64u w=0.98u l=0.13u
X207 a_2563_2616# a_2359_2616# VDD VDD sg13_lv_pmos ad=0.5508p pd=3.92u as=0.5508p ps=3.92u w=1.62u l=0.13u
X208 a_5317_2100# a_5253_1988# VDD VDD sg13_lv_pmos ad=0.3078p pd=2u as=0.5508p ps=3.92u w=1.62u l=0.13u
X209 a_5253_308# CS VDD VDD sg13_lv_pmos ad=0.5508p pd=3.92u as=0.3078p ps=2u w=1.62u l=0.13u
X210 VDD a_2563_98# a_4948_308# VDD sg13_lv_pmos ad=0.5508p pd=3.92u as=0.3078p ps=2u w=1.62u l=0.13u
.ends

.subckt RM_IHPSG13_1P_DEC02 CS ADDR<1> ADDR<0> CS_OUT VDD VSS
X0 a_931_98# ADDR<1> VSS VSS sg13_lv_nmos ad=0.1862p pd=1.36u as=0.3332p ps=2.64u w=0.98u l=0.13u
X1 CS_OUT a_931_420# VSS VSS sg13_lv_nmos ad=0.1862p pd=1.36u as=0.3332p ps=2.64u w=0.98u l=0.13u
X2 a_931_420# ADDR<1> VDD VDD sg13_lv_pmos ad=0.3078p pd=2u as=0.5508p ps=3.92u w=1.62u l=0.13u
X3 a_931_420# CS a_1033_98# VSS sg13_lv_nmos ad=0.3332p pd=2.64u as=0.1862p ps=1.36u w=0.98u l=0.13u
X4 VDD a_523_98# a_931_420# VDD sg13_lv_pmos ad=0.3078p pd=2u as=0.3078p ps=2u w=1.62u l=0.13u
X5 a_931_420# CS VDD VDD sg13_lv_pmos ad=0.5508p pd=3.92u as=0.3078p ps=2u w=1.62u l=0.13u
X6 CS_OUT a_931_420# VDD VDD sg13_lv_pmos ad=0.3078p pd=2u as=0.5508p ps=3.92u w=1.62u l=0.13u
X7 VSS a_59_278# a_21_98# VSS sg13_lv_nmos ad=0.2822p pd=2.34u as=0.1577p ps=1.21u w=0.83u l=0.13u
X8 VDD a_931_420# CS_OUT VDD sg13_lv_pmos ad=0.5508p pd=3.92u as=0.3078p ps=2u w=1.62u l=0.13u
X9 a_1033_98# a_523_98# a_931_98# VSS sg13_lv_nmos ad=0.1862p pd=1.36u as=0.1862p ps=1.36u w=0.98u l=0.13u
X10 VDD a_21_98# a_59_278# VDD sg13_lv_pmos ad=0.5508p pd=3.92u as=0.3078p ps=2u w=1.62u l=0.385u
X11 a_523_98# ADDR<0> VDD VDD sg13_lv_pmos ad=0.5508p pd=3.92u as=0.5508p ps=3.92u w=1.62u l=0.13u
X12 a_21_98# a_59_278# VSS VSS sg13_lv_nmos ad=0.1577p pd=1.21u as=0.1577p ps=1.21u w=0.83u l=0.13u
X13 VSS a_931_420# CS_OUT VSS sg13_lv_nmos ad=0.3332p pd=2.64u as=0.1862p ps=1.36u w=0.98u l=0.13u
X14 a_523_98# ADDR<0> VSS VSS sg13_lv_nmos ad=0.3332p pd=2.64u as=0.3332p ps=2.64u w=0.98u l=0.13u
X15 VSS a_59_278# a_21_98# VSS sg13_lv_nmos ad=0.1577p pd=1.21u as=0.2822p ps=2.34u w=0.83u l=0.13u
X16 a_59_278# a_21_98# VDD VDD sg13_lv_pmos ad=0.3078p pd=2u as=0.5508p ps=3.92u w=1.62u l=0.385u
.ends

.subckt RM_IHPSG13_1P_DEC00 ADDR<0> ADDR<1> CS VSS VDD CS_OUT
X0 a_931_98# a_727_98# VSS VSS sg13_lv_nmos ad=0.1862p pd=1.36u as=0.3332p ps=2.64u w=0.98u l=0.13u
X1 a_727_98# ADDR<1> VDD VDD sg13_lv_pmos ad=0.5508p pd=3.92u as=0.5508p ps=3.92u w=1.62u l=0.13u
X2 CS_OUT a_931_420# VSS VSS sg13_lv_nmos ad=0.1862p pd=1.36u as=0.3332p ps=2.64u w=0.98u l=0.13u
X3 a_931_420# a_727_98# VDD VDD sg13_lv_pmos ad=0.3078p pd=2u as=0.5508p ps=3.92u w=1.62u l=0.13u
X4 a_931_420# CS a_1033_98# VSS sg13_lv_nmos ad=0.3332p pd=2.64u as=0.1862p ps=1.36u w=0.98u l=0.13u
X5 VDD a_523_98# a_931_420# VDD sg13_lv_pmos ad=0.3078p pd=2u as=0.3078p ps=2u w=1.62u l=0.13u
X6 a_931_420# CS VDD VDD sg13_lv_pmos ad=0.5508p pd=3.92u as=0.3078p ps=2u w=1.62u l=0.13u
X7 CS_OUT a_931_420# VDD VDD sg13_lv_pmos ad=0.3078p pd=2u as=0.5508p ps=3.92u w=1.62u l=0.13u
X8 VSS a_59_278# a_21_98# VSS sg13_lv_nmos ad=0.2822p pd=2.34u as=0.1577p ps=1.21u w=0.83u l=0.13u
X9 VDD a_931_420# CS_OUT VDD sg13_lv_pmos ad=0.5508p pd=3.92u as=0.3078p ps=2u w=1.62u l=0.13u
X10 a_1033_98# a_523_98# a_931_98# VSS sg13_lv_nmos ad=0.1862p pd=1.36u as=0.1862p ps=1.36u w=0.98u l=0.13u
X11 a_727_98# ADDR<1> VSS VSS sg13_lv_nmos ad=0.3332p pd=2.64u as=0.3332p ps=2.64u w=0.98u l=0.13u
X12 VDD a_21_98# a_59_278# VDD sg13_lv_pmos ad=0.5508p pd=3.92u as=0.3078p ps=2u w=1.62u l=0.385u
X13 a_523_98# ADDR<0> VDD VDD sg13_lv_pmos ad=0.5508p pd=3.92u as=0.5508p ps=3.92u w=1.62u l=0.13u
X14 a_21_98# a_59_278# VSS VSS sg13_lv_nmos ad=0.1577p pd=1.21u as=0.1577p ps=1.21u w=0.83u l=0.13u
X15 VSS a_931_420# CS_OUT VSS sg13_lv_nmos ad=0.3332p pd=2.64u as=0.1862p ps=1.36u w=0.98u l=0.13u
X16 a_523_98# ADDR<0> VSS VSS sg13_lv_nmos ad=0.3332p pd=2.64u as=0.3332p ps=2.64u w=0.98u l=0.13u
X17 VSS a_59_278# a_21_98# VSS sg13_lv_nmos ad=0.1577p pd=1.21u as=0.2822p ps=2.34u w=0.83u l=0.13u
X18 a_59_278# a_21_98# VDD VDD sg13_lv_pmos ad=0.3078p pd=2u as=0.5508p ps=3.92u w=1.62u l=0.385u
.ends

.subckt RM_IHPSG13_1P_DEC03 CS ADDR<1> ADDR<0> CS_OUT VDD VSS
X0 a_931_98# ADDR<1> VSS VSS sg13_lv_nmos ad=0.1862p pd=1.36u as=0.3332p ps=2.64u w=0.98u l=0.13u
X1 CS_OUT a_931_420# VSS VSS sg13_lv_nmos ad=0.1862p pd=1.36u as=0.3332p ps=2.64u w=0.98u l=0.13u
X2 a_931_420# ADDR<1> VDD VDD sg13_lv_pmos ad=0.3078p pd=2u as=0.5508p ps=3.92u w=1.62u l=0.13u
X3 a_931_420# CS a_1033_98# VSS sg13_lv_nmos ad=0.3332p pd=2.64u as=0.1862p ps=1.36u w=0.98u l=0.13u
X4 VDD ADDR<0> a_931_420# VDD sg13_lv_pmos ad=0.3078p pd=2u as=0.3078p ps=2u w=1.62u l=0.13u
X5 a_931_420# CS VDD VDD sg13_lv_pmos ad=0.5508p pd=3.92u as=0.3078p ps=2u w=1.62u l=0.13u
X6 CS_OUT a_931_420# VDD VDD sg13_lv_pmos ad=0.3078p pd=2u as=0.5508p ps=3.92u w=1.62u l=0.13u
X7 VSS a_59_278# a_21_98# VSS sg13_lv_nmos ad=0.2822p pd=2.34u as=0.1577p ps=1.21u w=0.83u l=0.13u
X8 VDD a_931_420# CS_OUT VDD sg13_lv_pmos ad=0.5508p pd=3.92u as=0.3078p ps=2u w=1.62u l=0.13u
X9 a_1033_98# ADDR<0> a_931_98# VSS sg13_lv_nmos ad=0.1862p pd=1.36u as=0.1862p ps=1.36u w=0.98u l=0.13u
X10 VDD a_21_98# a_59_278# VDD sg13_lv_pmos ad=0.5508p pd=3.92u as=0.3078p ps=2u w=1.62u l=0.385u
X11 a_21_98# a_59_278# VSS VSS sg13_lv_nmos ad=0.1577p pd=1.21u as=0.1577p ps=1.21u w=0.83u l=0.13u
X12 VSS a_931_420# CS_OUT VSS sg13_lv_nmos ad=0.3332p pd=2.64u as=0.1862p ps=1.36u w=0.98u l=0.13u
X13 VSS a_59_278# a_21_98# VSS sg13_lv_nmos ad=0.1577p pd=1.21u as=0.2822p ps=2.34u w=0.83u l=0.13u
X14 a_59_278# a_21_98# VDD VDD sg13_lv_pmos ad=0.3078p pd=2u as=0.5508p ps=3.92u w=1.62u l=0.385u
.ends

.subckt RM_IHPSG13_1P_DEC01 CS ADDR<1> ADDR<0> CS_OUT VDD VSS
X0 a_931_98# a_727_98# VSS VSS sg13_lv_nmos ad=0.1862p pd=1.36u as=0.3332p ps=2.64u w=0.98u l=0.13u
X1 a_727_98# ADDR<1> VDD VDD sg13_lv_pmos ad=0.5508p pd=3.92u as=0.5508p ps=3.92u w=1.62u l=0.13u
X2 CS_OUT a_931_420# VSS VSS sg13_lv_nmos ad=0.1862p pd=1.36u as=0.3332p ps=2.64u w=0.98u l=0.13u
X3 a_931_420# a_727_98# VDD VDD sg13_lv_pmos ad=0.3078p pd=2u as=0.5508p ps=3.92u w=1.62u l=0.13u
X4 a_931_420# CS a_1033_98# VSS sg13_lv_nmos ad=0.3332p pd=2.64u as=0.1862p ps=1.36u w=0.98u l=0.13u
X5 VDD ADDR<0> a_931_420# VDD sg13_lv_pmos ad=0.3078p pd=2u as=0.3078p ps=2u w=1.62u l=0.13u
X6 a_931_420# CS VDD VDD sg13_lv_pmos ad=0.5508p pd=3.92u as=0.3078p ps=2u w=1.62u l=0.13u
X7 CS_OUT a_931_420# VDD VDD sg13_lv_pmos ad=0.3078p pd=2u as=0.5508p ps=3.92u w=1.62u l=0.13u
X8 VSS a_59_278# a_21_98# VSS sg13_lv_nmos ad=0.2822p pd=2.34u as=0.1577p ps=1.21u w=0.83u l=0.13u
X9 VDD a_931_420# CS_OUT VDD sg13_lv_pmos ad=0.5508p pd=3.92u as=0.3078p ps=2u w=1.62u l=0.13u
X10 a_1033_98# ADDR<0> a_931_98# VSS sg13_lv_nmos ad=0.1862p pd=1.36u as=0.1862p ps=1.36u w=0.98u l=0.13u
X11 a_727_98# ADDR<1> VSS VSS sg13_lv_nmos ad=0.3332p pd=2.64u as=0.3332p ps=2.64u w=0.98u l=0.13u
X12 VDD a_21_98# a_59_278# VDD sg13_lv_pmos ad=0.5508p pd=3.92u as=0.3078p ps=2u w=1.62u l=0.385u
X13 a_21_98# a_59_278# VSS VSS sg13_lv_nmos ad=0.1577p pd=1.21u as=0.1577p ps=1.21u w=0.83u l=0.13u
X14 VSS a_931_420# CS_OUT VSS sg13_lv_nmos ad=0.3332p pd=2.64u as=0.1862p ps=1.36u w=0.98u l=0.13u
X15 VSS a_59_278# a_21_98# VSS sg13_lv_nmos ad=0.1577p pd=1.21u as=0.2822p ps=2.34u w=0.83u l=0.13u
X16 a_59_278# a_21_98# VDD VDD sg13_lv_pmos ad=0.3078p pd=2u as=0.5508p ps=3.92u w=1.62u l=0.385u
.ends

.subckt RM_IHPSG13_1P_ROWDEC8 ADDR_N_I<7> ADDR_N_I<1> ADDR_N_I<0> ADDR_N_I<6> ADDR_N_I<5>
+ ADDR_N_I<3> ADDR_N_I<2> ADDR_N_I<4> CS_I ECLK_I WL_O<192> WL_O<193> WL_O<194> WL_O<195>
+ WL_O<200> WL_O<201> WL_O<202> WL_O<203> WL_O<204> WL_O<205> WL_O<206> WL_O<207>
+ WL_O<213> WL_O<214> WL_O<215> WL_O<216> WL_O<217> WL_O<230> WL_O<231> WL_O<232>
+ WL_O<233> WL_O<234> WL_O<235> WL_O<236> WL_O<237> WL_O<238> WL_O<239> WL_O<240>
+ WL_O<241> WL_O<242> WL_O<243> WL_O<244> WL_O<245> WL_O<246> WL_O<247> WL_O<132>
+ WL_O<133> WL_O<134> WL_O<135> WL_O<136> WL_O<137> WL_O<138> WL_O<139> WL_O<154>
+ WL_O<155> WL_O<156> WL_O<157> WL_O<158> WL_O<159> WL_O<170> WL_O<171> WL_O<172>
+ WL_O<173> WL_O<174> WL_O<175> WL_O<176> WL_O<177> WL_O<178> WL_O<185> WL_O<186>
+ WL_O<187> WL_O<188> WL_O<189> WL_O<190> WL_O<191> WL_O<70> WL_O<71> WL_O<72> WL_O<73>
+ WL_O<90> WL_O<100> WL_O<101> WL_O<109> WL_O<110> WL_O<111> WL_O<112> WL_O<113> WL_O<114>
+ WL_O<115> WL_O<116> WL_O<117> WL_O<118> WL_O<119> WL_O<10> WL_O<11> WL_O<12> WL_O<13>
+ WL_O<14> WL_O<15> WL_O<16> WL_O<17> WL_O<18> WL_O<19> WL_O<26> WL_O<27> WL_O<28>
+ WL_O<29> WL_O<30> WL_O<31> WL_O<32> WL_O<33> WL_O<34> WL_O<35> WL_O<36> WL_O<37>
+ WL_O<38> WL_O<39> WL_O<42> WL_O<43> WL_O<44> WL_O<45> WL_O<46> WL_O<47> WL_O<50>
+ WL_O<51> WL_O<52> WL_O<53> WL_O<54> WL_O<55> WL_O<56> RM_IHPSG13_1P_DEC_LE_tap_5/m3_0_3568#
+ WL_O<91> RM_IHPSG13_1P_DEC_LE_tap_6/m3_0_3568# WL_O<92> RM_IHPSG13_1P_DEC_LE_tap_0/m3_0_3364#
+ WL_O<93> WL_O<94> RM_IHPSG13_1P_DEC_LE_tap_10/m3_0_3364# WL_O<95> RM_IHPSG13_1P_DEC_LE_tap_7/m3_0_3568#
+ RM_IHPSG13_1P_DEC_LE_tap_1/m3_0_3364# RM_IHPSG13_1P_DEC_LE_tap_11/m3_0_3364# RM_IHPSG13_1P_DEC_LE_tap_8/m3_0_3568#
+ RM_IHPSG13_1P_DEC_LE_tap_2/m3_0_3364# RM_IHPSG13_1P_DEC_LE_tap_12/m3_0_3364# RM_IHPSG13_1P_DEC_LE_tap_9/m3_0_3568#
+ RM_IHPSG13_1P_DEC_LE_tap_3/m3_0_3364# WL_O<74> WL_O<75> RM_IHPSG13_1P_DEC_LE_tap_13/m3_0_3364#
+ WL_O<76> WL_O<77> RM_IHPSG13_1P_DEC_LE_tap_4/m3_0_3364# WL_O<96> WL_O<78> WL_O<97>
+ WL_O<48> WL_O<20> RM_IHPSG13_1P_DEC_LE_tap_14/m3_0_3364# WL_O<79> WL_O<98> RM_IHPSG13_1P_DEC_LE_tap_0/m3_0_3568#
+ WL_O<49> WL_O<21> RM_IHPSG13_1P_DEC_LE_tap_5/m3_0_3364# WL_O<99> WL_O<122> WL_O<22>
+ WL_O<64> WL_O<123> RM_IHPSG13_1P_DEC_LE_tap_10/m3_0_3568# WL_O<23> WL_O<65> WL_O<124>
+ WL_O<0> RM_IHPSG13_1P_DEC_LE_tap_1/m3_0_3568# WL_O<24> WL_O<66> WL_O<102> WL_O<1>
+ WL_O<125> RM_IHPSG13_1P_DEC_LE_tap_6/m3_0_3364# WL_O<25> WL_O<80> WL_O<40> WL_O<67>
+ WL_O<103> WL_O<2> WL_O<126> RM_IHPSG13_1P_DEC_LE_tap_11/m3_0_3568# WL_O<81> WL_O<41>
+ WL_O<68> WL_O<104> WL_O<127> WL_O<3> WL_O<140> WL_O<82> RM_IHPSG13_1P_DEC_LE_tap_2/m3_0_3568#
+ WL_O<160> WL_O<69> WL_O<144> WL_O<105> WL_O<4> WL_O<141> WL_O<83> WL_O<58> RM_IHPSG13_1P_DEC_LE_tap_7/m3_0_3364#
+ WL_O<161> WL_O<145> WL_O<5> WL_O<142> WL_O<57> WL_O<84> WL_O<59> WL_O<120> RM_IHPSG13_1P_DEC_LE_tap_12/m3_0_3568#
+ WL_O<162> WL_O<146> WL_O<6> WL_O<143> WL_O<85> WL_O<121> WL_O<60> WL_O<163> WL_O<147>
+ RM_IHPSG13_1P_DEC_LE_tap_3/m3_0_3568# WL_O<7> WL_O<86> WL_O<61> WL_O<224> WL_O<218>
+ WL_O<164> RM_IHPSG13_1P_DEC_LE_tap_8/m3_0_3364# WL_O<148> WL_O<179> WL_O<8> WL_O<87>
+ WL_O<250> WL_O<62> WL_O<225> WL_O<219> WL_O<165> WL_O<208> RM_IHPSG13_1P_DEC_LE_tap_13/m3_0_3568#
+ WL_O<149> WL_O<180> WL_O<9> WL_O<88> WL_O<251> WL_O<63> WL_O<226> WL_O<220> WL_O<166>
+ WL_O<209> WL_O<150> WL_O<181> WL_O<128> RM_IHPSG13_1P_DEC_LE_tap_4/m3_0_3568# WL_O<196>
+ WL_O<89> WL_O<252> WL_O<227> WL_O<221> WL_O<248> WL_O<167> WL_O<210> WL_O<151> WL_O<106>
+ WL_O<182> RM_IHPSG13_1P_DEC_LE_tap_9/m3_0_3364# WL_O<129> WL_O<197> WL_O<253> WL_O<228>
+ WL_O<222> WL_O<249> WL_O<168> WL_O<211> WL_O<152> WL_O<107> WL_O<183> WL_O<130>
+ RM_IHPSG13_1P_DEC_LE_tap_14/m3_0_3568# WL_O<198> WL_O<254> WL_O<229> WL_O<223> WL_O<169>
+ WL_O<212> WL_O<153> WL_O<108> WL_O<184> VDD WL_O<131> WL_O<199> WL_O<255> VSS
XRM_IHPSG13_1P_DEC_LE_l1empty_6 RM_IHPSG13_1P_DEC03_3/CS VDD VSS RM_IHPSG13_1P_DEC_LE_l1empty
XRM_IHPSG13_1P_DEC_LE_l2empty_11 VDD CS_I VSS RM_IHPSG13_1P_DEC_LE_l2empty
XRM_IHPSG13_1P_DEC_LE_l2empty_0 VDD CS_I VSS RM_IHPSG13_1P_DEC_LE_l2empty
XRM_IHPSG13_1P_DEC_LE_l1empty_7 RM_IHPSG13_1P_DEC03_4/CS VDD VSS RM_IHPSG13_1P_DEC_LE_l1empty
XRM_IHPSG13_1P_DEC_LE_l2empty_12 VDD CS_I VSS RM_IHPSG13_1P_DEC_LE_l2empty
XRM_IHPSG13_1P_DEC_LE_l2empty_1 VDD CS_I VSS RM_IHPSG13_1P_DEC_LE_l2empty
XRM_IHPSG13_1P_DEC_LE_l1empty_8 RM_IHPSG13_1P_DEC03_4/CS VDD VSS RM_IHPSG13_1P_DEC_LE_l1empty
XRM_IHPSG13_1P_DEC_LE_l2empty_13 VDD CS_I VSS RM_IHPSG13_1P_DEC_LE_l2empty
XRM_IHPSG13_1P_DEC_LE_l2empty_2 VDD CS_I VSS RM_IHPSG13_1P_DEC_LE_l2empty
XRM_IHPSG13_1P_DEC_LE_l1empty_9 RM_IHPSG13_1P_DEC03_4/CS VDD VSS RM_IHPSG13_1P_DEC_LE_l1empty
XRM_IHPSG13_1P_DEC_LE_l2empty_14 VDD CS_I VSS RM_IHPSG13_1P_DEC_LE_l2empty
XRM_IHPSG13_1P_DEC_LE_l2empty_3 VDD CS_I VSS RM_IHPSG13_1P_DEC_LE_l2empty
XRM_IHPSG13_1P_DEC04_0 ADDR_N_I<0> ADDR_N_I<1> ADDR_N_I<2> ADDR_N_I<3> RM_IHPSG13_1P_DEC04_6/ECLK_L_TOP
+ RM_IHPSG13_1P_DEC04_6/ECLK_H_TOP RM_IHPSG13_1P_DEC04_1/ECLK_H_BOT RM_IHPSG13_1P_DEC04_1/ECLK_L_BOT
+ RM_IHPSG13_1P_DEC04_0/CS WL_O<31> WL_O<30> WL_O<29> WL_O<28> WL_O<27> WL_O<26> WL_O<25>
+ WL_O<24> WL_O<23> WL_O<22> WL_O<21> WL_O<20> WL_O<19> WL_O<18> WL_O<17> WL_O<16>
+ VSS VDD RM_IHPSG13_1P_DEC04_9/m2_1382_0# ADDR_N_I<7> ADDR_N_I<5> ADDR_N_I<6> RM_IHPSG13_1P_DEC04_9/m2_56_840#
+ ADDR_N_I<4> RM_IHPSG13_1P_DEC04_9/m2_158_840# RM_IHPSG13_1P_DEC04
XRM_IHPSG13_1P_DEC_LE_l2empty_4 VDD CS_I VSS RM_IHPSG13_1P_DEC_LE_l2empty
XRM_IHPSG13_1P_DEC04_1 ADDR_N_I<0> ADDR_N_I<1> ADDR_N_I<2> ADDR_N_I<3> RM_IHPSG13_1P_DEC04_1/ECLK_L_BOT
+ RM_IHPSG13_1P_DEC04_1/ECLK_H_BOT RM_IHPSG13_1P_DEC04_3/ECLK_H_BOT RM_IHPSG13_1P_DEC04_3/ECLK_L_BOT
+ RM_IHPSG13_1P_DEC04_1/CS WL_O<47> WL_O<46> WL_O<45> WL_O<44> WL_O<43> WL_O<42> WL_O<41>
+ WL_O<40> WL_O<39> WL_O<38> WL_O<37> WL_O<36> WL_O<35> WL_O<34> WL_O<33> WL_O<32>
+ VSS VDD RM_IHPSG13_1P_DEC04_9/m2_1382_0# ADDR_N_I<7> ADDR_N_I<5> ADDR_N_I<6> RM_IHPSG13_1P_DEC04_9/m2_56_840#
+ ADDR_N_I<4> RM_IHPSG13_1P_DEC04_9/m2_158_840# RM_IHPSG13_1P_DEC04
XRM_IHPSG13_1P_DEC_LE_l2empty_5 VDD CS_I VSS RM_IHPSG13_1P_DEC_LE_l2empty
XRM_IHPSG13_1P_DEC04_2 ADDR_N_I<0> ADDR_N_I<1> ADDR_N_I<2> ADDR_N_I<3> RM_IHPSG13_1P_DEC04_7/ECLK_L_TOP
+ RM_IHPSG13_1P_DEC04_7/ECLK_H_TOP RM_IHPSG13_1P_DEC04_4/ECLK_H_BOT RM_IHPSG13_1P_DEC04_4/ECLK_L_BOT
+ RM_IHPSG13_1P_DEC04_2/CS WL_O<111> WL_O<110> WL_O<109> WL_O<108> WL_O<107> WL_O<106>
+ WL_O<105> WL_O<104> WL_O<103> WL_O<102> WL_O<101> WL_O<100> WL_O<99> WL_O<98> WL_O<97>
+ WL_O<96> VSS VDD RM_IHPSG13_1P_DEC04_9/m2_1382_0# ADDR_N_I<7> ADDR_N_I<5> ADDR_N_I<6>
+ RM_IHPSG13_1P_DEC04_9/m2_56_840# ADDR_N_I<4> RM_IHPSG13_1P_DEC04_9/m2_158_840# RM_IHPSG13_1P_DEC04
XRM_IHPSG13_1P_DEC_LE_l2empty_6 VDD CS_I VSS RM_IHPSG13_1P_DEC_LE_l2empty
XRM_IHPSG13_1P_DEC04_3 ADDR_N_I<0> ADDR_N_I<1> ADDR_N_I<2> ADDR_N_I<3> RM_IHPSG13_1P_DEC04_3/ECLK_L_BOT
+ RM_IHPSG13_1P_DEC04_3/ECLK_H_BOT RM_IHPSG13_1P_DEC04_5/ECLK_H_BOT RM_IHPSG13_1P_DEC04_5/ECLK_L_BOT
+ RM_IHPSG13_1P_DEC04_3/CS WL_O<63> WL_O<62> WL_O<61> WL_O<60> WL_O<59> WL_O<58> WL_O<57>
+ WL_O<56> WL_O<55> WL_O<54> WL_O<53> WL_O<52> WL_O<51> WL_O<50> WL_O<49> WL_O<48>
+ VSS VDD RM_IHPSG13_1P_DEC04_9/m2_1382_0# ADDR_N_I<7> ADDR_N_I<5> ADDR_N_I<6> RM_IHPSG13_1P_DEC04_9/m2_56_840#
+ ADDR_N_I<4> RM_IHPSG13_1P_DEC04_9/m2_158_840# RM_IHPSG13_1P_DEC04
XRM_IHPSG13_1P_DEC02_0 RM_IHPSG13_1P_DEC03_0/CS ADDR_N_I<5> ADDR_N_I<4> RM_IHPSG13_1P_DEC04_1/CS
+ VDD VSS RM_IHPSG13_1P_DEC02
XRM_IHPSG13_1P_DEC_LE_l2empty_7 VDD CS_I VSS RM_IHPSG13_1P_DEC_LE_l2empty
XRM_IHPSG13_1P_DEC02_1 RM_IHPSG13_1P_DEC03_1/CS ADDR_N_I<5> ADDR_N_I<4> RM_IHPSG13_1P_DEC04_2/CS
+ VDD VSS RM_IHPSG13_1P_DEC02
XRM_IHPSG13_1P_DEC04_4 ADDR_N_I<0> ADDR_N_I<1> ADDR_N_I<2> ADDR_N_I<3> RM_IHPSG13_1P_DEC04_4/ECLK_L_BOT
+ RM_IHPSG13_1P_DEC04_4/ECLK_H_BOT RM_IHPSG13_1P_DEC04_4/ECLK_H_TOP RM_IHPSG13_1P_DEC04_4/ECLK_L_TOP
+ RM_IHPSG13_1P_DEC04_4/CS WL_O<127> WL_O<126> WL_O<125> WL_O<124> WL_O<123> WL_O<122>
+ WL_O<121> WL_O<120> WL_O<119> WL_O<118> WL_O<117> WL_O<116> WL_O<115> WL_O<114>
+ WL_O<113> WL_O<112> VSS VDD RM_IHPSG13_1P_DEC04_9/m2_1382_0# ADDR_N_I<7> ADDR_N_I<5>
+ ADDR_N_I<6> RM_IHPSG13_1P_DEC04_9/m2_56_840# ADDR_N_I<4> RM_IHPSG13_1P_DEC04_9/m2_158_840#
+ RM_IHPSG13_1P_DEC04
XRM_IHPSG13_1P_DEC_LE_l1empty_10 RM_IHPSG13_1P_DEC03_3/CS VDD VSS RM_IHPSG13_1P_DEC_LE_l1empty
XRM_IHPSG13_1P_DEC_LE_l2empty_8 VDD CS_I VSS RM_IHPSG13_1P_DEC_LE_l2empty
XRM_IHPSG13_1P_DEC04_5 ADDR_N_I<0> ADDR_N_I<1> ADDR_N_I<2> ADDR_N_I<3> RM_IHPSG13_1P_DEC04_5/ECLK_L_BOT
+ RM_IHPSG13_1P_DEC04_5/ECLK_H_BOT RM_IHPSG13_1P_DEC04_7/ECLK_H_BOT RM_IHPSG13_1P_DEC04_7/ECLK_L_BOT
+ RM_IHPSG13_1P_DEC04_5/CS WL_O<79> WL_O<78> WL_O<77> WL_O<76> WL_O<75> WL_O<74> WL_O<73>
+ WL_O<72> WL_O<71> WL_O<70> WL_O<69> WL_O<68> WL_O<67> WL_O<66> WL_O<65> WL_O<64>
+ VSS VDD RM_IHPSG13_1P_DEC04_9/m2_1382_0# ADDR_N_I<7> ADDR_N_I<5> ADDR_N_I<6> RM_IHPSG13_1P_DEC04_9/m2_56_840#
+ ADDR_N_I<4> RM_IHPSG13_1P_DEC04_9/m2_158_840# RM_IHPSG13_1P_DEC04
XRM_IHPSG13_1P_DEC02_2 CS_I ADDR_N_I<7> ADDR_N_I<6> RM_IHPSG13_1P_DEC03_4/CS VDD VSS
+ RM_IHPSG13_1P_DEC02
XRM_IHPSG13_1P_DEC_LE_l2empty_9 VDD CS_I VSS RM_IHPSG13_1P_DEC_LE_l2empty
XRM_IHPSG13_1P_DEC_LE_l1empty_11 RM_IHPSG13_1P_DEC03_3/CS VDD VSS RM_IHPSG13_1P_DEC_LE_l1empty
XRM_IHPSG13_1P_DEC04_6 ADDR_N_I<0> ADDR_N_I<1> ADDR_N_I<2> ADDR_N_I<3> RM_IHPSG13_1P_DEC04_6/ECLK_L_BOT
+ ECLK_I RM_IHPSG13_1P_DEC04_6/ECLK_H_TOP RM_IHPSG13_1P_DEC04_6/ECLK_L_TOP RM_IHPSG13_1P_DEC04_6/CS
+ WL_O<15> WL_O<14> WL_O<13> WL_O<12> WL_O<11> WL_O<10> WL_O<9> WL_O<8> WL_O<7> WL_O<6>
+ WL_O<5> WL_O<4> WL_O<3> WL_O<2> WL_O<1> WL_O<0> VSS VDD RM_IHPSG13_1P_DEC04_9/m2_1382_0#
+ ADDR_N_I<7> ADDR_N_I<5> ADDR_N_I<6> RM_IHPSG13_1P_DEC04_9/m2_56_840# ADDR_N_I<4>
+ RM_IHPSG13_1P_DEC04_9/m2_158_840# RM_IHPSG13_1P_DEC04
XRM_IHPSG13_1P_DEC02_3 RM_IHPSG13_1P_DEC03_4/CS ADDR_N_I<5> ADDR_N_I<4> RM_IHPSG13_1P_DEC04_10/CS
+ VDD VSS RM_IHPSG13_1P_DEC02
XRM_IHPSG13_1P_DEC00_0 ADDR_N_I<4> ADDR_N_I<5> RM_IHPSG13_1P_DEC03_0/CS VSS VDD RM_IHPSG13_1P_DEC04_6/CS
+ RM_IHPSG13_1P_DEC00
XRM_IHPSG13_1P_DEC04_7 ADDR_N_I<0> ADDR_N_I<1> ADDR_N_I<2> ADDR_N_I<3> RM_IHPSG13_1P_DEC04_7/ECLK_L_BOT
+ RM_IHPSG13_1P_DEC04_7/ECLK_H_BOT RM_IHPSG13_1P_DEC04_7/ECLK_H_TOP RM_IHPSG13_1P_DEC04_7/ECLK_L_TOP
+ RM_IHPSG13_1P_DEC04_7/CS WL_O<95> WL_O<94> WL_O<93> WL_O<92> WL_O<91> WL_O<90> WL_O<89>
+ WL_O<88> WL_O<87> WL_O<86> WL_O<85> WL_O<84> WL_O<83> WL_O<82> WL_O<81> WL_O<80>
+ VSS VDD RM_IHPSG13_1P_DEC04_9/m2_1382_0# ADDR_N_I<7> ADDR_N_I<5> ADDR_N_I<6> RM_IHPSG13_1P_DEC04_9/m2_56_840#
+ ADDR_N_I<4> RM_IHPSG13_1P_DEC04_9/m2_158_840# RM_IHPSG13_1P_DEC04
XRM_IHPSG13_1P_DEC02_4 RM_IHPSG13_1P_DEC03_3/CS ADDR_N_I<5> ADDR_N_I<4> RM_IHPSG13_1P_DEC04_13/CS
+ VDD VSS RM_IHPSG13_1P_DEC02
XRM_IHPSG13_1P_DEC00_1 ADDR_N_I<6> ADDR_N_I<7> CS_I VSS VDD RM_IHPSG13_1P_DEC03_0/CS
+ RM_IHPSG13_1P_DEC00
XRM_IHPSG13_1P_DEC04_8 ADDR_N_I<0> ADDR_N_I<1> ADDR_N_I<2> ADDR_N_I<3> RM_IHPSG13_1P_DEC04_8/ECLK_L_BOT
+ RM_IHPSG13_1P_DEC04_8/ECLK_H_BOT RM_IHPSG13_1P_DEC04_8/ECLK_H_TOP RM_IHPSG13_1P_DEC04_8/ECLK_L_TOP
+ RM_IHPSG13_1P_DEC04_8/CS WL_O<255> WL_O<254> WL_O<253> WL_O<252> WL_O<251> WL_O<250>
+ WL_O<249> WL_O<248> WL_O<247> WL_O<246> WL_O<245> WL_O<244> WL_O<243> WL_O<242>
+ WL_O<241> WL_O<240> VSS VDD RM_IHPSG13_1P_DEC04_9/m2_1382_0# ADDR_N_I<7> ADDR_N_I<5>
+ ADDR_N_I<6> RM_IHPSG13_1P_DEC04_9/m2_56_840# ADDR_N_I<4> RM_IHPSG13_1P_DEC04_9/m2_158_840#
+ RM_IHPSG13_1P_DEC04
XRM_IHPSG13_1P_DEC00_2 ADDR_N_I<4> ADDR_N_I<5> RM_IHPSG13_1P_DEC03_1/CS VSS VDD RM_IHPSG13_1P_DEC04_5/CS
+ RM_IHPSG13_1P_DEC00
XRM_IHPSG13_1P_DEC04_9 ADDR_N_I<0> ADDR_N_I<1> ADDR_N_I<2> ADDR_N_I<3> RM_IHPSG13_1P_DEC04_9/ECLK_L_BOT
+ RM_IHPSG13_1P_DEC04_9/ECLK_H_BOT RM_IHPSG13_1P_DEC04_9/ECLK_H_TOP RM_IHPSG13_1P_DEC04_9/ECLK_L_TOP
+ RM_IHPSG13_1P_DEC04_9/CS WL_O<159> WL_O<158> WL_O<157> WL_O<156> WL_O<155> WL_O<154>
+ WL_O<153> WL_O<152> WL_O<151> WL_O<150> WL_O<149> WL_O<148> WL_O<147> WL_O<146>
+ WL_O<145> WL_O<144> VSS VDD RM_IHPSG13_1P_DEC04_9/m2_1382_0# ADDR_N_I<7> ADDR_N_I<5>
+ ADDR_N_I<6> RM_IHPSG13_1P_DEC04_9/m2_56_840# ADDR_N_I<4> RM_IHPSG13_1P_DEC04_9/m2_158_840#
+ RM_IHPSG13_1P_DEC04
XRM_IHPSG13_1P_DEC00_3 ADDR_N_I<4> ADDR_N_I<5> RM_IHPSG13_1P_DEC03_3/CS VSS VDD RM_IHPSG13_1P_DEC04_12/CS
+ RM_IHPSG13_1P_DEC00
XRM_IHPSG13_1P_DEC00_4 ADDR_N_I<4> ADDR_N_I<5> RM_IHPSG13_1P_DEC03_4/CS VSS VDD RM_IHPSG13_1P_DEC04_15/CS
+ RM_IHPSG13_1P_DEC00
XRM_IHPSG13_1P_DEC04_10 ADDR_N_I<0> ADDR_N_I<1> ADDR_N_I<2> ADDR_N_I<3> RM_IHPSG13_1P_DEC04_9/ECLK_L_TOP
+ RM_IHPSG13_1P_DEC04_9/ECLK_H_TOP RM_IHPSG13_1P_DEC04_11/ECLK_H_BOT RM_IHPSG13_1P_DEC04_11/ECLK_L_BOT
+ RM_IHPSG13_1P_DEC04_10/CS WL_O<175> WL_O<174> WL_O<173> WL_O<172> WL_O<171> WL_O<170>
+ WL_O<169> WL_O<168> WL_O<167> WL_O<166> WL_O<165> WL_O<164> WL_O<163> WL_O<162>
+ WL_O<161> WL_O<160> VSS VDD RM_IHPSG13_1P_DEC04_9/m2_1382_0# ADDR_N_I<7> ADDR_N_I<5>
+ ADDR_N_I<6> RM_IHPSG13_1P_DEC04_9/m2_56_840# ADDR_N_I<4> RM_IHPSG13_1P_DEC04_9/m2_158_840#
+ RM_IHPSG13_1P_DEC04
XRM_IHPSG13_1P_DEC04_11 ADDR_N_I<0> ADDR_N_I<1> ADDR_N_I<2> ADDR_N_I<3> RM_IHPSG13_1P_DEC04_11/ECLK_L_BOT
+ RM_IHPSG13_1P_DEC04_11/ECLK_H_BOT RM_IHPSG13_1P_DEC04_12/ECLK_H_BOT RM_IHPSG13_1P_DEC04_12/ECLK_L_BOT
+ RM_IHPSG13_1P_DEC04_11/CS WL_O<191> WL_O<190> WL_O<189> WL_O<188> WL_O<187> WL_O<186>
+ WL_O<185> WL_O<184> WL_O<183> WL_O<182> WL_O<181> WL_O<180> WL_O<179> WL_O<178>
+ WL_O<177> WL_O<176> VSS VDD RM_IHPSG13_1P_DEC04_9/m2_1382_0# ADDR_N_I<7> ADDR_N_I<5>
+ ADDR_N_I<6> RM_IHPSG13_1P_DEC04_9/m2_56_840# ADDR_N_I<4> RM_IHPSG13_1P_DEC04_9/m2_158_840#
+ RM_IHPSG13_1P_DEC04
XRM_IHPSG13_1P_DEC04_12 ADDR_N_I<0> ADDR_N_I<1> ADDR_N_I<2> ADDR_N_I<3> RM_IHPSG13_1P_DEC04_12/ECLK_L_BOT
+ RM_IHPSG13_1P_DEC04_12/ECLK_H_BOT RM_IHPSG13_1P_DEC04_14/ECLK_H_BOT RM_IHPSG13_1P_DEC04_14/ECLK_L_BOT
+ RM_IHPSG13_1P_DEC04_12/CS WL_O<207> WL_O<206> WL_O<205> WL_O<204> WL_O<203> WL_O<202>
+ WL_O<201> WL_O<200> WL_O<199> WL_O<198> WL_O<197> WL_O<196> WL_O<195> WL_O<194>
+ WL_O<193> WL_O<192> VSS VDD RM_IHPSG13_1P_DEC04_9/m2_1382_0# ADDR_N_I<7> ADDR_N_I<5>
+ ADDR_N_I<6> RM_IHPSG13_1P_DEC04_9/m2_56_840# ADDR_N_I<4> RM_IHPSG13_1P_DEC04_9/m2_158_840#
+ RM_IHPSG13_1P_DEC04
XRM_IHPSG13_1P_DEC04_13 ADDR_N_I<0> ADDR_N_I<1> ADDR_N_I<2> ADDR_N_I<3> RM_IHPSG13_1P_DEC04_14/ECLK_L_TOP
+ RM_IHPSG13_1P_DEC04_14/ECLK_H_TOP RM_IHPSG13_1P_DEC04_8/ECLK_H_BOT RM_IHPSG13_1P_DEC04_8/ECLK_L_BOT
+ RM_IHPSG13_1P_DEC04_13/CS WL_O<239> WL_O<238> WL_O<237> WL_O<236> WL_O<235> WL_O<234>
+ WL_O<233> WL_O<232> WL_O<231> WL_O<230> WL_O<229> WL_O<228> WL_O<227> WL_O<226>
+ WL_O<225> WL_O<224> VSS VDD RM_IHPSG13_1P_DEC04_9/m2_1382_0# ADDR_N_I<7> ADDR_N_I<5>
+ ADDR_N_I<6> RM_IHPSG13_1P_DEC04_9/m2_56_840# ADDR_N_I<4> RM_IHPSG13_1P_DEC04_9/m2_158_840#
+ RM_IHPSG13_1P_DEC04
XRM_IHPSG13_1P_DEC04_14 ADDR_N_I<0> ADDR_N_I<1> ADDR_N_I<2> ADDR_N_I<3> RM_IHPSG13_1P_DEC04_14/ECLK_L_BOT
+ RM_IHPSG13_1P_DEC04_14/ECLK_H_BOT RM_IHPSG13_1P_DEC04_14/ECLK_H_TOP RM_IHPSG13_1P_DEC04_14/ECLK_L_TOP
+ RM_IHPSG13_1P_DEC04_14/CS WL_O<223> WL_O<222> WL_O<221> WL_O<220> WL_O<219> WL_O<218>
+ WL_O<217> WL_O<216> WL_O<215> WL_O<214> WL_O<213> WL_O<212> WL_O<211> WL_O<210>
+ WL_O<209> WL_O<208> VSS VDD RM_IHPSG13_1P_DEC04_9/m2_1382_0# ADDR_N_I<7> ADDR_N_I<5>
+ ADDR_N_I<6> RM_IHPSG13_1P_DEC04_9/m2_56_840# ADDR_N_I<4> RM_IHPSG13_1P_DEC04_9/m2_158_840#
+ RM_IHPSG13_1P_DEC04
XRM_IHPSG13_1P_DEC04_15 ADDR_N_I<0> ADDR_N_I<1> ADDR_N_I<2> ADDR_N_I<3> RM_IHPSG13_1P_DEC04_4/ECLK_L_TOP
+ RM_IHPSG13_1P_DEC04_4/ECLK_H_TOP RM_IHPSG13_1P_DEC04_9/ECLK_H_BOT RM_IHPSG13_1P_DEC04_9/ECLK_L_BOT
+ RM_IHPSG13_1P_DEC04_15/CS WL_O<143> WL_O<142> WL_O<141> WL_O<140> WL_O<139> WL_O<138>
+ WL_O<137> WL_O<136> WL_O<135> WL_O<134> WL_O<133> WL_O<132> WL_O<131> WL_O<130>
+ WL_O<129> WL_O<128> VSS VDD RM_IHPSG13_1P_DEC04_9/m2_1382_0# ADDR_N_I<7> ADDR_N_I<5>
+ ADDR_N_I<6> RM_IHPSG13_1P_DEC04_9/m2_56_840# ADDR_N_I<4> RM_IHPSG13_1P_DEC04_9/m2_158_840#
+ RM_IHPSG13_1P_DEC04
XRM_IHPSG13_1P_DEC03_0 RM_IHPSG13_1P_DEC03_0/CS ADDR_N_I<5> ADDR_N_I<4> RM_IHPSG13_1P_DEC04_3/CS
+ VDD VSS RM_IHPSG13_1P_DEC03
XRM_IHPSG13_1P_DEC03_1 RM_IHPSG13_1P_DEC03_1/CS ADDR_N_I<5> ADDR_N_I<4> RM_IHPSG13_1P_DEC04_4/CS
+ VDD VSS RM_IHPSG13_1P_DEC03
XRM_IHPSG13_1P_DEC03_2 CS_I ADDR_N_I<7> ADDR_N_I<6> RM_IHPSG13_1P_DEC03_3/CS VDD VSS
+ RM_IHPSG13_1P_DEC03
XRM_IHPSG13_1P_DEC03_3 RM_IHPSG13_1P_DEC03_3/CS ADDR_N_I<5> ADDR_N_I<4> RM_IHPSG13_1P_DEC04_8/CS
+ VDD VSS RM_IHPSG13_1P_DEC03
XRM_IHPSG13_1P_DEC01_0 CS_I ADDR_N_I<7> ADDR_N_I<6> RM_IHPSG13_1P_DEC03_1/CS VDD VSS
+ RM_IHPSG13_1P_DEC01
XRM_IHPSG13_1P_DEC03_4 RM_IHPSG13_1P_DEC03_4/CS ADDR_N_I<5> ADDR_N_I<4> RM_IHPSG13_1P_DEC04_11/CS
+ VDD VSS RM_IHPSG13_1P_DEC03
XRM_IHPSG13_1P_DEC01_1 RM_IHPSG13_1P_DEC03_1/CS ADDR_N_I<5> ADDR_N_I<4> RM_IHPSG13_1P_DEC04_7/CS
+ VDD VSS RM_IHPSG13_1P_DEC01
XRM_IHPSG13_1P_DEC01_2 RM_IHPSG13_1P_DEC03_0/CS ADDR_N_I<5> ADDR_N_I<4> RM_IHPSG13_1P_DEC04_0/CS
+ VDD VSS RM_IHPSG13_1P_DEC01
XRM_IHPSG13_1P_DEC01_3 RM_IHPSG13_1P_DEC03_3/CS ADDR_N_I<5> ADDR_N_I<4> RM_IHPSG13_1P_DEC04_14/CS
+ VDD VSS RM_IHPSG13_1P_DEC01
XRM_IHPSG13_1P_DEC_LE_l1empty_0 RM_IHPSG13_1P_DEC03_1/CS VDD VSS RM_IHPSG13_1P_DEC_LE_l1empty
XRM_IHPSG13_1P_DEC01_4 RM_IHPSG13_1P_DEC03_4/CS ADDR_N_I<5> ADDR_N_I<4> RM_IHPSG13_1P_DEC04_9/CS
+ VDD VSS RM_IHPSG13_1P_DEC01
XRM_IHPSG13_1P_DEC_LE_l1empty_1 RM_IHPSG13_1P_DEC03_0/CS VDD VSS RM_IHPSG13_1P_DEC_LE_l1empty
XRM_IHPSG13_1P_DEC_LE_l1empty_2 RM_IHPSG13_1P_DEC03_0/CS VDD VSS RM_IHPSG13_1P_DEC_LE_l1empty
XRM_IHPSG13_1P_DEC_LE_l1empty_3 RM_IHPSG13_1P_DEC03_1/CS VDD VSS RM_IHPSG13_1P_DEC_LE_l1empty
XRM_IHPSG13_1P_DEC_LE_l1empty_4 RM_IHPSG13_1P_DEC03_1/CS VDD VSS RM_IHPSG13_1P_DEC_LE_l1empty
XRM_IHPSG13_1P_DEC_LE_l1empty_5 RM_IHPSG13_1P_DEC03_0/CS VDD VSS RM_IHPSG13_1P_DEC_LE_l1empty
XRM_IHPSG13_1P_DEC_LE_l2empty_10 VDD CS_I VSS RM_IHPSG13_1P_DEC_LE_l2empty
X0 a_293_35226# a_293_35712# VSS VSS sg13_lv_nmos ad=0.1577p pd=1.21u as=0.1577p ps=1.21u w=0.83u l=0.13u
X1 VDD a_905_17086# a_905_17572# VDD sg13_lv_pmos ad=0.3078p pd=2u as=0.3078p ps=2u w=1.62u l=0.385u
X2 a_905_46596# a_905_46110# VDD VDD sg13_lv_pmos ad=0.3078p pd=2u as=0.3078p ps=2u w=1.62u l=0.385u
X3 a_905_42968# a_905_42482# VDD VDD sg13_lv_pmos ad=0.3078p pd=2u as=0.3078p ps=2u w=1.62u l=0.385u
X4 VDD a_293_336# a_293_58# VDD sg13_lv_pmos ad=0.3078p pd=2u as=0.3078p ps=2u w=1.62u l=0.385u
X5 a_293_6202# a_293_6688# VSS VSS sg13_lv_nmos ad=0.1577p pd=1.21u as=0.1577p ps=1.21u w=0.83u l=0.13u
X6 VDD a_905_38854# a_905_39340# VDD sg13_lv_pmos ad=0.5508p pd=3.92u as=0.3078p ps=2u w=1.62u l=0.385u
X7 a_293_6202# a_293_6688# VSS VSS sg13_lv_nmos ad=0.1577p pd=1.21u as=0.2822p ps=2.34u w=0.83u l=0.13u
X8 a_905_53366# a_905_53852# VSS VSS sg13_lv_nmos ad=0.1577p pd=1.21u as=0.1577p ps=1.21u w=0.83u l=0.13u
X9 VSS a_293_35712# a_293_35226# VSS sg13_lv_nmos ad=0.1577p pd=1.21u as=0.1577p ps=1.21u w=0.83u l=0.13u
X10 VSS a_905_24828# a_905_24342# VSS sg13_lv_nmos ad=0.2822p pd=2.34u as=0.1577p ps=1.21u w=0.83u l=0.13u
X11 VSS a_293_10316# a_293_9830# VSS sg13_lv_nmos ad=0.1577p pd=1.21u as=0.1577p ps=1.21u w=0.83u l=0.13u
X12 VSS a_293_46596# a_293_46110# VSS sg13_lv_nmos ad=0.1577p pd=1.21u as=0.1577p ps=1.21u w=0.83u l=0.13u
X13 VSS a_905_24828# a_905_24342# VSS sg13_lv_nmos ad=0.1577p pd=1.21u as=0.1577p ps=1.21u w=0.83u l=0.13u
X14 a_905_336# a_905_58# VSS VSS sg13_lv_nmos ad=0.1577p pd=1.21u as=0.1577p ps=1.21u w=0.83u l=0.13u
X15 VDD a_905_56994# a_905_57480# VDD sg13_lv_pmos ad=0.3078p pd=2u as=0.3078p ps=2u w=1.62u l=0.385u
X16 a_905_42482# a_905_42968# VSS VSS sg13_lv_nmos ad=0.1577p pd=1.21u as=0.1577p ps=1.21u w=0.83u l=0.13u
X17 a_905_9830# a_905_10316# VSS VSS sg13_lv_nmos ad=0.1577p pd=1.21u as=0.1577p ps=1.21u w=0.83u l=0.13u
X18 VDD a_293_24342# a_293_24828# VDD sg13_lv_pmos ad=0.3078p pd=2u as=0.3078p ps=2u w=1.62u l=0.385u
X19 VSS a_293_3060# a_293_2574# VSS sg13_lv_nmos ad=0.1577p pd=1.21u as=0.1577p ps=1.21u w=0.83u l=0.13u
X20 VSS a_293_50224# a_293_49738# VSS sg13_lv_nmos ad=0.1577p pd=1.21u as=0.1577p ps=1.21u w=0.83u l=0.13u
X21 VDD a_905_49738# a_905_50224# VDD sg13_lv_pmos ad=0.3078p pd=2u as=0.3078p ps=2u w=1.62u l=0.385u
X22 a_905_46110# a_905_46596# VSS VSS sg13_lv_nmos ad=0.1577p pd=1.21u as=0.1577p ps=1.21u w=0.83u l=0.13u
X23 a_293_46596# a_293_46110# VDD VDD sg13_lv_pmos ad=0.3078p pd=2u as=0.5508p ps=3.92u w=1.62u l=0.385u
X24 VSS a_293_3060# a_293_2574# VSS sg13_lv_nmos ad=0.1577p pd=1.21u as=0.1577p ps=1.21u w=0.83u l=0.13u
X25 VDD a_293_13458# a_293_13944# VDD sg13_lv_pmos ad=0.3078p pd=2u as=0.3078p ps=2u w=1.62u l=0.385u
X26 a_293_32084# a_293_31598# VDD VDD sg13_lv_pmos ad=0.3078p pd=2u as=0.3078p ps=2u w=1.62u l=0.385u
X27 a_293_27970# a_293_28456# VSS VSS sg13_lv_nmos ad=0.1577p pd=1.21u as=0.1577p ps=1.21u w=0.83u l=0.13u
X28 a_905_49738# a_905_50224# VSS VSS sg13_lv_nmos ad=0.1577p pd=1.21u as=0.1577p ps=1.21u w=0.83u l=0.13u
X29 VSS a_293_28456# a_293_27970# VSS sg13_lv_nmos ad=0.1577p pd=1.21u as=0.1577p ps=1.21u w=0.83u l=0.13u
X30 a_905_32084# a_905_31598# VDD VDD sg13_lv_pmos ad=0.3078p pd=2u as=0.3078p ps=2u w=1.62u l=0.385u
X31 a_293_28456# a_293_27970# VDD VDD sg13_lv_pmos ad=0.3078p pd=2u as=0.3078p ps=2u w=1.62u l=0.385u
X32 a_293_9830# a_293_10316# VSS VSS sg13_lv_nmos ad=0.1577p pd=1.21u as=0.2822p ps=2.34u w=0.83u l=0.13u
X33 a_293_46110# a_293_46596# VSS VSS sg13_lv_nmos ad=0.1577p pd=1.21u as=0.2822p ps=2.34u w=0.83u l=0.13u
X34 VSS a_905_42968# a_905_42482# VSS sg13_lv_nmos ad=0.1577p pd=1.21u as=0.1577p ps=1.21u w=0.83u l=0.13u
X35 a_293_17086# a_293_17572# VSS VSS sg13_lv_nmos ad=0.1577p pd=1.21u as=0.1577p ps=1.21u w=0.83u l=0.13u
X36 a_905_28456# a_905_27970# VDD VDD sg13_lv_pmos ad=0.3078p pd=2u as=0.3078p ps=2u w=1.62u l=0.385u
X37 VDD a_293_53366# a_293_53852# VDD sg13_lv_pmos ad=0.3078p pd=2u as=0.3078p ps=2u w=1.62u l=0.385u
X38 a_293_49738# a_293_50224# VSS VSS sg13_lv_nmos ad=0.1577p pd=1.21u as=0.2822p ps=2.34u w=0.83u l=0.13u
X39 VDD a_905_42482# a_905_42968# VDD sg13_lv_pmos ad=0.3078p pd=2u as=0.3078p ps=2u w=1.62u l=0.385u
X40 VSS a_293_17572# a_293_17086# VSS sg13_lv_nmos ad=0.1577p pd=1.21u as=0.1577p ps=1.21u w=0.83u l=0.13u
X41 a_905_35226# a_905_35712# VSS VSS sg13_lv_nmos ad=0.1577p pd=1.21u as=0.1577p ps=1.21u w=0.83u l=0.13u
X42 a_293_20714# a_293_21200# VSS VSS sg13_lv_nmos ad=0.1577p pd=1.21u as=0.1577p ps=1.21u w=0.83u l=0.13u
X43 a_293_56994# a_293_57480# VSS VSS sg13_lv_nmos ad=0.1577p pd=1.21u as=0.1577p ps=1.21u w=0.83u l=0.13u
X44 a_293_32084# a_293_31598# VDD VDD sg13_lv_pmos ad=0.3078p pd=2u as=0.5508p ps=3.92u w=1.62u l=0.385u
X45 VDD a_293_35226# a_293_35712# VDD sg13_lv_pmos ad=0.3078p pd=2u as=0.3078p ps=2u w=1.62u l=0.385u
X46 a_293_10316# a_293_9830# VDD VDD sg13_lv_pmos ad=0.3078p pd=2u as=0.3078p ps=2u w=1.62u l=0.385u
X47 VDD a_905_24342# a_905_24828# VDD sg13_lv_pmos ad=0.5508p pd=3.92u as=0.3078p ps=2u w=1.62u l=0.385u
X48 VSS a_293_21200# a_293_20714# VSS sg13_lv_nmos ad=0.1577p pd=1.21u as=0.1577p ps=1.21u w=0.83u l=0.13u
X49 a_293_13458# a_293_13944# VSS VSS sg13_lv_nmos ad=0.1577p pd=1.21u as=0.1577p ps=1.21u w=0.83u l=0.13u
X50 a_905_336# a_905_58# VSS VSS sg13_lv_nmos ad=0.1577p pd=1.21u as=0.1577p ps=1.21u w=0.83u l=0.13u
X51 VSS a_905_10316# a_905_9830# VSS sg13_lv_nmos ad=0.2822p pd=2.34u as=0.1577p ps=1.21u w=0.83u l=0.13u
X52 VSS a_293_57480# a_293_56994# VSS sg13_lv_nmos ad=0.1577p pd=1.21u as=0.1577p ps=1.21u w=0.83u l=0.13u
X53 VSS a_905_46596# a_905_46110# VSS sg13_lv_nmos ad=0.2822p pd=2.34u as=0.1577p ps=1.21u w=0.83u l=0.13u
X54 VSS a_293_32084# a_293_31598# VSS sg13_lv_nmos ad=0.1577p pd=1.21u as=0.1577p ps=1.21u w=0.83u l=0.13u
X55 a_293_28456# a_293_27970# VDD VDD sg13_lv_pmos ad=0.3078p pd=2u as=0.5508p ps=3.92u w=1.62u l=0.385u
X56 VSS a_905_10316# a_905_9830# VSS sg13_lv_nmos ad=0.1577p pd=1.21u as=0.1577p ps=1.21u w=0.83u l=0.13u
X57 VSS a_905_46596# a_905_46110# VSS sg13_lv_nmos ad=0.1577p pd=1.21u as=0.1577p ps=1.21u w=0.83u l=0.13u
X58 VSS a_293_58# a_293_336# VSS sg13_lv_nmos ad=0.1577p pd=1.21u as=0.1577p ps=1.21u w=0.83u l=0.13u
X59 VSS a_293_13944# a_293_13458# VSS sg13_lv_nmos ad=0.1577p pd=1.21u as=0.1577p ps=1.21u w=0.83u l=0.13u
X60 VSS a_293_39340# a_293_38854# VSS sg13_lv_nmos ad=0.1577p pd=1.21u as=0.1577p ps=1.21u w=0.83u l=0.13u
X61 a_293_13944# a_293_13458# VDD VDD sg13_lv_pmos ad=0.3078p pd=2u as=0.3078p ps=2u w=1.62u l=0.385u
X62 VSS a_905_50224# a_905_49738# VSS sg13_lv_nmos ad=0.2822p pd=2.34u as=0.1577p ps=1.21u w=0.83u l=0.13u
X63 a_905_31598# a_905_32084# VSS VSS sg13_lv_nmos ad=0.1577p pd=1.21u as=0.1577p ps=1.21u w=0.83u l=0.13u
X64 VDD a_293_46110# a_293_46596# VDD sg13_lv_pmos ad=0.3078p pd=2u as=0.3078p ps=2u w=1.62u l=0.385u
X65 VSS a_293_53852# a_293_53366# VSS sg13_lv_nmos ad=0.1577p pd=1.21u as=0.1577p ps=1.21u w=0.83u l=0.13u
X66 VSS a_905_50224# a_905_49738# VSS sg13_lv_nmos ad=0.1577p pd=1.21u as=0.1577p ps=1.21u w=0.83u l=0.13u
X67 a_293_38854# a_293_39340# VSS VSS sg13_lv_nmos ad=0.1577p pd=1.21u as=0.1577p ps=1.21u w=0.83u l=0.13u
X68 a_905_27970# a_905_28456# VSS VSS sg13_lv_nmos ad=0.1577p pd=1.21u as=0.1577p ps=1.21u w=0.83u l=0.13u
X69 a_905_13944# a_905_13458# VDD VDD sg13_lv_pmos ad=0.3078p pd=2u as=0.3078p ps=2u w=1.62u l=0.385u
X70 VDD a_293_6202# a_293_6688# VDD sg13_lv_pmos ad=0.3078p pd=2u as=0.3078p ps=2u w=1.62u l=0.385u
X71 VDD a_293_6202# a_293_6688# VDD sg13_lv_pmos ad=0.3078p pd=2u as=0.3078p ps=2u w=1.62u l=0.385u
X72 a_905_53366# a_905_53852# VSS VSS sg13_lv_nmos ad=0.1577p pd=1.21u as=0.1577p ps=1.21u w=0.83u l=0.13u
X73 a_905_39340# a_905_38854# VDD VDD sg13_lv_pmos ad=0.3078p pd=2u as=0.3078p ps=2u w=1.62u l=0.385u
X74 a_293_3060# a_293_2574# VDD VDD sg13_lv_pmos ad=0.3078p pd=2u as=0.3078p ps=2u w=1.62u l=0.385u
X75 VDD a_905_53366# a_905_53852# VDD sg13_lv_pmos ad=0.5508p pd=3.92u as=0.3078p ps=2u w=1.62u l=0.385u
X76 a_905_58# a_905_336# VDD VDD sg13_lv_pmos ad=0.3078p pd=2u as=0.3078p ps=2u w=1.62u l=0.385u
X77 a_293_31598# a_293_32084# VSS VSS sg13_lv_nmos ad=0.1577p pd=1.21u as=0.2822p ps=2.34u w=0.83u l=0.13u
X78 VDD a_293_20714# a_293_21200# VDD sg13_lv_pmos ad=0.3078p pd=2u as=0.3078p ps=2u w=1.62u l=0.385u
X79 a_905_17086# a_905_17572# VSS VSS sg13_lv_nmos ad=0.1577p pd=1.21u as=0.1577p ps=1.21u w=0.83u l=0.13u
X80 VSS a_293_6688# a_293_6202# VSS sg13_lv_nmos ad=0.1577p pd=1.21u as=0.1577p ps=1.21u w=0.83u l=0.13u
X81 a_293_13944# a_293_13458# VDD VDD sg13_lv_pmos ad=0.3078p pd=2u as=0.5508p ps=3.92u w=1.62u l=0.385u
X82 a_905_38854# a_905_39340# VSS VSS sg13_lv_nmos ad=0.1577p pd=1.21u as=0.1577p ps=1.21u w=0.83u l=0.13u
X83 VDD a_293_17086# a_293_17572# VDD sg13_lv_pmos ad=0.3078p pd=2u as=0.3078p ps=2u w=1.62u l=0.385u
X84 VSS a_905_3060# a_905_2574# VSS sg13_lv_nmos ad=0.1577p pd=1.21u as=0.1577p ps=1.21u w=0.83u l=0.13u
X85 VSS a_293_6688# a_293_6202# VSS sg13_lv_nmos ad=0.1577p pd=1.21u as=0.1577p ps=1.21u w=0.83u l=0.13u
X86 a_293_35712# a_293_35226# VDD VDD sg13_lv_pmos ad=0.3078p pd=2u as=0.3078p ps=2u w=1.62u l=0.385u
X87 VSS a_293_24828# a_293_24342# VSS sg13_lv_nmos ad=0.1577p pd=1.21u as=0.1577p ps=1.21u w=0.83u l=0.13u
X88 a_905_20714# a_905_21200# VSS VSS sg13_lv_nmos ad=0.1577p pd=1.21u as=0.1577p ps=1.21u w=0.83u l=0.13u
X89 VDD a_905_336# a_905_58# VDD sg13_lv_pmos ad=0.3078p pd=2u as=0.3078p ps=2u w=1.62u l=0.385u
X90 a_905_56994# a_905_57480# VSS VSS sg13_lv_nmos ad=0.1577p pd=1.21u as=0.1577p ps=1.21u w=0.83u l=0.13u
X91 a_293_53366# a_293_53852# VSS VSS sg13_lv_nmos ad=0.1577p pd=1.21u as=0.2822p ps=2.34u w=0.83u l=0.13u
X92 VDD a_293_31598# a_293_32084# VDD sg13_lv_pmos ad=0.3078p pd=2u as=0.3078p ps=2u w=1.62u l=0.385u
X93 a_905_336# a_905_58# VSS VSS sg13_lv_nmos ad=0.1577p pd=1.21u as=0.1577p ps=1.21u w=0.83u l=0.13u
X94 a_293_42482# a_293_42968# VSS VSS sg13_lv_nmos ad=0.1577p pd=1.21u as=0.1577p ps=1.21u w=0.83u l=0.13u
X95 a_905_35712# a_905_35226# VDD VDD sg13_lv_pmos ad=0.3078p pd=2u as=0.3078p ps=2u w=1.62u l=0.385u
X96 a_293_24342# a_293_24828# VSS VSS sg13_lv_nmos ad=0.1577p pd=1.21u as=0.1577p ps=1.21u w=0.83u l=0.13u
X97 a_905_13458# a_905_13944# VSS VSS sg13_lv_nmos ad=0.1577p pd=1.21u as=0.1577p ps=1.21u w=0.83u l=0.13u
X98 VDD a_293_56994# a_293_57480# VDD sg13_lv_pmos ad=0.3078p pd=2u as=0.3078p ps=2u w=1.62u l=0.385u
X99 VDD a_905_46110# a_905_46596# VDD sg13_lv_pmos ad=0.5508p pd=3.92u as=0.3078p ps=2u w=1.62u l=0.385u
X100 VSS a_293_42968# a_293_42482# VSS sg13_lv_nmos ad=0.1577p pd=1.21u as=0.1577p ps=1.21u w=0.83u l=0.13u
X101 VSS a_905_32084# a_905_31598# VSS sg13_lv_nmos ad=0.2822p pd=2.34u as=0.1577p ps=1.21u w=0.83u l=0.13u
X102 VDD a_293_27970# a_293_28456# VDD sg13_lv_pmos ad=0.3078p pd=2u as=0.3078p ps=2u w=1.62u l=0.385u
X103 a_905_2574# a_905_3060# VSS VSS sg13_lv_nmos ad=0.1577p pd=1.21u as=0.1577p ps=1.21u w=0.83u l=0.13u
X104 VSS a_905_32084# a_905_31598# VSS sg13_lv_nmos ad=0.1577p pd=1.21u as=0.1577p ps=1.21u w=0.83u l=0.13u
X105 a_293_2574# a_293_3060# VSS VSS sg13_lv_nmos ad=0.1577p pd=1.21u as=0.1577p ps=1.21u w=0.83u l=0.13u
X106 VDD a_293_49738# a_293_50224# VDD sg13_lv_pmos ad=0.3078p pd=2u as=0.3078p ps=2u w=1.62u l=0.385u
X107 VSS a_905_39340# a_905_38854# VSS sg13_lv_nmos ad=0.1577p pd=1.21u as=0.1577p ps=1.21u w=0.83u l=0.13u
X108 VSS a_293_35712# a_293_35226# VSS sg13_lv_nmos ad=0.1577p pd=1.21u as=0.1577p ps=1.21u w=0.83u l=0.13u
X109 a_905_35226# a_905_35712# VSS VSS sg13_lv_nmos ad=0.1577p pd=1.21u as=0.1577p ps=1.21u w=0.83u l=0.13u
X110 VSS a_905_53852# a_905_53366# VSS sg13_lv_nmos ad=0.2822p pd=2.34u as=0.1577p ps=1.21u w=0.83u l=0.13u
X111 VDD a_905_38854# a_905_39340# VDD sg13_lv_pmos ad=0.3078p pd=2u as=0.3078p ps=2u w=1.62u l=0.385u
X112 a_293_35712# a_293_35226# VDD VDD sg13_lv_pmos ad=0.3078p pd=2u as=0.5508p ps=3.92u w=1.62u l=0.385u
X113 a_905_24342# a_905_24828# VSS VSS sg13_lv_nmos ad=0.1577p pd=1.21u as=0.1577p ps=1.21u w=0.83u l=0.13u
X114 VSS a_905_53852# a_905_53366# VSS sg13_lv_nmos ad=0.1577p pd=1.21u as=0.1577p ps=1.21u w=0.83u l=0.13u
X115 a_293_21200# a_293_20714# VDD VDD sg13_lv_pmos ad=0.3078p pd=2u as=0.3078p ps=2u w=1.62u l=0.385u
X116 a_905_24828# a_905_24342# VDD VDD sg13_lv_pmos ad=0.3078p pd=2u as=0.3078p ps=2u w=1.62u l=0.385u
X117 VSS a_293_58# a_293_336# VSS sg13_lv_nmos ad=0.1577p pd=1.21u as=0.1577p ps=1.21u w=0.83u l=0.13u
X118 VDD a_905_9830# a_905_10316# VDD sg13_lv_pmos ad=0.5508p pd=3.92u as=0.3078p ps=2u w=1.62u l=0.385u
X119 VDD a_905_9830# a_905_10316# VDD sg13_lv_pmos ad=0.3078p pd=2u as=0.3078p ps=2u w=1.62u l=0.385u
X120 a_293_35226# a_293_35712# VSS VSS sg13_lv_nmos ad=0.1577p pd=1.21u as=0.2822p ps=2.34u w=0.83u l=0.13u
X121 a_905_21200# a_905_20714# VDD VDD sg13_lv_pmos ad=0.3078p pd=2u as=0.3078p ps=2u w=1.62u l=0.385u
X122 a_293_17572# a_293_17086# VDD VDD sg13_lv_pmos ad=0.3078p pd=2u as=0.3078p ps=2u w=1.62u l=0.385u
X123 VDD a_293_42482# a_293_42968# VDD sg13_lv_pmos ad=0.3078p pd=2u as=0.3078p ps=2u w=1.62u l=0.385u
X124 VDD a_905_31598# a_905_32084# VDD sg13_lv_pmos ad=0.5508p pd=3.92u as=0.3078p ps=2u w=1.62u l=0.385u
X125 VSS a_293_28456# a_293_27970# VSS sg13_lv_nmos ad=0.1577p pd=1.21u as=0.1577p ps=1.21u w=0.83u l=0.13u
X126 VDD a_293_13458# a_293_13944# VDD sg13_lv_pmos ad=0.3078p pd=2u as=0.3078p ps=2u w=1.62u l=0.385u
X127 a_905_27970# a_905_28456# VSS VSS sg13_lv_nmos ad=0.1577p pd=1.21u as=0.1577p ps=1.21u w=0.83u l=0.13u
X128 VSS a_905_24828# a_905_24342# VSS sg13_lv_nmos ad=0.1577p pd=1.21u as=0.1577p ps=1.21u w=0.83u l=0.13u
X129 a_905_17572# a_905_17086# VDD VDD sg13_lv_pmos ad=0.3078p pd=2u as=0.3078p ps=2u w=1.62u l=0.385u
X130 VDD a_905_336# a_905_58# VDD sg13_lv_pmos ad=0.5508p pd=3.92u as=0.3078p ps=2u w=1.62u l=0.385u
X131 VSS a_293_10316# a_293_9830# VSS sg13_lv_nmos ad=0.1577p pd=1.21u as=0.1577p ps=1.21u w=0.83u l=0.13u
X132 VSS a_293_46596# a_293_46110# VSS sg13_lv_nmos ad=0.1577p pd=1.21u as=0.1577p ps=1.21u w=0.83u l=0.13u
X133 VDD a_905_27970# a_905_28456# VDD sg13_lv_pmos ad=0.5508p pd=3.92u as=0.3078p ps=2u w=1.62u l=0.385u
X134 a_293_57480# a_293_56994# VDD VDD sg13_lv_pmos ad=0.3078p pd=2u as=0.3078p ps=2u w=1.62u l=0.385u
X135 a_905_42482# a_905_42968# VSS VSS sg13_lv_nmos ad=0.1577p pd=1.21u as=0.1577p ps=1.21u w=0.83u l=0.13u
X136 a_293_10316# a_293_9830# VDD VDD sg13_lv_pmos ad=0.3078p pd=2u as=0.5508p ps=3.92u w=1.62u l=0.385u
X137 a_293_21200# a_293_20714# VDD VDD sg13_lv_pmos ad=0.3078p pd=2u as=0.5508p ps=3.92u w=1.62u l=0.385u
X138 VSS a_293_17572# a_293_17086# VSS sg13_lv_nmos ad=0.1577p pd=1.21u as=0.1577p ps=1.21u w=0.83u l=0.13u
X139 VDD a_905_2574# a_905_3060# VDD sg13_lv_pmos ad=0.5508p pd=3.92u as=0.3078p ps=2u w=1.62u l=0.385u
X140 a_905_6688# a_905_6202# VDD VDD sg13_lv_pmos ad=0.3078p pd=2u as=0.3078p ps=2u w=1.62u l=0.385u
X141 a_293_9830# a_293_10316# VSS VSS sg13_lv_nmos ad=0.1577p pd=1.21u as=0.1577p ps=1.21u w=0.83u l=0.13u
X142 a_905_57480# a_905_56994# VDD VDD sg13_lv_pmos ad=0.3078p pd=2u as=0.3078p ps=2u w=1.62u l=0.385u
X143 a_905_53852# a_905_53366# VDD VDD sg13_lv_pmos ad=0.3078p pd=2u as=0.3078p ps=2u w=1.62u l=0.385u
X144 a_293_50224# a_293_49738# VDD VDD sg13_lv_pmos ad=0.3078p pd=2u as=0.3078p ps=2u w=1.62u l=0.385u
X145 a_293_46110# a_293_46596# VSS VSS sg13_lv_nmos ad=0.1577p pd=1.21u as=0.1577p ps=1.21u w=0.83u l=0.13u
X146 VDD a_905_2574# a_905_3060# VDD sg13_lv_pmos ad=0.3078p pd=2u as=0.3078p ps=2u w=1.62u l=0.385u
X147 VSS a_293_50224# a_293_49738# VSS sg13_lv_nmos ad=0.1577p pd=1.21u as=0.1577p ps=1.21u w=0.83u l=0.13u
X148 a_905_17086# a_905_17572# VSS VSS sg13_lv_nmos ad=0.1577p pd=1.21u as=0.1577p ps=1.21u w=0.83u l=0.13u
X149 VSS a_905_35712# a_905_35226# VSS sg13_lv_nmos ad=0.2822p pd=2.34u as=0.1577p ps=1.21u w=0.83u l=0.13u
X150 a_293_27970# a_293_28456# VSS VSS sg13_lv_nmos ad=0.1577p pd=1.21u as=0.2822p ps=2.34u w=0.83u l=0.13u
X151 VSS a_293_21200# a_293_20714# VSS sg13_lv_nmos ad=0.1577p pd=1.21u as=0.1577p ps=1.21u w=0.83u l=0.13u
X152 a_293_17572# a_293_17086# VDD VDD sg13_lv_pmos ad=0.3078p pd=2u as=0.5508p ps=3.92u w=1.62u l=0.385u
X153 a_905_58# a_905_336# VDD VDD sg13_lv_pmos ad=0.3078p pd=2u as=0.3078p ps=2u w=1.62u l=0.385u
X154 VSS a_293_57480# a_293_56994# VSS sg13_lv_nmos ad=0.1577p pd=1.21u as=0.1577p ps=1.21u w=0.83u l=0.13u
X155 a_293_49738# a_293_50224# VSS VSS sg13_lv_nmos ad=0.1577p pd=1.21u as=0.1577p ps=1.21u w=0.83u l=0.13u
X156 a_905_50224# a_905_49738# VDD VDD sg13_lv_pmos ad=0.3078p pd=2u as=0.3078p ps=2u w=1.62u l=0.385u
X157 VSS a_905_35712# a_905_35226# VSS sg13_lv_nmos ad=0.1577p pd=1.21u as=0.1577p ps=1.21u w=0.83u l=0.13u
X158 a_905_6688# a_905_6202# VDD VDD sg13_lv_pmos ad=0.3078p pd=2u as=0.3078p ps=2u w=1.62u l=0.385u
X159 VSS a_293_13944# a_293_13458# VSS sg13_lv_nmos ad=0.1577p pd=1.21u as=0.1577p ps=1.21u w=0.83u l=0.13u
X160 VSS a_905_6688# a_905_6202# VSS sg13_lv_nmos ad=0.1577p pd=1.21u as=0.1577p ps=1.21u w=0.83u l=0.13u
X161 VDD a_293_35226# a_293_35712# VDD sg13_lv_pmos ad=0.3078p pd=2u as=0.3078p ps=2u w=1.62u l=0.385u
X162 VDD a_905_24342# a_905_24828# VDD sg13_lv_pmos ad=0.3078p pd=2u as=0.3078p ps=2u w=1.62u l=0.385u
X163 a_905_20714# a_905_21200# VSS VSS sg13_lv_nmos ad=0.1577p pd=1.21u as=0.1577p ps=1.21u w=0.83u l=0.13u
X164 a_905_56994# a_905_57480# VSS VSS sg13_lv_nmos ad=0.1577p pd=1.21u as=0.1577p ps=1.21u w=0.83u l=0.13u
X165 a_293_57480# a_293_56994# VDD VDD sg13_lv_pmos ad=0.3078p pd=2u as=0.5508p ps=3.92u w=1.62u l=0.385u
X166 VSS a_905_58# a_905_336# VSS sg13_lv_nmos ad=0.1577p pd=1.21u as=0.1577p ps=1.21u w=0.83u l=0.13u
X167 a_293_3060# a_293_2574# VDD VDD sg13_lv_pmos ad=0.3078p pd=2u as=0.5508p ps=3.92u w=1.62u l=0.385u
X168 a_905_9830# a_905_10316# VSS VSS sg13_lv_nmos ad=0.1577p pd=1.21u as=0.1577p ps=1.21u w=0.83u l=0.13u
X169 a_905_46110# a_905_46596# VSS VSS sg13_lv_nmos ad=0.1577p pd=1.21u as=0.1577p ps=1.21u w=0.83u l=0.13u
X170 a_293_17086# a_293_17572# VSS VSS sg13_lv_nmos ad=0.1577p pd=1.21u as=0.2822p ps=2.34u w=0.83u l=0.13u
X171 a_905_13458# a_905_13944# VSS VSS sg13_lv_nmos ad=0.1577p pd=1.21u as=0.1577p ps=1.21u w=0.83u l=0.13u
X172 a_293_42968# a_293_42482# VDD VDD sg13_lv_pmos ad=0.3078p pd=2u as=0.3078p ps=2u w=1.62u l=0.385u
X173 a_293_38854# a_293_39340# VSS VSS sg13_lv_nmos ad=0.1577p pd=1.21u as=0.1577p ps=1.21u w=0.83u l=0.13u
X174 a_905_6202# a_905_6688# VSS VSS sg13_lv_nmos ad=0.1577p pd=1.21u as=0.1577p ps=1.21u w=0.83u l=0.13u
X175 VDD a_905_13458# a_905_13944# VDD sg13_lv_pmos ad=0.5508p pd=3.92u as=0.3078p ps=2u w=1.62u l=0.385u
X176 a_293_50224# a_293_49738# VDD VDD sg13_lv_pmos ad=0.3078p pd=2u as=0.5508p ps=3.92u w=1.62u l=0.385u
X177 a_905_46596# a_905_46110# VDD VDD sg13_lv_pmos ad=0.3078p pd=2u as=0.3078p ps=2u w=1.62u l=0.385u
X178 a_293_336# a_293_58# VSS VSS sg13_lv_nmos ad=0.1577p pd=1.21u as=0.2822p ps=2.34u w=0.83u l=0.13u
X179 a_905_49738# a_905_50224# VSS VSS sg13_lv_nmos ad=0.1577p pd=1.21u as=0.1577p ps=1.21u w=0.83u l=0.13u
X180 a_905_2574# a_905_3060# VSS VSS sg13_lv_nmos ad=0.1577p pd=1.21u as=0.1577p ps=1.21u w=0.83u l=0.13u
X181 VSS a_905_3060# a_905_2574# VSS sg13_lv_nmos ad=0.1577p pd=1.21u as=0.1577p ps=1.21u w=0.83u l=0.13u
X182 a_293_6202# a_293_6688# VSS VSS sg13_lv_nmos ad=0.1577p pd=1.21u as=0.1577p ps=1.21u w=0.83u l=0.13u
X183 a_905_42968# a_905_42482# VDD VDD sg13_lv_pmos ad=0.3078p pd=2u as=0.3078p ps=2u w=1.62u l=0.385u
X184 VSS a_293_39340# a_293_38854# VSS sg13_lv_nmos ad=0.1577p pd=1.21u as=0.1577p ps=1.21u w=0.83u l=0.13u
X185 VSS a_905_28456# a_905_27970# VSS sg13_lv_nmos ad=0.2822p pd=2.34u as=0.1577p ps=1.21u w=0.83u l=0.13u
X186 a_293_20714# a_293_21200# VSS VSS sg13_lv_nmos ad=0.1577p pd=1.21u as=0.2822p ps=2.34u w=0.83u l=0.13u
X187 VSS a_293_58# a_293_336# VSS sg13_lv_nmos ad=0.1577p pd=1.21u as=0.1577p ps=1.21u w=0.83u l=0.13u
X188 a_293_56994# a_293_57480# VSS VSS sg13_lv_nmos ad=0.1577p pd=1.21u as=0.2822p ps=2.34u w=0.83u l=0.13u
X189 VSS a_905_28456# a_905_27970# VSS sg13_lv_nmos ad=0.1577p pd=1.21u as=0.1577p ps=1.21u w=0.83u l=0.13u
X190 a_293_13458# a_293_13944# VSS VSS sg13_lv_nmos ad=0.1577p pd=1.21u as=0.2822p ps=2.34u w=0.83u l=0.13u
X191 VSS a_905_10316# a_905_9830# VSS sg13_lv_nmos ad=0.1577p pd=1.21u as=0.1577p ps=1.21u w=0.83u l=0.13u
X192 VDD a_905_53366# a_905_53852# VDD sg13_lv_pmos ad=0.3078p pd=2u as=0.3078p ps=2u w=1.62u l=0.385u
X193 VSS a_905_46596# a_905_46110# VSS sg13_lv_nmos ad=0.1577p pd=1.21u as=0.1577p ps=1.21u w=0.83u l=0.13u
X194 VSS a_293_32084# a_293_31598# VSS sg13_lv_nmos ad=0.1577p pd=1.21u as=0.1577p ps=1.21u w=0.83u l=0.13u
X195 VSS a_293_3060# a_293_2574# VSS sg13_lv_nmos ad=0.1577p pd=1.21u as=0.1577p ps=1.21u w=0.83u l=0.13u
X196 VDD a_293_20714# a_293_21200# VDD sg13_lv_pmos ad=0.3078p pd=2u as=0.3078p ps=2u w=1.62u l=0.385u
X197 VSS a_905_17572# a_905_17086# VSS sg13_lv_nmos ad=0.2822p pd=2.34u as=0.1577p ps=1.21u w=0.83u l=0.13u
X198 a_293_42968# a_293_42482# VDD VDD sg13_lv_pmos ad=0.3078p pd=2u as=0.5508p ps=3.92u w=1.62u l=0.385u
X199 a_293_31598# a_293_32084# VSS VSS sg13_lv_nmos ad=0.1577p pd=1.21u as=0.1577p ps=1.21u w=0.83u l=0.13u
X200 VSS a_905_17572# a_905_17086# VSS sg13_lv_nmos ad=0.1577p pd=1.21u as=0.1577p ps=1.21u w=0.83u l=0.13u
X201 VSS a_905_50224# a_905_49738# VSS sg13_lv_nmos ad=0.1577p pd=1.21u as=0.1577p ps=1.21u w=0.83u l=0.13u
X202 VSS a_293_53852# a_293_53366# VSS sg13_lv_nmos ad=0.1577p pd=1.21u as=0.1577p ps=1.21u w=0.83u l=0.13u
X203 VDD a_905_35226# a_905_35712# VDD sg13_lv_pmos ad=0.5508p pd=3.92u as=0.3078p ps=2u w=1.62u l=0.385u
X204 a_293_24342# a_293_24828# VSS VSS sg13_lv_nmos ad=0.1577p pd=1.21u as=0.1577p ps=1.21u w=0.83u l=0.13u
X205 VSS a_905_21200# a_905_20714# VSS sg13_lv_nmos ad=0.2822p pd=2.34u as=0.1577p ps=1.21u w=0.83u l=0.13u
X206 VDD a_293_17086# a_293_17572# VDD sg13_lv_pmos ad=0.3078p pd=2u as=0.3078p ps=2u w=1.62u l=0.385u
X207 VSS a_905_57480# a_905_56994# VSS sg13_lv_nmos ad=0.2822p pd=2.34u as=0.1577p ps=1.21u w=0.83u l=0.13u
X208 VSS a_293_42968# a_293_42482# VSS sg13_lv_nmos ad=0.1577p pd=1.21u as=0.1577p ps=1.21u w=0.83u l=0.13u
X209 a_905_32084# a_905_31598# VDD VDD sg13_lv_pmos ad=0.3078p pd=2u as=0.3078p ps=2u w=1.62u l=0.385u
X210 VSS a_905_21200# a_905_20714# VSS sg13_lv_nmos ad=0.1577p pd=1.21u as=0.1577p ps=1.21u w=0.83u l=0.13u
X211 VSS a_905_57480# a_905_56994# VSS sg13_lv_nmos ad=0.1577p pd=1.21u as=0.1577p ps=1.21u w=0.83u l=0.13u
X212 VDD a_293_38854# a_293_39340# VDD sg13_lv_pmos ad=0.3078p pd=2u as=0.3078p ps=2u w=1.62u l=0.385u
X213 VSS a_293_24828# a_293_24342# VSS sg13_lv_nmos ad=0.1577p pd=1.21u as=0.1577p ps=1.21u w=0.83u l=0.13u
X214 VSS a_905_13944# a_905_13458# VSS sg13_lv_nmos ad=0.2822p pd=2.34u as=0.1577p ps=1.21u w=0.83u l=0.13u
X215 a_293_53366# a_293_53852# VSS VSS sg13_lv_nmos ad=0.1577p pd=1.21u as=0.1577p ps=1.21u w=0.83u l=0.13u
X216 VSS a_905_58# a_905_336# VSS sg13_lv_nmos ad=0.1577p pd=1.21u as=0.1577p ps=1.21u w=0.83u l=0.13u
X217 a_905_42482# a_905_42968# VSS VSS sg13_lv_nmos ad=0.1577p pd=1.21u as=0.1577p ps=1.21u w=0.83u l=0.13u
X218 a_905_28456# a_905_27970# VDD VDD sg13_lv_pmos ad=0.3078p pd=2u as=0.3078p ps=2u w=1.62u l=0.385u
X219 VSS a_905_13944# a_905_13458# VSS sg13_lv_nmos ad=0.1577p pd=1.21u as=0.1577p ps=1.21u w=0.83u l=0.13u
X220 VDD a_293_56994# a_293_57480# VDD sg13_lv_pmos ad=0.3078p pd=2u as=0.3078p ps=2u w=1.62u l=0.385u
X221 VDD a_905_46110# a_905_46596# VDD sg13_lv_pmos ad=0.3078p pd=2u as=0.3078p ps=2u w=1.62u l=0.385u
X222 a_905_31598# a_905_32084# VSS VSS sg13_lv_nmos ad=0.1577p pd=1.21u as=0.1577p ps=1.21u w=0.83u l=0.13u
X223 a_905_38854# a_905_39340# VSS VSS sg13_lv_nmos ad=0.1577p pd=1.21u as=0.1577p ps=1.21u w=0.83u l=0.13u
X224 VDD a_293_49738# a_293_50224# VDD sg13_lv_pmos ad=0.3078p pd=2u as=0.3078p ps=2u w=1.62u l=0.385u
X225 VDD a_293_9830# a_293_10316# VDD sg13_lv_pmos ad=0.3078p pd=2u as=0.3078p ps=2u w=1.62u l=0.385u
X226 a_905_53366# a_905_53852# VSS VSS sg13_lv_nmos ad=0.1577p pd=1.21u as=0.1577p ps=1.21u w=0.83u l=0.13u
X227 a_293_42482# a_293_42968# VSS VSS sg13_lv_nmos ad=0.1577p pd=1.21u as=0.2822p ps=2.34u w=0.83u l=0.13u
X228 VDD a_905_20714# a_905_21200# VDD sg13_lv_pmos ad=0.5508p pd=3.92u as=0.3078p ps=2u w=1.62u l=0.385u
X229 VDD a_293_9830# a_293_10316# VDD sg13_lv_pmos ad=0.3078p pd=2u as=0.3078p ps=2u w=1.62u l=0.385u
X230 a_293_58# a_293_336# VDD VDD sg13_lv_pmos ad=0.3078p pd=2u as=0.5508p ps=3.92u w=1.62u l=0.385u
X231 VSS a_905_32084# a_905_31598# VSS sg13_lv_nmos ad=0.1577p pd=1.21u as=0.1577p ps=1.21u w=0.83u l=0.13u
X232 VDD a_905_17086# a_905_17572# VDD sg13_lv_pmos ad=0.5508p pd=3.92u as=0.3078p ps=2u w=1.62u l=0.385u
X233 a_293_336# a_293_58# VSS VSS sg13_lv_nmos ad=0.1577p pd=1.21u as=0.1577p ps=1.21u w=0.83u l=0.13u
X234 VSS a_293_35712# a_293_35226# VSS sg13_lv_nmos ad=0.1577p pd=1.21u as=0.1577p ps=1.21u w=0.83u l=0.13u
X235 a_905_13944# a_905_13458# VDD VDD sg13_lv_pmos ad=0.3078p pd=2u as=0.3078p ps=2u w=1.62u l=0.385u
X236 VDD a_293_42482# a_293_42968# VDD sg13_lv_pmos ad=0.3078p pd=2u as=0.3078p ps=2u w=1.62u l=0.385u
X237 VDD a_905_31598# a_905_32084# VDD sg13_lv_pmos ad=0.3078p pd=2u as=0.3078p ps=2u w=1.62u l=0.385u
X238 VSS a_905_53852# a_905_53366# VSS sg13_lv_nmos ad=0.1577p pd=1.21u as=0.1577p ps=1.21u w=0.83u l=0.13u
X239 a_293_39340# a_293_38854# VDD VDD sg13_lv_pmos ad=0.3078p pd=2u as=0.3078p ps=2u w=1.62u l=0.385u
X240 a_293_35226# a_293_35712# VSS VSS sg13_lv_nmos ad=0.1577p pd=1.21u as=0.1577p ps=1.21u w=0.83u l=0.13u
X241 a_905_24342# a_905_24828# VSS VSS sg13_lv_nmos ad=0.1577p pd=1.21u as=0.1577p ps=1.21u w=0.83u l=0.13u
X242 a_293_6688# a_293_6202# VDD VDD sg13_lv_pmos ad=0.3078p pd=2u as=0.3078p ps=2u w=1.62u l=0.385u
X243 a_905_6202# a_905_6688# VSS VSS sg13_lv_nmos ad=0.1577p pd=1.21u as=0.1577p ps=1.21u w=0.83u l=0.13u
X244 VSS a_905_6688# a_905_6202# VSS sg13_lv_nmos ad=0.1577p pd=1.21u as=0.1577p ps=1.21u w=0.83u l=0.13u
X245 a_293_9830# a_293_10316# VSS VSS sg13_lv_nmos ad=0.1577p pd=1.21u as=0.1577p ps=1.21u w=0.83u l=0.13u
X246 VDD a_905_56994# a_905_57480# VDD sg13_lv_pmos ad=0.5508p pd=3.92u as=0.3078p ps=2u w=1.62u l=0.385u
X247 a_293_46110# a_293_46596# VSS VSS sg13_lv_nmos ad=0.1577p pd=1.21u as=0.1577p ps=1.21u w=0.83u l=0.13u
X248 VSS a_905_42968# a_905_42482# VSS sg13_lv_nmos ad=0.2822p pd=2.34u as=0.1577p ps=1.21u w=0.83u l=0.13u
X249 VDD a_293_2574# a_293_3060# VDD sg13_lv_pmos ad=0.3078p pd=2u as=0.3078p ps=2u w=1.62u l=0.385u
X250 VDD a_293_2574# a_293_3060# VDD sg13_lv_pmos ad=0.3078p pd=2u as=0.3078p ps=2u w=1.62u l=0.385u
X251 a_905_39340# a_905_38854# VDD VDD sg13_lv_pmos ad=0.3078p pd=2u as=0.3078p ps=2u w=1.62u l=0.385u
X252 VDD a_905_27970# a_905_28456# VDD sg13_lv_pmos ad=0.3078p pd=2u as=0.3078p ps=2u w=1.62u l=0.385u
X253 VDD a_293_24342# a_293_24828# VDD sg13_lv_pmos ad=0.3078p pd=2u as=0.3078p ps=2u w=1.62u l=0.385u
X254 VSS a_905_42968# a_905_42482# VSS sg13_lv_nmos ad=0.1577p pd=1.21u as=0.1577p ps=1.21u w=0.83u l=0.13u
X255 VSS a_293_10316# a_293_9830# VSS sg13_lv_nmos ad=0.1577p pd=1.21u as=0.1577p ps=1.21u w=0.83u l=0.13u
X256 VDD a_905_49738# a_905_50224# VDD sg13_lv_pmos ad=0.5508p pd=3.92u as=0.3078p ps=2u w=1.62u l=0.385u
X257 VSS a_293_46596# a_293_46110# VSS sg13_lv_nmos ad=0.1577p pd=1.21u as=0.1577p ps=1.21u w=0.83u l=0.13u
X258 a_293_49738# a_293_50224# VSS VSS sg13_lv_nmos ad=0.1577p pd=1.21u as=0.1577p ps=1.21u w=0.83u l=0.13u
X259 VSS a_905_3060# a_905_2574# VSS sg13_lv_nmos ad=0.2822p pd=2.34u as=0.1577p ps=1.21u w=0.83u l=0.13u
X260 VSS a_293_6688# a_293_6202# VSS sg13_lv_nmos ad=0.1577p pd=1.21u as=0.1577p ps=1.21u w=0.83u l=0.13u
X261 VSS a_293_28456# a_293_27970# VSS sg13_lv_nmos ad=0.1577p pd=1.21u as=0.1577p ps=1.21u w=0.83u l=0.13u
X262 a_905_2574# a_905_3060# VSS VSS sg13_lv_nmos ad=0.1577p pd=1.21u as=0.1577p ps=1.21u w=0.83u l=0.13u
X263 VSS a_293_50224# a_293_49738# VSS sg13_lv_nmos ad=0.1577p pd=1.21u as=0.1577p ps=1.21u w=0.83u l=0.13u
X264 a_905_35226# a_905_35712# VSS VSS sg13_lv_nmos ad=0.1577p pd=1.21u as=0.1577p ps=1.21u w=0.83u l=0.13u
X265 a_293_39340# a_293_38854# VDD VDD sg13_lv_pmos ad=0.3078p pd=2u as=0.5508p ps=3.92u w=1.62u l=0.385u
X266 a_905_35712# a_905_35226# VDD VDD sg13_lv_pmos ad=0.3078p pd=2u as=0.3078p ps=2u w=1.62u l=0.385u
X267 a_293_27970# a_293_28456# VSS VSS sg13_lv_nmos ad=0.1577p pd=1.21u as=0.1577p ps=1.21u w=0.83u l=0.13u
X268 VSS a_293_17572# a_293_17086# VSS sg13_lv_nmos ad=0.1577p pd=1.21u as=0.1577p ps=1.21u w=0.83u l=0.13u
X269 VDD a_293_53366# a_293_53852# VDD sg13_lv_pmos ad=0.3078p pd=2u as=0.3078p ps=2u w=1.62u l=0.385u
X270 VDD a_905_42482# a_905_42968# VDD sg13_lv_pmos ad=0.5508p pd=3.92u as=0.3078p ps=2u w=1.62u l=0.385u
X271 VSS a_293_39340# a_293_38854# VSS sg13_lv_nmos ad=0.1577p pd=1.21u as=0.1577p ps=1.21u w=0.83u l=0.13u
X272 a_293_2574# a_293_3060# VSS VSS sg13_lv_nmos ad=0.1577p pd=1.21u as=0.1577p ps=1.21u w=0.83u l=0.13u
X273 VDD a_905_13458# a_905_13944# VDD sg13_lv_pmos ad=0.3078p pd=2u as=0.3078p ps=2u w=1.62u l=0.385u
X274 a_293_2574# a_293_3060# VSS VSS sg13_lv_nmos ad=0.1577p pd=1.21u as=0.2822p ps=2.34u w=0.83u l=0.13u
X275 a_905_38854# a_905_39340# VSS VSS sg13_lv_nmos ad=0.1577p pd=1.21u as=0.1577p ps=1.21u w=0.83u l=0.13u
X276 VSS a_905_35712# a_905_35226# VSS sg13_lv_nmos ad=0.1577p pd=1.21u as=0.1577p ps=1.21u w=0.83u l=0.13u
X277 VSS a_293_21200# a_293_20714# VSS sg13_lv_nmos ad=0.1577p pd=1.21u as=0.1577p ps=1.21u w=0.83u l=0.13u
X278 a_293_17086# a_293_17572# VSS VSS sg13_lv_nmos ad=0.1577p pd=1.21u as=0.1577p ps=1.21u w=0.83u l=0.13u
X279 a_905_27970# a_905_28456# VSS VSS sg13_lv_nmos ad=0.1577p pd=1.21u as=0.1577p ps=1.21u w=0.83u l=0.13u
X280 VSS a_905_58# a_905_336# VSS sg13_lv_nmos ad=0.2822p pd=2.34u as=0.1577p ps=1.21u w=0.83u l=0.13u
X281 VSS a_293_57480# a_293_56994# VSS sg13_lv_nmos ad=0.1577p pd=1.21u as=0.1577p ps=1.21u w=0.83u l=0.13u
X282 a_293_58# a_293_336# VDD VDD sg13_lv_pmos ad=0.3078p pd=2u as=0.3078p ps=2u w=1.62u l=0.385u
X283 a_293_24828# a_293_24342# VDD VDD sg13_lv_pmos ad=0.3078p pd=2u as=0.3078p ps=2u w=1.62u l=0.385u
X284 a_293_20714# a_293_21200# VSS VSS sg13_lv_nmos ad=0.1577p pd=1.21u as=0.1577p ps=1.21u w=0.83u l=0.13u
X285 VSS a_293_13944# a_293_13458# VSS sg13_lv_nmos ad=0.1577p pd=1.21u as=0.1577p ps=1.21u w=0.83u l=0.13u
X286 a_293_336# a_293_58# VSS VSS sg13_lv_nmos ad=0.1577p pd=1.21u as=0.1577p ps=1.21u w=0.83u l=0.13u
X287 a_905_9830# a_905_10316# VSS VSS sg13_lv_nmos ad=0.1577p pd=1.21u as=0.1577p ps=1.21u w=0.83u l=0.13u
X288 a_293_56994# a_293_57480# VSS VSS sg13_lv_nmos ad=0.1577p pd=1.21u as=0.1577p ps=1.21u w=0.83u l=0.13u
X289 a_905_46110# a_905_46596# VSS VSS sg13_lv_nmos ad=0.1577p pd=1.21u as=0.1577p ps=1.21u w=0.83u l=0.13u
X290 a_293_31598# a_293_32084# VSS VSS sg13_lv_nmos ad=0.1577p pd=1.21u as=0.1577p ps=1.21u w=0.83u l=0.13u
X291 a_905_10316# a_905_9830# VDD VDD sg13_lv_pmos ad=0.3078p pd=2u as=0.3078p ps=2u w=1.62u l=0.385u
X292 a_293_13458# a_293_13944# VSS VSS sg13_lv_nmos ad=0.1577p pd=1.21u as=0.1577p ps=1.21u w=0.83u l=0.13u
X293 a_293_38854# a_293_39340# VSS VSS sg13_lv_nmos ad=0.1577p pd=1.21u as=0.2822p ps=2.34u w=0.83u l=0.13u
X294 a_905_24828# a_905_24342# VDD VDD sg13_lv_pmos ad=0.3078p pd=2u as=0.3078p ps=2u w=1.62u l=0.385u
X295 a_905_21200# a_905_20714# VDD VDD sg13_lv_pmos ad=0.3078p pd=2u as=0.3078p ps=2u w=1.62u l=0.385u
X296 a_905_17086# a_905_17572# VSS VSS sg13_lv_nmos ad=0.1577p pd=1.21u as=0.1577p ps=1.21u w=0.83u l=0.13u
X297 VDD a_293_46110# a_293_46596# VDD sg13_lv_pmos ad=0.3078p pd=2u as=0.3078p ps=2u w=1.62u l=0.385u
X298 VSS a_293_32084# a_293_31598# VSS sg13_lv_nmos ad=0.1577p pd=1.21u as=0.1577p ps=1.21u w=0.83u l=0.13u
X299 VDD a_293_336# a_293_58# VDD sg13_lv_pmos ad=0.3078p pd=2u as=0.3078p ps=2u w=1.62u l=0.385u
X300 a_905_49738# a_905_50224# VSS VSS sg13_lv_nmos ad=0.1577p pd=1.21u as=0.1577p ps=1.21u w=0.83u l=0.13u
X301 a_293_53366# a_293_53852# VSS VSS sg13_lv_nmos ad=0.1577p pd=1.21u as=0.1577p ps=1.21u w=0.83u l=0.13u
X302 VSS a_905_28456# a_905_27970# VSS sg13_lv_nmos ad=0.1577p pd=1.21u as=0.1577p ps=1.21u w=0.83u l=0.13u
X303 VSS a_293_24828# a_293_24342# VSS sg13_lv_nmos ad=0.1577p pd=1.21u as=0.1577p ps=1.21u w=0.83u l=0.13u
X304 a_905_17572# a_905_17086# VDD VDD sg13_lv_pmos ad=0.3078p pd=2u as=0.3078p ps=2u w=1.62u l=0.385u
X305 a_905_10316# a_905_9830# VDD VDD sg13_lv_pmos ad=0.3078p pd=2u as=0.3078p ps=2u w=1.62u l=0.385u
X306 VDD a_905_35226# a_905_35712# VDD sg13_lv_pmos ad=0.3078p pd=2u as=0.3078p ps=2u w=1.62u l=0.385u
X307 a_905_20714# a_905_21200# VSS VSS sg13_lv_nmos ad=0.1577p pd=1.21u as=0.1577p ps=1.21u w=0.83u l=0.13u
X308 a_905_56994# a_905_57480# VSS VSS sg13_lv_nmos ad=0.1577p pd=1.21u as=0.1577p ps=1.21u w=0.83u l=0.13u
X309 a_905_24342# a_905_24828# VSS VSS sg13_lv_nmos ad=0.1577p pd=1.21u as=0.1577p ps=1.21u w=0.83u l=0.13u
X310 VSS a_293_53852# a_293_53366# VSS sg13_lv_nmos ad=0.1577p pd=1.21u as=0.1577p ps=1.21u w=0.83u l=0.13u
X311 VDD a_293_38854# a_293_39340# VDD sg13_lv_pmos ad=0.3078p pd=2u as=0.3078p ps=2u w=1.62u l=0.385u
X312 a_293_24828# a_293_24342# VDD VDD sg13_lv_pmos ad=0.3078p pd=2u as=0.5508p ps=3.92u w=1.62u l=0.385u
X313 VDD a_905_6202# a_905_6688# VDD sg13_lv_pmos ad=0.5508p pd=3.92u as=0.3078p ps=2u w=1.62u l=0.385u
X314 a_905_13458# a_905_13944# VSS VSS sg13_lv_nmos ad=0.1577p pd=1.21u as=0.1577p ps=1.21u w=0.83u l=0.13u
X315 a_905_57480# a_905_56994# VDD VDD sg13_lv_pmos ad=0.3078p pd=2u as=0.3078p ps=2u w=1.62u l=0.385u
X316 a_293_53852# a_293_53366# VDD VDD sg13_lv_pmos ad=0.3078p pd=2u as=0.3078p ps=2u w=1.62u l=0.385u
X317 VDD a_905_6202# a_905_6688# VDD sg13_lv_pmos ad=0.3078p pd=2u as=0.3078p ps=2u w=1.62u l=0.385u
X318 VSS a_905_17572# a_905_17086# VSS sg13_lv_nmos ad=0.1577p pd=1.21u as=0.1577p ps=1.21u w=0.83u l=0.13u
X319 a_905_3060# a_905_2574# VDD VDD sg13_lv_pmos ad=0.3078p pd=2u as=0.3078p ps=2u w=1.62u l=0.385u
X320 a_905_53852# a_905_53366# VDD VDD sg13_lv_pmos ad=0.3078p pd=2u as=0.3078p ps=2u w=1.62u l=0.385u
X321 VSS a_905_39340# a_905_38854# VSS sg13_lv_nmos ad=0.2822p pd=2.34u as=0.1577p ps=1.21u w=0.83u l=0.13u
X322 a_905_50224# a_905_49738# VDD VDD sg13_lv_pmos ad=0.3078p pd=2u as=0.3078p ps=2u w=1.62u l=0.385u
X323 VSS a_905_39340# a_905_38854# VSS sg13_lv_nmos ad=0.1577p pd=1.21u as=0.1577p ps=1.21u w=0.83u l=0.13u
X324 a_293_24342# a_293_24828# VSS VSS sg13_lv_nmos ad=0.1577p pd=1.21u as=0.2822p ps=2.34u w=0.83u l=0.13u
X325 VSS a_905_21200# a_905_20714# VSS sg13_lv_nmos ad=0.1577p pd=1.21u as=0.1577p ps=1.21u w=0.83u l=0.13u
X326 VSS a_905_6688# a_905_6202# VSS sg13_lv_nmos ad=0.2822p pd=2.34u as=0.1577p ps=1.21u w=0.83u l=0.13u
X327 VDD a_293_31598# a_293_32084# VDD sg13_lv_pmos ad=0.3078p pd=2u as=0.3078p ps=2u w=1.62u l=0.385u
X328 a_905_3060# a_905_2574# VDD VDD sg13_lv_pmos ad=0.3078p pd=2u as=0.3078p ps=2u w=1.62u l=0.385u
X329 a_905_6202# a_905_6688# VSS VSS sg13_lv_nmos ad=0.1577p pd=1.21u as=0.1577p ps=1.21u w=0.83u l=0.13u
X330 VSS a_905_57480# a_905_56994# VSS sg13_lv_nmos ad=0.1577p pd=1.21u as=0.1577p ps=1.21u w=0.83u l=0.13u
X331 VSS a_293_42968# a_293_42482# VSS sg13_lv_nmos ad=0.1577p pd=1.21u as=0.1577p ps=1.21u w=0.83u l=0.13u
X332 a_293_6688# a_293_6202# VDD VDD sg13_lv_pmos ad=0.3078p pd=2u as=0.5508p ps=3.92u w=1.62u l=0.385u
X333 VDD a_905_20714# a_905_21200# VDD sg13_lv_pmos ad=0.3078p pd=2u as=0.3078p ps=2u w=1.62u l=0.385u
X334 VSS a_905_13944# a_905_13458# VSS sg13_lv_nmos ad=0.1577p pd=1.21u as=0.1577p ps=1.21u w=0.83u l=0.13u
X335 a_293_53852# a_293_53366# VDD VDD sg13_lv_pmos ad=0.3078p pd=2u as=0.5508p ps=3.92u w=1.62u l=0.385u
X336 a_293_46596# a_293_46110# VDD VDD sg13_lv_pmos ad=0.3078p pd=2u as=0.3078p ps=2u w=1.62u l=0.385u
X337 a_293_42482# a_293_42968# VSS VSS sg13_lv_nmos ad=0.1577p pd=1.21u as=0.1577p ps=1.21u w=0.83u l=0.13u
X338 VDD a_293_27970# a_293_28456# VDD sg13_lv_pmos ad=0.3078p pd=2u as=0.3078p ps=2u w=1.62u l=0.385u
X339 a_905_31598# a_905_32084# VSS VSS sg13_lv_nmos ad=0.1577p pd=1.21u as=0.1577p ps=1.21u w=0.83u l=0.13u
.ends

.subckt RM_IHPSG13_1P_ROWREG8 ADDR_N_O<5> BIST_EN_I ADDR_N_O<0> ADDR_N_O<1> ADDR_N_O<2>
+ ADDR_N_O<3> ADDR_I<7> ADDR_I<0> ADDR_I<1> ADDR_I<2> ADDR_N_O<4> BIST_ADDR_I<0> BIST_ADDR_I<1>
+ BIST_ADDR_I<2> BIST_ADDR_I<3> ADDR_N_O<6> ADDR_N_O<7> BIST_ADDR_I<4> BIST_ADDR_I<5>
+ BIST_ADDR_I<6> BIST_ADDR_I<7> ADDR_I<3> ADDR_I<4> ADDR_I<5> ADDR_I<6> RM_IHPSG13_1P_ROWREG0_0/m3_n1122_n273#
+ ACLK_N_I RM_IHPSG13_1P_ROWREG0_0/m2_6482_n2520# RM_IHPSG13_1P_ROWREG0_0/m2_4442_n2520#
+ RM_IHPSG13_1P_ROWREG0_0/m3_4544_n441# RM_IHPSG13_1P_ROWREG0_0/m2_4340_n2520# RM_IHPSG13_1P_ROWREG0_0/m2_1178_n2520#
+ VSS VDD
X0 a_13_n675# a_n285_n675# a_n89_n675# VDD sg13_lv_pmos ad=0.14927p pd=1.355u as=0.18525p ps=1.355u w=0.975u l=0.13u
X1 a_2563_n1200# ACLK_N_I a_1989_n1403# VDD sg13_lv_pmos ad=0.1881p pd=1.37u as=0.1511p ps=1.37u w=0.99u l=0.13u
X2 a_4271_n1344# a_4271_n1622# VSS VSS sg13_lv_nmos ad=0.1577p pd=1.21u as=0.1577p ps=1.21u w=0.83u l=0.13u
X3 a_4501_n675# BIST_EN_I a_4399_n675# VDD sg13_lv_pmos ad=0.18715p pd=1.365u as=0.18715p ps=1.365u w=0.985u l=0.13u
X4 a_2971_n1952# a_2639_n2394# VSS VSS sg13_lv_nmos ad=91.2f pd=0.86u as=91.2f ps=0.86u w=0.48u l=0.13u
X5 VSS a_5291_n680# a_5215_n272# VSS sg13_lv_nmos ad=91.2f pd=0.86u as=91.2f ps=0.86u w=0.48u l=0.13u
X6 a_1989_n1403# a_2401_n1030# a_2359_n1198# VDD sg13_lv_pmos ad=0.1511p pd=1.37u as=91.2f ps=0.86u w=0.48u l=0.13u
X7 VSS a_6107_n1622# a_6107_n1344# VSS sg13_lv_nmos ad=0.1577p pd=1.21u as=0.1577p ps=1.21u w=0.83u l=0.13u
X8 a_5725_n678# a_4815_n675# a_5623_n312# VSS sg13_lv_nmos ad=0.13375p pd=1.23u as=0.1783p ps=1.44u w=0.85u l=0.13u
X9 a_n497_n1522# BIST_EN_I a_n599_n1522# VSS sg13_lv_nmos ad=0.1064p pd=0.94u as=0.1064p ps=0.94u w=0.56u l=0.13u
X10 VSS a_5495_n1622# a_5495_n1344# VSS sg13_lv_nmos ad=0.1577p pd=1.21u as=0.1577p ps=1.21u w=0.83u l=0.13u
X11 a_4603_n1950# BIST_EN_I a_4501_n2355# VSS sg13_lv_nmos ad=0.1064p pd=0.94u as=0.1064p ps=0.94u w=0.56u l=0.13u
X12 a_115_n582# ACLK_N_I a_13_n675# VDD sg13_lv_pmos ad=91.2f pd=0.86u as=0.14927p ps=1.355u w=0.48u l=0.13u
X13 a_2401_n746# ACLK_N_I VSS VSS sg13_lv_nmos ad=0.1683p pd=1.67u as=0.13717p ps=1.25u w=0.495u l=0.13u
X14 a_1619_n1620# a_1989_n1403# VSS VSS sg13_lv_nmos ad=0.2397p pd=2.09u as=0.13395p ps=1.085u w=0.705u l=0.13u
X15 a_3787_n1522# a_3624_n991# a_3251_n1620# VSS sg13_lv_nmos ad=0.1064p pd=0.94u as=0.1064p ps=0.94u w=0.56u l=0.13u
X16 VDD a_1619_n2460# ADDR_N_O<0> VDD sg13_lv_pmos ad=0.3078p pd=2u as=0.3078p ps=2u w=1.62u l=0.13u
X17 a_n599_n2355# BIST_EN_I a_n701_n2355# VDD sg13_lv_pmos ad=0.18715p pd=1.365u as=0.18715p ps=1.365u w=0.985u l=0.13u
X18 VDD a_1041_n2424# ADDR_N_O<1> VDD sg13_lv_pmos ad=0.3078p pd=2u as=0.3078p ps=2u w=1.62u l=0.13u
X19 a_2563_n1950# a_2401_n2426# a_1989_n2053# VSS sg13_lv_nmos ad=0.1783p pd=1.44u as=0.13375p ps=1.23u w=0.85u l=0.13u
X20 VDD ACLK_N_I a_n285_n2355# VDD sg13_lv_pmos ad=0.14812p pd=1.355u as=0.1632p ps=1.64u w=0.48u l=0.13u
X21 a_5291_n680# a_5113_n675# VDD VDD sg13_lv_pmos ad=0.1632p pd=1.64u as=91.2f ps=0.86u w=0.48u l=0.13u
X22 a_5113_n2355# a_4815_n2355# a_5011_n2355# VDD sg13_lv_pmos ad=0.14927p pd=1.355u as=0.18525p ps=1.355u w=0.975u l=0.13u
X23 VDD ADDR_I<0> a_3787_n2355# VDD sg13_lv_pmos ad=0.16165p pd=1.365u as=0.18715p ps=1.365u w=0.985u l=0.13u
X24 a_2838_n2085# ACLK_N_I a_2971_n2262# VDD sg13_lv_pmos ad=0.14927p pd=1.355u as=91.2f ps=0.86u w=0.48u l=0.13u
X25 a_2971_n272# a_2639_n714# VSS VSS sg13_lv_nmos ad=91.2f pd=0.86u as=91.2f ps=0.86u w=0.48u l=0.13u
X26 a_625_n1580# ACLK_N_I a_523_n1200# VDD sg13_lv_pmos ad=0.1511p pd=1.37u as=0.1881p ps=1.37u w=0.99u l=0.13u
X27 VSS ACLK_N_I a_4815_n2355# VSS sg13_lv_nmos ad=0.13717p pd=1.25u as=0.1683p ps=1.67u w=0.495u l=0.13u
X28 VSS a_191_n680# a_115_n272# VSS sg13_lv_nmos ad=91.2f pd=0.86u as=91.2f ps=0.86u w=0.48u l=0.13u
X29 a_5113_n675# a_4815_n675# a_5011_n675# VDD sg13_lv_pmos ad=0.14927p pd=1.355u as=0.18525p ps=1.355u w=0.975u l=0.13u
X30 a_625_n678# a_n285_n675# a_523_n312# VSS sg13_lv_nmos ad=0.13375p pd=1.23u as=0.1783p ps=1.44u w=0.85u l=0.13u
X31 a_5495_n1622# a_5495_n1344# VDD VDD sg13_lv_pmos ad=0.3078p pd=2u as=0.3078p ps=2u w=1.62u l=0.385u
X32 a_115_n1194# ACLK_N_I a_13_n1582# VDD sg13_lv_pmos ad=91.2f pd=0.86u as=0.14927p ps=1.355u w=0.48u l=0.13u
X33 VDD a_803_n1620# a_727_n1198# VDD sg13_lv_pmos ad=91.2f pd=0.86u as=91.2f ps=0.86u w=0.48u l=0.13u
X34 VSS BIST_EN_I a_4203_n2355# VSS sg13_lv_nmos ad=0.1064p pd=0.94u as=0.1904p ps=1.8u w=0.56u l=0.13u
X35 VDD a_1041_n744# ADDR_N_O<5> VDD sg13_lv_pmos ad=0.3078p pd=2u as=0.3078p ps=2u w=1.62u l=0.13u
X36 a_5903_n677# a_5725_n678# VSS VSS sg13_lv_nmos ad=0.1632p pd=1.64u as=91.2f ps=0.86u w=0.48u l=0.13u
X37 a_191_n1540# a_13_n1582# VDD VDD sg13_lv_pmos ad=0.1632p pd=1.64u as=91.2f ps=0.86u w=0.48u l=0.13u
X38 a_5495_n1622# a_5495_n1344# VDD VDD sg13_lv_pmos ad=0.3078p pd=2u as=0.3078p ps=2u w=1.62u l=0.385u
X39 a_625_n2358# a_n285_n2355# a_523_n1992# VSS sg13_lv_nmos ad=0.13375p pd=1.23u as=0.1783p ps=1.44u w=0.85u l=0.13u
X40 VSS a_2639_n2394# a_2563_n1950# VSS sg13_lv_nmos ad=0.289p pd=2.38u as=0.1783p ps=1.44u w=0.85u l=0.13u
X41 ADDR_N_O<3> a_1619_n780# VSS VSS sg13_lv_nmos ad=0.13395p pd=1.085u as=0.13395p ps=1.085u w=0.705u l=0.13u
X42 VSS a_1989_n373# a_2163_n746# VSS sg13_lv_nmos ad=91.2f pd=0.86u as=0.1632p ps=1.64u w=0.48u l=0.13u
X43 ADDR_N_O<2> a_1619_n1620# VDD VDD sg13_lv_pmos ad=0.3078p pd=2u as=0.3078p ps=2u w=1.62u l=0.13u
X44 VDD a_4271_n1344# a_4271_n1622# VDD sg13_lv_pmos ad=0.3078p pd=2u as=0.3078p ps=2u w=1.62u l=0.385u
X45 VSS a_1989_n2053# a_2163_n2426# VSS sg13_lv_nmos ad=91.2f pd=0.86u as=0.1632p ps=1.64u w=0.48u l=0.13u
X46 VSS a_1041_n744# ADDR_N_O<5> VSS sg13_lv_nmos ad=0.13395p pd=1.085u as=0.13395p ps=1.085u w=0.705u l=0.13u
X47 a_191_n680# a_13_n675# VDD VDD sg13_lv_pmos ad=0.1632p pd=1.64u as=91.2f ps=0.86u w=0.48u l=0.13u
X48 ADDR_N_O<4> a_1041_n1582# VDD VDD sg13_lv_pmos ad=0.3078p pd=2u as=0.3078p ps=2u w=1.62u l=0.13u
X49 a_5495_n1344# a_5495_n1622# VSS VSS sg13_lv_nmos ad=0.1577p pd=1.21u as=0.1577p ps=1.21u w=0.83u l=0.13u
X50 a_n599_n675# a_n897_n675# a_n701_n270# VSS sg13_lv_nmos ad=0.1064p pd=0.94u as=0.1064p ps=0.94u w=0.56u l=0.13u
X51 a_803_n2357# a_625_n2358# VSS VSS sg13_lv_nmos ad=0.1632p pd=1.64u as=91.2f ps=0.86u w=0.48u l=0.13u
X52 VSS a_1619_n2460# ADDR_N_O<0> VSS sg13_lv_nmos ad=0.13395p pd=1.085u as=0.13395p ps=1.085u w=0.705u l=0.13u
X53 VSS a_1041_n2424# ADDR_N_O<1> VSS sg13_lv_nmos ad=0.13395p pd=1.085u as=0.13395p ps=1.085u w=0.705u l=0.13u
X54 VSS a_625_n2358# a_1041_n2424# VSS sg13_lv_nmos ad=0.13395p pd=1.085u as=0.2397p ps=2.09u w=0.705u l=0.13u
X55 VSS ADDR_I<3> a_3787_n270# VSS sg13_lv_nmos ad=0.1064p pd=0.94u as=0.1064p ps=0.94u w=0.56u l=0.13u
X56 ADDR_N_O<2> a_1619_n1620# VSS VSS sg13_lv_nmos ad=0.13395p pd=1.085u as=0.13395p ps=1.085u w=0.705u l=0.13u
X57 VSS a_2838_n1371# a_2639_n1574# VSS sg13_lv_nmos ad=91.2f pd=0.86u as=0.1632p ps=1.64u w=0.48u l=0.13u
X58 a_115_n1952# a_n285_n2355# a_13_n2355# VSS sg13_lv_nmos ad=91.2f pd=0.86u as=0.13605p ps=1.25u w=0.48u l=0.13u
X59 a_191_n2360# a_13_n2355# VSS VSS sg13_lv_nmos ad=0.1632p pd=1.64u as=91.2f ps=0.86u w=0.48u l=0.13u
X60 ADDR_N_O<6> a_6141_n2424# VDD VDD sg13_lv_pmos ad=0.3078p pd=2u as=0.3078p ps=2u w=1.62u l=0.13u
X61 a_n701_n675# ADDR_I<5> VDD VDD sg13_lv_pmos ad=0.18715p pd=1.365u as=0.16165p ps=1.365u w=0.985u l=0.13u
X62 a_3583_n270# BIST_ADDR_I<3> VSS VSS sg13_lv_nmos ad=0.1064p pd=0.94u as=0.1904p ps=1.8u w=0.56u l=0.13u
X63 a_2838_n1371# ACLK_N_I a_2971_n1194# VDD sg13_lv_pmos ad=0.14927p pd=1.355u as=91.2f ps=0.86u w=0.48u l=0.13u
X64 ADDR_N_O<7> a_6141_n744# VDD VDD sg13_lv_pmos ad=0.3078p pd=2u as=0.3078p ps=2u w=1.62u l=0.13u
X65 a_13_n1582# ACLK_N_I a_n89_n1582# VSS sg13_lv_nmos ad=0.13605p pd=1.25u as=0.1653p ps=1.25u w=0.87u l=0.13u
X66 VSS a_5725_n678# a_6141_n744# VSS sg13_lv_nmos ad=0.13395p pd=1.085u as=0.2397p ps=2.09u w=0.705u l=0.13u
X67 ADDR_N_O<7> a_6141_n744# VSS VSS sg13_lv_nmos ad=0.13395p pd=1.085u as=0.13395p ps=1.085u w=0.705u l=0.13u
X68 VDD BIST_ADDR_I<6> a_4603_n2355# VDD sg13_lv_pmos ad=0.3349p pd=2.65u as=0.18715p ps=1.365u w=0.985u l=0.13u
X69 a_3624_n749# BIST_EN_I VDD VDD sg13_lv_pmos ad=0.2193p pd=1.97u as=0.16165p ps=1.365u w=0.645u l=0.13u
X70 a_13_n675# ACLK_N_I a_n89_n272# VSS sg13_lv_nmos ad=0.13605p pd=1.25u as=0.1653p ps=1.25u w=0.87u l=0.13u
X71 a_3251_n711# a_3624_n749# a_3583_n675# VDD sg13_lv_pmos ad=0.18715p pd=1.365u as=0.18715p ps=1.365u w=0.985u l=0.13u
X72 a_n89_n1582# a_n599_n1522# VSS VSS sg13_lv_nmos ad=0.1653p pd=1.25u as=0.13717p ps=1.25u w=0.87u l=0.13u
X73 VSS a_4883_n1622# a_4883_n1344# VSS sg13_lv_nmos ad=0.1577p pd=1.21u as=0.1577p ps=1.21u w=0.83u l=0.13u
X74 a_5113_n2355# ACLK_N_I a_5011_n1952# VSS sg13_lv_nmos ad=0.13605p pd=1.25u as=0.1653p ps=1.25u w=0.87u l=0.13u
X75 ADDR_N_O<1> a_1041_n2424# VSS VSS sg13_lv_nmos ad=0.13395p pd=1.085u as=0.13395p ps=1.085u w=0.705u l=0.13u
X76 a_2401_n1030# ACLK_N_I VSS VSS sg13_lv_nmos ad=0.1683p pd=1.67u as=0.13717p ps=1.25u w=0.495u l=0.13u
X77 a_n599_n2355# a_n897_n2355# a_n701_n1950# VSS sg13_lv_nmos ad=0.1064p pd=0.94u as=0.1064p ps=0.94u w=0.56u l=0.13u
X78 a_2838_n2085# a_2401_n2426# a_2971_n1952# VSS sg13_lv_nmos ad=0.13605p pd=1.25u as=91.2f ps=0.86u w=0.48u l=0.13u
X79 VDD a_3251_n711# a_3175_n675# VDD sg13_lv_pmos ad=0.14812p pd=1.355u as=0.18525p ps=1.355u w=0.975u l=0.13u
X80 a_n701_n1202# ADDR_I<4> VDD VDD sg13_lv_pmos ad=0.18715p pd=1.365u as=0.16165p ps=1.365u w=0.985u l=0.13u
X81 VSS a_1619_n1620# ADDR_N_O<2> VSS sg13_lv_nmos ad=0.13395p pd=1.085u as=0.13395p ps=1.085u w=0.705u l=0.13u
X82 VSS a_1989_n1403# a_2163_n1506# VSS sg13_lv_nmos ad=91.2f pd=0.86u as=0.1632p ps=1.64u w=0.48u l=0.13u
X83 VSS a_2639_n1574# a_2563_n1580# VSS sg13_lv_nmos ad=0.289p pd=2.38u as=0.1783p ps=1.44u w=0.85u l=0.13u
X84 VSS ADDR_I<0> a_3787_n1950# VSS sg13_lv_nmos ad=0.1064p pd=0.94u as=0.1064p ps=0.94u w=0.56u l=0.13u
X85 VDD a_2639_n2394# a_2563_n2358# VDD sg13_lv_pmos ad=0.3366p pd=2.66u as=0.1881p ps=1.37u w=0.99u l=0.13u
X86 a_4501_n675# a_4203_n675# a_4399_n270# VSS sg13_lv_nmos ad=0.1064p pd=0.94u as=0.1064p ps=0.94u w=0.56u l=0.13u
X87 a_5903_n677# a_5725_n678# VDD VDD sg13_lv_pmos ad=0.1632p pd=1.64u as=91.2f ps=0.86u w=0.48u l=0.13u
X88 VSS a_1041_n1582# ADDR_N_O<4> VSS sg13_lv_nmos ad=0.13395p pd=1.085u as=0.13395p ps=1.085u w=0.705u l=0.13u
X89 VDD a_5495_n1344# a_5495_n1622# VDD sg13_lv_pmos ad=0.3078p pd=2u as=0.3078p ps=2u w=1.62u l=0.385u
X90 VDD a_1989_n373# a_2163_n746# VDD sg13_lv_pmos ad=91.2f pd=0.86u as=0.1632p ps=1.64u w=0.48u l=0.13u
X91 a_803_n1620# a_625_n1580# VSS VSS sg13_lv_nmos ad=0.1632p pd=1.64u as=91.2f ps=0.86u w=0.48u l=0.13u
X92 a_3583_n1202# BIST_ADDR_I<2> VDD VDD sg13_lv_pmos ad=0.18715p pd=1.365u as=0.3349p ps=2.65u w=0.985u l=0.13u
X93 a_5827_n1950# ACLK_N_I a_5725_n2358# VSS sg13_lv_nmos ad=91.2f pd=0.86u as=0.13375p ps=1.23u w=0.48u l=0.13u
X94 a_115_n272# a_n285_n675# a_13_n675# VSS sg13_lv_nmos ad=91.2f pd=0.86u as=0.13605p ps=1.25u w=0.48u l=0.13u
X95 a_4399_n2355# ADDR_I<6> VDD VDD sg13_lv_pmos ad=0.18715p pd=1.365u as=0.16165p ps=1.365u w=0.985u l=0.13u
X96 VSS ACLK_N_I a_n285_n675# VSS sg13_lv_nmos ad=0.13717p pd=1.25u as=0.1683p ps=1.67u w=0.495u l=0.13u
X97 a_4603_n675# a_4203_n675# a_4501_n675# VDD sg13_lv_pmos ad=0.18715p pd=1.365u as=0.18715p ps=1.365u w=0.985u l=0.13u
X98 VDD ACLK_N_I a_4815_n675# VDD sg13_lv_pmos ad=0.14812p pd=1.355u as=0.1632p ps=1.64u w=0.48u l=0.13u
X99 a_5291_n680# a_5113_n675# VSS VSS sg13_lv_nmos ad=0.1632p pd=1.64u as=91.2f ps=0.86u w=0.48u l=0.13u
X100 a_5113_n675# ACLK_N_I a_5011_n272# VSS sg13_lv_nmos ad=0.13605p pd=1.25u as=0.1653p ps=1.25u w=0.87u l=0.13u
X101 a_5623_n1992# a_5291_n2360# VSS VSS sg13_lv_nmos ad=0.1783p pd=1.44u as=0.289p ps=2.38u w=0.85u l=0.13u
X102 a_5827_n270# ACLK_N_I a_5725_n678# VSS sg13_lv_nmos ad=91.2f pd=0.86u as=0.13375p ps=1.23u w=0.48u l=0.13u
X103 VDD a_1989_n2053# a_2163_n2426# VDD sg13_lv_pmos ad=91.2f pd=0.86u as=0.1632p ps=1.64u w=0.48u l=0.13u
X104 a_5623_n312# a_5291_n680# VSS VSS sg13_lv_nmos ad=0.1783p pd=1.44u as=0.289p ps=2.38u w=0.85u l=0.13u
X105 VDD BIST_ADDR_I<4> a_n497_n1202# VDD sg13_lv_pmos ad=0.3349p pd=2.65u as=0.18715p ps=1.365u w=0.985u l=0.13u
X106 a_2401_n2426# ACLK_N_I VSS VSS sg13_lv_nmos ad=0.1683p pd=1.67u as=0.13717p ps=1.25u w=0.495u l=0.13u
X107 VSS a_191_n1540# a_115_n1504# VSS sg13_lv_nmos ad=91.2f pd=0.86u as=91.2f ps=0.86u w=0.48u l=0.13u
X108 a_3624_n991# BIST_EN_I VDD VDD sg13_lv_pmos ad=0.2193p pd=1.97u as=0.16165p ps=1.365u w=0.645u l=0.13u
X109 VDD a_4883_n1344# a_4883_n1622# VDD sg13_lv_pmos ad=0.3078p pd=2u as=0.3078p ps=2u w=1.62u l=0.385u
X110 a_803_n2357# a_625_n2358# VDD VDD sg13_lv_pmos ad=0.1632p pd=1.64u as=91.2f ps=0.86u w=0.48u l=0.13u
X111 a_5215_n582# ACLK_N_I a_5113_n675# VDD sg13_lv_pmos ad=91.2f pd=0.86u as=0.14927p ps=1.355u w=0.48u l=0.13u
X112 VSS a_4883_n1622# a_4883_n1344# VSS sg13_lv_nmos ad=0.1577p pd=1.21u as=0.1577p ps=1.21u w=0.83u l=0.13u
X113 VSS a_6141_n2424# ADDR_N_O<6> VSS sg13_lv_nmos ad=0.13395p pd=1.085u as=0.13395p ps=1.085u w=0.705u l=0.13u
X114 VDD a_2639_n1574# a_2563_n1200# VDD sg13_lv_pmos ad=0.3366p pd=2.66u as=0.1881p ps=1.37u w=0.99u l=0.13u
X115 VSS a_4271_n1622# a_4271_n1344# VSS sg13_lv_nmos ad=0.1577p pd=1.21u as=0.1577p ps=1.21u w=0.83u l=0.13u
X116 a_1619_n2460# a_1989_n2053# VSS VSS sg13_lv_nmos ad=0.2397p pd=2.09u as=0.13395p ps=1.085u w=0.705u l=0.13u
X117 a_191_n680# a_13_n675# VSS VSS sg13_lv_nmos ad=0.1632p pd=1.64u as=91.2f ps=0.86u w=0.48u l=0.13u
X118 a_6107_n1344# a_6107_n1622# VSS VSS sg13_lv_nmos ad=0.1577p pd=1.21u as=0.1577p ps=1.21u w=0.83u l=0.13u
X119 a_727_n270# ACLK_N_I a_625_n678# VSS sg13_lv_nmos ad=91.2f pd=0.86u as=0.13375p ps=1.23u w=0.48u l=0.13u
X120 a_n599_n1522# a_n897_n1522# a_n701_n1522# VSS sg13_lv_nmos ad=0.1064p pd=0.94u as=0.1064p ps=0.94u w=0.56u l=0.13u
X121 a_6107_n1344# a_6107_n1622# VSS VSS sg13_lv_nmos ad=0.1577p pd=1.21u as=0.1577p ps=1.21u w=0.83u l=0.13u
X122 VSS BIST_ADDR_I<6> a_4603_n1950# VSS sg13_lv_nmos ad=0.1904p pd=1.8u as=0.1064p ps=0.94u w=0.56u l=0.13u
X123 VDD a_1619_n780# ADDR_N_O<3> VDD sg13_lv_pmos ad=0.3078p pd=2u as=0.3078p ps=2u w=1.62u l=0.13u
X124 VSS ADDR_I<2> a_3787_n1522# VSS sg13_lv_nmos ad=0.1064p pd=0.94u as=0.1064p ps=0.94u w=0.56u l=0.13u
X125 a_5215_n2262# ACLK_N_I a_5113_n2355# VDD sg13_lv_pmos ad=91.2f pd=0.86u as=0.14927p ps=1.355u w=0.48u l=0.13u
X126 ADDR_N_O<0> a_1619_n2460# VDD VDD sg13_lv_pmos ad=0.3078p pd=2u as=0.3078p ps=2u w=1.62u l=0.13u
X127 a_523_n312# a_191_n680# VSS VSS sg13_lv_nmos ad=0.1783p pd=1.44u as=0.289p ps=2.38u w=0.85u l=0.13u
X128 VSS a_1619_n780# ADDR_N_O<3> VSS sg13_lv_nmos ad=0.13395p pd=1.085u as=0.13395p ps=1.085u w=0.705u l=0.13u
X129 a_2359_n270# a_2163_n746# VSS VSS sg13_lv_nmos ad=91.2f pd=0.86u as=91.2f ps=0.86u w=0.48u l=0.13u
X130 VDD a_625_n678# a_1041_n744# VDD sg13_lv_pmos ad=0.3078p pd=2u as=0.5508p ps=3.92u w=1.62u l=0.13u
X131 ADDR_N_O<5> a_1041_n744# VDD VDD sg13_lv_pmos ad=0.3078p pd=2u as=0.3078p ps=2u w=1.62u l=0.13u
X132 a_2563_n1580# a_2401_n1030# a_1989_n1403# VSS sg13_lv_nmos ad=0.1783p pd=1.44u as=0.13375p ps=1.23u w=0.85u l=0.13u
X133 a_n701_n2355# ADDR_I<1> VDD VDD sg13_lv_pmos ad=0.18715p pd=1.365u as=0.16165p ps=1.365u w=0.985u l=0.13u
X134 ADDR_N_O<1> a_1041_n2424# VDD VDD sg13_lv_pmos ad=0.3078p pd=2u as=0.3078p ps=2u w=1.62u l=0.13u
X135 ADDR_N_O<3> a_1619_n780# VSS VSS sg13_lv_nmos ad=0.13395p pd=1.085u as=0.13395p ps=1.085u w=0.705u l=0.13u
X136 a_3624_n2429# BIST_EN_I VDD VDD sg13_lv_pmos ad=0.2193p pd=1.97u as=0.16165p ps=1.365u w=0.645u l=0.13u
X137 a_n701_n270# ADDR_I<5> VSS VSS sg13_lv_nmos ad=0.1064p pd=0.94u as=0.1064p ps=0.94u w=0.56u l=0.13u
X138 a_3583_n2355# BIST_ADDR_I<0> VDD VDD sg13_lv_pmos ad=0.18715p pd=1.365u as=0.3349p ps=2.65u w=0.985u l=0.13u
X139 ADDR_N_O<5> a_1041_n744# VSS VSS sg13_lv_nmos ad=0.13395p pd=1.085u as=0.13395p ps=1.085u w=0.705u l=0.13u
X140 a_5623_n2358# a_5291_n2360# VDD VDD sg13_lv_pmos ad=0.1881p pd=1.37u as=0.3366p ps=2.66u w=0.99u l=0.13u
X141 a_4271_n1344# a_4271_n1622# VSS VSS sg13_lv_nmos ad=0.1577p pd=1.21u as=0.2822p ps=2.34u w=0.83u l=0.13u
X142 a_3175_n2355# a_2401_n2426# a_2838_n2085# VDD sg13_lv_pmos ad=0.18525p pd=1.355u as=0.14927p ps=1.355u w=0.975u l=0.13u
X143 a_5827_n578# a_4815_n675# a_5725_n678# VDD sg13_lv_pmos ad=91.2f pd=0.86u as=0.1511p ps=1.37u w=0.48u l=0.13u
X144 VDD a_1989_n1403# a_2163_n1506# VDD sg13_lv_pmos ad=91.2f pd=0.86u as=0.1632p ps=1.64u w=0.48u l=0.13u
X145 a_5827_n2258# a_4815_n2355# a_5725_n2358# VDD sg13_lv_pmos ad=91.2f pd=0.86u as=0.1511p ps=1.37u w=0.48u l=0.13u
X146 VDD BIST_EN_I a_n897_n675# VDD sg13_lv_pmos ad=0.16165p pd=1.365u as=0.2193p ps=1.97u w=0.645u l=0.13u
X147 VSS a_3251_n711# a_3175_n272# VSS sg13_lv_nmos ad=0.13717p pd=1.25u as=0.1653p ps=1.25u w=0.87u l=0.13u
X148 a_3251_n711# BIST_EN_I a_3583_n270# VSS sg13_lv_nmos ad=0.1064p pd=0.94u as=0.1064p ps=0.94u w=0.56u l=0.13u
X149 a_3624_n749# BIST_EN_I VSS VSS sg13_lv_nmos ad=0.1904p pd=1.8u as=0.1064p ps=0.94u w=0.56u l=0.13u
X150 VDD a_6107_n1344# a_6107_n1622# VDD sg13_lv_pmos ad=0.5508p pd=3.92u as=0.3078p ps=2u w=1.62u l=0.385u
X151 a_4399_n1950# ADDR_I<6> VSS VSS sg13_lv_nmos ad=0.1064p pd=0.94u as=0.1064p ps=0.94u w=0.56u l=0.13u
X152 VDD a_6141_n744# ADDR_N_O<7> VDD sg13_lv_pmos ad=0.3078p pd=2u as=0.3078p ps=2u w=1.62u l=0.13u
X153 a_803_n1620# a_625_n1580# VDD VDD sg13_lv_pmos ad=0.1632p pd=1.64u as=91.2f ps=0.86u w=0.48u l=0.13u
X154 a_4883_n1622# a_4883_n1344# VDD VDD sg13_lv_pmos ad=0.3078p pd=2u as=0.3078p ps=2u w=1.62u l=0.385u
X155 VDD a_5291_n2360# a_5215_n2262# VDD sg13_lv_pmos ad=91.2f pd=0.86u as=91.2f ps=0.86u w=0.48u l=0.13u
X156 VSS a_6141_n744# ADDR_N_O<7> VSS sg13_lv_nmos ad=0.2397p pd=2.09u as=0.13395p ps=1.085u w=0.705u l=0.13u
X157 VDD BIST_ADDR_I<5> a_n497_n675# VDD sg13_lv_pmos ad=0.3349p pd=2.65u as=0.18715p ps=1.365u w=0.985u l=0.13u
X158 a_n89_n675# a_n599_n675# VDD VDD sg13_lv_pmos ad=0.18525p pd=1.355u as=0.14812p ps=1.355u w=0.975u l=0.13u
X159 a_1619_n780# a_1989_n373# VDD VDD sg13_lv_pmos ad=0.5508p pd=3.92u as=0.3078p ps=2u w=1.62u l=0.13u
X160 VDD a_1619_n1620# ADDR_N_O<2> VDD sg13_lv_pmos ad=0.3078p pd=2u as=0.3078p ps=2u w=1.62u l=0.13u
X161 a_625_n1580# a_n285_n1582# a_523_n1538# VSS sg13_lv_nmos ad=0.13375p pd=1.23u as=0.1783p ps=1.44u w=0.85u l=0.13u
X162 VDD BIST_ADDR_I<1> a_n497_n2355# VDD sg13_lv_pmos ad=0.3349p pd=2.65u as=0.18715p ps=1.365u w=0.985u l=0.13u
X163 a_2359_n1950# a_2163_n2426# VSS VSS sg13_lv_nmos ad=91.2f pd=0.86u as=91.2f ps=0.86u w=0.48u l=0.13u
X164 VDD a_1041_n1582# ADDR_N_O<4> VDD sg13_lv_pmos ad=0.3078p pd=2u as=0.3078p ps=2u w=1.62u l=0.13u
X165 a_2838_n405# ACLK_N_I a_2971_n582# VDD sg13_lv_pmos ad=0.14927p pd=1.355u as=91.2f ps=0.86u w=0.48u l=0.13u
X166 VDD a_625_n1580# a_1041_n1582# VDD sg13_lv_pmos ad=0.3078p pd=2u as=0.5508p ps=3.92u w=1.62u l=0.13u
X167 ADDR_N_O<0> a_1619_n2460# VSS VSS sg13_lv_nmos ad=0.13395p pd=1.085u as=0.13395p ps=1.085u w=0.705u l=0.13u
X168 VDD a_3251_n2391# a_3175_n2355# VDD sg13_lv_pmos ad=0.14812p pd=1.355u as=0.18525p ps=1.355u w=0.975u l=0.13u
X169 a_727_n578# a_n285_n675# a_625_n678# VDD sg13_lv_pmos ad=91.2f pd=0.86u as=0.1511p ps=1.37u w=0.48u l=0.13u
X170 a_2401_n746# ACLK_N_I VDD VDD sg13_lv_pmos ad=0.1632p pd=1.64u as=0.14812p ps=1.355u w=0.48u l=0.13u
X171 a_2971_n1504# a_2639_n1574# VSS VSS sg13_lv_nmos ad=91.2f pd=0.86u as=91.2f ps=0.86u w=0.48u l=0.13u
X172 VDD a_6141_n2424# ADDR_N_O<6> VDD sg13_lv_pmos ad=0.5508p pd=3.92u as=0.3078p ps=2u w=1.62u l=0.13u
X173 a_4603_n270# BIST_EN_I a_4501_n675# VSS sg13_lv_nmos ad=0.1064p pd=0.94u as=0.1064p ps=0.94u w=0.56u l=0.13u
X174 a_2359_n578# a_2163_n746# VDD VDD sg13_lv_pmos ad=91.2f pd=0.86u as=91.2f ps=0.86u w=0.48u l=0.13u
X175 VDD a_6107_n1344# a_6107_n1622# VDD sg13_lv_pmos ad=0.3078p pd=2u as=0.3078p ps=2u w=1.62u l=0.385u
X176 VDD a_5725_n2358# a_6141_n2424# VDD sg13_lv_pmos ad=0.3078p pd=2u as=0.5508p ps=3.92u w=1.62u l=0.13u
X177 a_5011_n675# a_4501_n675# VDD VDD sg13_lv_pmos ad=0.18525p pd=1.355u as=0.14812p ps=1.355u w=0.975u l=0.13u
X178 a_5495_n1344# a_5495_n1622# VSS VSS sg13_lv_nmos ad=0.1577p pd=1.21u as=0.1577p ps=1.21u w=0.83u l=0.13u
X179 VDD BIST_ADDR_I<7> a_4603_n675# VDD sg13_lv_pmos ad=0.3349p pd=2.65u as=0.18715p ps=1.365u w=0.985u l=0.13u
X180 VSS ACLK_N_I a_n285_n1582# VSS sg13_lv_nmos ad=0.13717p pd=1.25u as=0.1683p ps=1.67u w=0.495u l=0.13u
X181 ADDR_N_O<4> a_1041_n1582# VDD VDD sg13_lv_pmos ad=0.3078p pd=2u as=0.3078p ps=2u w=1.62u l=0.13u
X182 a_3175_n1200# a_2401_n1030# a_2838_n1371# VDD sg13_lv_pmos ad=0.18525p pd=1.355u as=0.14927p ps=1.355u w=0.975u l=0.13u
X183 a_4883_n1344# a_4883_n1622# VSS VSS sg13_lv_nmos ad=0.1577p pd=1.21u as=0.1577p ps=1.21u w=0.83u l=0.13u
X184 a_727_n1950# ACLK_N_I a_625_n2358# VSS sg13_lv_nmos ad=91.2f pd=0.86u as=0.13375p ps=1.23u w=0.48u l=0.13u
X185 a_5215_n1952# a_4815_n2355# a_5113_n2355# VSS sg13_lv_nmos ad=91.2f pd=0.86u as=0.13605p ps=1.25u w=0.48u l=0.13u
X186 VSS a_1619_n2460# ADDR_N_O<0> VSS sg13_lv_nmos ad=0.13395p pd=1.085u as=0.13395p ps=1.085u w=0.705u l=0.13u
X187 a_5215_n272# a_4815_n675# a_5113_n675# VSS sg13_lv_nmos ad=91.2f pd=0.86u as=0.13605p ps=1.25u w=0.48u l=0.13u
X188 VSS a_1041_n2424# ADDR_N_O<1> VSS sg13_lv_nmos ad=0.13395p pd=1.085u as=0.13395p ps=1.085u w=0.705u l=0.13u
X189 VDD BIST_EN_I a_4203_n675# VDD sg13_lv_pmos ad=0.16165p pd=1.365u as=0.2193p ps=1.97u w=0.645u l=0.13u
X190 VSS a_5495_n1622# a_5495_n1344# VSS sg13_lv_nmos ad=0.1577p pd=1.21u as=0.1577p ps=1.21u w=0.83u l=0.13u
X191 a_n701_n1950# ADDR_I<1> VSS VSS sg13_lv_nmos ad=0.1064p pd=0.94u as=0.1064p ps=0.94u w=0.56u l=0.13u
X192 a_3175_n1952# ACLK_N_I a_2838_n2085# VSS sg13_lv_nmos ad=0.1653p pd=1.25u as=0.13605p ps=1.25u w=0.87u l=0.13u
X193 VSS a_5903_n677# a_5827_n270# VSS sg13_lv_nmos ad=91.2f pd=0.86u as=91.2f ps=0.86u w=0.48u l=0.13u
X194 ADDR_N_O<2> a_1619_n1620# VSS VSS sg13_lv_nmos ad=0.13395p pd=1.085u as=0.13395p ps=1.085u w=0.705u l=0.13u
X195 a_2359_n1506# a_2163_n1506# VSS VSS sg13_lv_nmos ad=91.2f pd=0.86u as=91.2f ps=0.86u w=0.48u l=0.13u
X196 ADDR_N_O<6> a_6141_n2424# VDD VDD sg13_lv_pmos ad=0.3078p pd=2u as=0.3078p ps=2u w=1.62u l=0.13u
X197 a_3624_n2429# BIST_EN_I VSS VSS sg13_lv_nmos ad=0.1904p pd=1.8u as=0.1064p ps=0.94u w=0.56u l=0.13u
X198 ADDR_N_O<4> a_1041_n1582# VSS VSS sg13_lv_nmos ad=0.13395p pd=1.085u as=0.13395p ps=1.085u w=0.705u l=0.13u
X199 VSS a_5903_n2357# a_5827_n1950# VSS sg13_lv_nmos ad=91.2f pd=0.86u as=91.2f ps=0.86u w=0.48u l=0.13u
X200 a_3583_n1950# BIST_ADDR_I<0> VSS VSS sg13_lv_nmos ad=0.1064p pd=0.94u as=0.1904p ps=1.8u w=0.56u l=0.13u
X201 a_3251_n1620# a_3624_n991# a_3583_n1202# VDD sg13_lv_pmos ad=0.18715p pd=1.365u as=0.18715p ps=1.365u w=0.985u l=0.13u
X202 a_523_n1992# a_191_n2360# VSS VSS sg13_lv_nmos ad=0.1783p pd=1.44u as=0.289p ps=2.38u w=0.85u l=0.13u
X203 VDD ACLK_N_I a_4815_n2355# VDD sg13_lv_pmos ad=0.14812p pd=1.355u as=0.1632p ps=1.64u w=0.48u l=0.13u
X204 VDD a_2838_n2085# a_2639_n2394# VDD sg13_lv_pmos ad=91.2f pd=0.86u as=0.1632p ps=1.64u w=0.48u l=0.13u
X205 a_4501_n2355# BIST_EN_I a_4399_n2355# VDD sg13_lv_pmos ad=0.18715p pd=1.365u as=0.18715p ps=1.365u w=0.985u l=0.13u
X206 VDD a_3251_n1620# a_3175_n1200# VDD sg13_lv_pmos ad=0.14812p pd=1.355u as=0.18525p ps=1.355u w=0.975u l=0.13u
X207 VSS a_5291_n2360# a_5215_n1952# VSS sg13_lv_nmos ad=91.2f pd=0.86u as=91.2f ps=0.86u w=0.48u l=0.13u
X208 a_2401_n1030# ACLK_N_I VDD VDD sg13_lv_pmos ad=0.1632p pd=1.64u as=0.14812p ps=1.355u w=0.48u l=0.13u
X209 VSS BIST_ADDR_I<1> a_n497_n1950# VSS sg13_lv_nmos ad=0.1904p pd=1.8u as=0.1064p ps=0.94u w=0.56u l=0.13u
X210 VSS ACLK_N_I a_n285_n2355# VSS sg13_lv_nmos ad=0.13717p pd=1.25u as=0.1683p ps=1.67u w=0.495u l=0.13u
X211 VSS a_3251_n2391# a_3175_n1952# VSS sg13_lv_nmos ad=0.13717p pd=1.25u as=0.1653p ps=1.25u w=0.87u l=0.13u
X212 VSS a_803_n677# a_727_n270# VSS sg13_lv_nmos ad=91.2f pd=0.86u as=91.2f ps=0.86u w=0.48u l=0.13u
X213 ADDR_N_O<3> a_1619_n780# VDD VDD sg13_lv_pmos ad=0.3078p pd=2u as=0.3078p ps=2u w=1.62u l=0.13u
X214 a_5623_n678# a_5291_n680# VDD VDD sg13_lv_pmos ad=0.1881p pd=1.37u as=0.3366p ps=2.66u w=0.99u l=0.13u
X215 VDD BIST_EN_I a_n897_n1522# VDD sg13_lv_pmos ad=0.16165p pd=1.365u as=0.2193p ps=1.97u w=0.645u l=0.13u
X216 a_4883_n1622# a_4883_n1344# VDD VDD sg13_lv_pmos ad=0.3078p pd=2u as=0.3078p ps=2u w=1.62u l=0.385u
X217 a_2359_n2258# a_2163_n2426# VDD VDD sg13_lv_pmos ad=91.2f pd=0.86u as=91.2f ps=0.86u w=0.48u l=0.13u
X218 VDD a_1041_n744# ADDR_N_O<5> VDD sg13_lv_pmos ad=0.3078p pd=2u as=0.3078p ps=2u w=1.62u l=0.13u
X219 a_n497_n1202# a_n897_n1522# a_n599_n1522# VDD sg13_lv_pmos ad=0.18715p pd=1.365u as=0.18715p ps=1.365u w=0.985u l=0.13u
X220 a_115_n1504# a_n285_n1582# a_13_n1582# VSS sg13_lv_nmos ad=91.2f pd=0.86u as=0.13605p ps=1.25u w=0.48u l=0.13u
X221 a_191_n1540# a_13_n1582# VSS VSS sg13_lv_nmos ad=0.1632p pd=1.64u as=91.2f ps=0.86u w=0.48u l=0.13u
X222 a_1989_n373# ACLK_N_I a_2359_n270# VSS sg13_lv_nmos ad=0.13375p pd=1.23u as=91.2f ps=0.86u w=0.48u l=0.13u
X223 VSS a_2639_n714# a_2563_n270# VSS sg13_lv_nmos ad=0.289p pd=2.38u as=0.1783p ps=1.44u w=0.85u l=0.13u
X224 a_3787_n1202# BIST_EN_I a_3251_n1620# VDD sg13_lv_pmos ad=0.18715p pd=1.365u as=0.18715p ps=1.365u w=0.985u l=0.13u
X225 a_6107_n1622# a_6107_n1344# VDD VDD sg13_lv_pmos ad=0.3078p pd=2u as=0.3078p ps=2u w=1.62u l=0.385u
X226 VSS BIST_EN_I a_n897_n675# VSS sg13_lv_nmos ad=0.1064p pd=0.94u as=0.1904p ps=1.8u w=0.56u l=0.13u
X227 a_n89_n272# a_n599_n675# VSS VSS sg13_lv_nmos ad=0.1653p pd=1.25u as=0.13717p ps=1.25u w=0.87u l=0.13u
X228 VDD a_2838_n405# a_2639_n714# VDD sg13_lv_pmos ad=91.2f pd=0.86u as=0.1632p ps=1.64u w=0.48u l=0.13u
X229 a_727_n1506# ACLK_N_I a_625_n1580# VSS sg13_lv_nmos ad=91.2f pd=0.86u as=0.13375p ps=1.23u w=0.48u l=0.13u
X230 VDD a_4883_n1344# a_4883_n1622# VDD sg13_lv_pmos ad=0.3078p pd=2u as=0.3078p ps=2u w=1.62u l=0.385u
X231 a_1619_n1620# a_1989_n1403# VDD VDD sg13_lv_pmos ad=0.5508p pd=3.92u as=0.3078p ps=2u w=1.62u l=0.13u
X232 ADDR_N_O<6> a_6141_n2424# VSS VSS sg13_lv_nmos ad=0.13395p pd=1.085u as=0.13395p ps=1.085u w=0.705u l=0.13u
X233 VSS a_1041_n744# ADDR_N_O<5> VSS sg13_lv_nmos ad=0.13395p pd=1.085u as=0.13395p ps=1.085u w=0.705u l=0.13u
X234 a_4271_n1344# a_4271_n1622# VSS VSS sg13_lv_nmos ad=0.1577p pd=1.21u as=0.1577p ps=1.21u w=0.83u l=0.13u
X235 VSS BIST_ADDR_I<5> a_n497_n270# VSS sg13_lv_nmos ad=0.1904p pd=1.8u as=0.1064p ps=0.94u w=0.56u l=0.13u
X236 VDD a_5903_n677# a_5827_n578# VDD sg13_lv_pmos ad=91.2f pd=0.86u as=91.2f ps=0.86u w=0.48u l=0.13u
X237 VSS a_6107_n1622# a_6107_n1344# VSS sg13_lv_nmos ad=0.2822p pd=2.34u as=0.1577p ps=1.21u w=0.83u l=0.13u
X238 a_n701_n1522# ADDR_I<4> VSS VSS sg13_lv_nmos ad=0.1064p pd=0.94u as=0.1064p ps=0.94u w=0.56u l=0.13u
X239 VSS a_6107_n1622# a_6107_n1344# VSS sg13_lv_nmos ad=0.1577p pd=1.21u as=0.1577p ps=1.21u w=0.83u l=0.13u
X240 a_523_n678# a_191_n680# VDD VDD sg13_lv_pmos ad=0.1881p pd=1.37u as=0.3366p ps=2.66u w=0.99u l=0.13u
X241 a_2838_n405# a_2401_n746# a_2971_n272# VSS sg13_lv_nmos ad=0.13605p pd=1.25u as=91.2f ps=0.86u w=0.48u l=0.13u
X242 a_2563_n678# ACLK_N_I a_1989_n373# VDD sg13_lv_pmos ad=0.1881p pd=1.37u as=0.1511p ps=1.37u w=0.99u l=0.13u
X243 ADDR_N_O<7> a_6141_n744# VDD VDD sg13_lv_pmos ad=0.3078p pd=2u as=0.3078p ps=2u w=1.62u l=0.13u
X244 VDD a_2838_n1371# a_2639_n1574# VDD sg13_lv_pmos ad=91.2f pd=0.86u as=0.1632p ps=1.64u w=0.48u l=0.13u
X245 VDD a_1619_n2460# ADDR_N_O<0> VDD sg13_lv_pmos ad=0.3078p pd=2u as=0.3078p ps=2u w=1.62u l=0.13u
X246 a_523_n2358# a_191_n2360# VDD VDD sg13_lv_pmos ad=0.1881p pd=1.37u as=0.3366p ps=2.66u w=0.99u l=0.13u
X247 VDD a_5725_n678# a_6141_n744# VDD sg13_lv_pmos ad=0.3078p pd=2u as=0.5508p ps=3.92u w=1.62u l=0.13u
X248 a_523_n1538# a_191_n1540# VSS VSS sg13_lv_nmos ad=0.1783p pd=1.44u as=0.289p ps=2.38u w=0.85u l=0.13u
X249 a_2838_n1371# a_2401_n1030# a_2971_n1504# VSS sg13_lv_nmos ad=0.13605p pd=1.25u as=91.2f ps=0.86u w=0.48u l=0.13u
X250 a_3624_n991# BIST_EN_I VSS VSS sg13_lv_nmos ad=0.1904p pd=1.8u as=0.1064p ps=0.94u w=0.56u l=0.13u
X251 VDD a_1041_n2424# ADDR_N_O<1> VDD sg13_lv_pmos ad=0.3078p pd=2u as=0.3078p ps=2u w=1.62u l=0.13u
X252 a_n497_n675# a_n897_n675# a_n599_n675# VDD sg13_lv_pmos ad=0.18715p pd=1.365u as=0.18715p ps=1.365u w=0.985u l=0.13u
X253 a_3583_n1522# BIST_ADDR_I<2> VSS VSS sg13_lv_nmos ad=0.1064p pd=0.94u as=0.1904p ps=1.8u w=0.56u l=0.13u
X254 VDD BIST_EN_I a_n897_n2355# VDD sg13_lv_pmos ad=0.16165p pd=1.365u as=0.2193p ps=1.97u w=0.645u l=0.13u
X255 VDD ACLK_N_I a_n285_n675# VDD sg13_lv_pmos ad=0.14812p pd=1.355u as=0.1632p ps=1.64u w=0.48u l=0.13u
X256 VDD a_625_n2358# a_1041_n2424# VDD sg13_lv_pmos ad=0.3078p pd=2u as=0.5508p ps=3.92u w=1.62u l=0.13u
X257 a_727_n2258# a_n285_n2355# a_625_n2358# VDD sg13_lv_pmos ad=91.2f pd=0.86u as=0.1511p ps=1.37u w=0.48u l=0.13u
X258 a_5011_n272# a_4501_n675# VSS VSS sg13_lv_nmos ad=0.1653p pd=1.25u as=0.13717p ps=1.25u w=0.87u l=0.13u
X259 ADDR_N_O<7> a_6141_n744# VSS VSS sg13_lv_nmos ad=0.13395p pd=1.085u as=0.13395p ps=1.085u w=0.705u l=0.13u
X260 a_5725_n2358# ACLK_N_I a_5623_n2358# VDD sg13_lv_pmos ad=0.1511p pd=1.37u as=0.1881p ps=1.37u w=0.99u l=0.13u
X261 a_3251_n2391# a_3624_n2429# a_3583_n2355# VDD sg13_lv_pmos ad=0.18715p pd=1.365u as=0.18715p ps=1.365u w=0.985u l=0.13u
X262 VSS a_4271_n1622# a_4271_n1344# VSS sg13_lv_nmos ad=0.1577p pd=1.21u as=0.1577p ps=1.21u w=0.83u l=0.13u
X263 VDD a_191_n2360# a_115_n2262# VDD sg13_lv_pmos ad=91.2f pd=0.86u as=91.2f ps=0.86u w=0.48u l=0.13u
X264 a_3787_n675# BIST_EN_I a_3251_n711# VDD sg13_lv_pmos ad=0.18715p pd=1.365u as=0.18715p ps=1.365u w=0.985u l=0.13u
X265 VSS a_4271_n1622# a_4271_n1344# VSS sg13_lv_nmos ad=0.1577p pd=1.21u as=0.1577p ps=1.21u w=0.83u l=0.13u
X266 VSS a_2838_n2085# a_2639_n2394# VSS sg13_lv_nmos ad=91.2f pd=0.86u as=0.1632p ps=1.64u w=0.48u l=0.13u
X267 VDD a_803_n677# a_727_n578# VDD sg13_lv_pmos ad=91.2f pd=0.86u as=91.2f ps=0.86u w=0.48u l=0.13u
X268 a_3175_n675# a_2401_n746# a_2838_n405# VDD sg13_lv_pmos ad=0.18525p pd=1.355u as=0.14927p ps=1.355u w=0.975u l=0.13u
X269 a_2359_n1198# a_2163_n1506# VDD VDD sg13_lv_pmos ad=91.2f pd=0.86u as=91.2f ps=0.86u w=0.48u l=0.13u
X270 a_6107_n1344# a_6107_n1622# VSS VSS sg13_lv_nmos ad=0.1577p pd=1.21u as=0.1577p ps=1.21u w=0.83u l=0.13u
X271 VDD a_5903_n2357# a_5827_n2258# VDD sg13_lv_pmos ad=91.2f pd=0.86u as=91.2f ps=0.86u w=0.48u l=0.13u
X272 a_1989_n373# a_2401_n746# a_2359_n578# VDD sg13_lv_pmos ad=0.1511p pd=1.37u as=91.2f ps=0.86u w=0.48u l=0.13u
X273 VSS BIST_ADDR_I<7> a_4603_n270# VSS sg13_lv_nmos ad=0.1904p pd=1.8u as=0.1064p ps=0.94u w=0.56u l=0.13u
X274 VSS BIST_ADDR_I<4> a_n497_n1522# VSS sg13_lv_nmos ad=0.1904p pd=1.8u as=0.1064p ps=0.94u w=0.56u l=0.13u
X275 a_13_n2355# a_n285_n2355# a_n89_n2355# VDD sg13_lv_pmos ad=0.14927p pd=1.355u as=0.18525p ps=1.355u w=0.975u l=0.13u
X276 a_4501_n2355# a_4203_n2355# a_4399_n1950# VSS sg13_lv_nmos ad=0.1064p pd=0.94u as=0.1064p ps=0.94u w=0.56u l=0.13u
X277 a_5291_n2360# a_5113_n2355# VDD VDD sg13_lv_pmos ad=0.1632p pd=1.64u as=91.2f ps=0.86u w=0.48u l=0.13u
X278 VSS BIST_EN_I a_4203_n675# VSS sg13_lv_nmos ad=0.1064p pd=0.94u as=0.1904p ps=1.8u w=0.56u l=0.13u
X279 a_n497_n2355# a_n897_n2355# a_n599_n2355# VDD sg13_lv_pmos ad=0.18715p pd=1.365u as=0.18715p ps=1.365u w=0.985u l=0.13u
X280 ADDR_N_O<1> a_1041_n2424# VDD VDD sg13_lv_pmos ad=0.3078p pd=2u as=0.3078p ps=2u w=1.62u l=0.13u
X281 a_1989_n2053# ACLK_N_I a_2359_n1950# VSS sg13_lv_nmos ad=0.13375p pd=1.23u as=91.2f ps=0.86u w=0.48u l=0.13u
X282 a_5903_n2357# a_5725_n2358# VSS VSS sg13_lv_nmos ad=0.1632p pd=1.64u as=91.2f ps=0.86u w=0.48u l=0.13u
X283 ADDR_N_O<2> a_1619_n1620# VDD VDD sg13_lv_pmos ad=0.3078p pd=2u as=0.3078p ps=2u w=1.62u l=0.13u
X284 a_n89_n2355# a_n599_n2355# VDD VDD sg13_lv_pmos ad=0.18525p pd=1.355u as=0.14812p ps=1.355u w=0.975u l=0.13u
X285 a_3787_n2355# BIST_EN_I a_3251_n2391# VDD sg13_lv_pmos ad=0.18715p pd=1.365u as=0.18715p ps=1.365u w=0.985u l=0.13u
X286 a_2401_n2426# ACLK_N_I VDD VDD sg13_lv_pmos ad=0.1632p pd=1.64u as=0.14812p ps=1.355u w=0.48u l=0.13u
X287 a_523_n1200# a_191_n1540# VDD VDD sg13_lv_pmos ad=0.1881p pd=1.37u as=0.3366p ps=2.66u w=0.99u l=0.13u
X288 a_4399_n675# ADDR_I<7> VDD VDD sg13_lv_pmos ad=0.18715p pd=1.365u as=0.16165p ps=1.365u w=0.985u l=0.13u
X289 VDD a_191_n1540# a_115_n1194# VDD sg13_lv_pmos ad=91.2f pd=0.86u as=91.2f ps=0.86u w=0.48u l=0.13u
X290 a_727_n1198# a_n285_n1582# a_625_n1580# VDD sg13_lv_pmos ad=91.2f pd=0.86u as=0.1511p ps=1.37u w=0.48u l=0.13u
X291 VDD a_4271_n1344# a_4271_n1622# VDD sg13_lv_pmos ad=0.3078p pd=2u as=0.3078p ps=2u w=1.62u l=0.385u
X292 VDD a_1619_n1620# ADDR_N_O<2> VDD sg13_lv_pmos ad=0.3078p pd=2u as=0.3078p ps=2u w=1.62u l=0.13u
X293 VDD a_1041_n1582# ADDR_N_O<4> VDD sg13_lv_pmos ad=0.3078p pd=2u as=0.3078p ps=2u w=1.62u l=0.13u
X294 VSS a_5495_n1622# a_5495_n1344# VSS sg13_lv_nmos ad=0.1577p pd=1.21u as=0.1577p ps=1.21u w=0.83u l=0.13u
X295 VSS a_2838_n405# a_2639_n714# VSS sg13_lv_nmos ad=91.2f pd=0.86u as=0.1632p ps=1.64u w=0.48u l=0.13u
X296 VDD a_5291_n680# a_5215_n582# VDD sg13_lv_pmos ad=91.2f pd=0.86u as=91.2f ps=0.86u w=0.48u l=0.13u
X297 VSS a_4883_n1622# a_4883_n1344# VSS sg13_lv_nmos ad=0.1577p pd=1.21u as=0.1577p ps=1.21u w=0.83u l=0.13u
X298 VSS a_803_n2357# a_727_n1950# VSS sg13_lv_nmos ad=91.2f pd=0.86u as=91.2f ps=0.86u w=0.48u l=0.13u
X299 ADDR_N_O<0> a_1619_n2460# VSS VSS sg13_lv_nmos ad=0.13395p pd=1.085u as=0.13395p ps=1.085u w=0.705u l=0.13u
X300 VSS BIST_EN_I a_n897_n2355# VSS sg13_lv_nmos ad=0.1064p pd=0.94u as=0.1904p ps=1.8u w=0.56u l=0.13u
X301 ADDR_N_O<1> a_1041_n2424# VSS VSS sg13_lv_nmos ad=0.13395p pd=1.085u as=0.13395p ps=1.085u w=0.705u l=0.13u
X302 a_803_n677# a_625_n678# VSS VSS sg13_lv_nmos ad=0.1632p pd=1.64u as=91.2f ps=0.86u w=0.48u l=0.13u
X303 VSS ACLK_N_I a_4815_n675# VSS sg13_lv_nmos ad=0.13717p pd=1.25u as=0.1683p ps=1.67u w=0.495u l=0.13u
X304 a_5725_n678# ACLK_N_I a_5623_n678# VDD sg13_lv_pmos ad=0.1511p pd=1.37u as=0.1881p ps=1.37u w=0.99u l=0.13u
X305 VSS a_1619_n1620# ADDR_N_O<2> VSS sg13_lv_nmos ad=0.13395p pd=1.085u as=0.13395p ps=1.085u w=0.705u l=0.13u
X306 a_3175_n1582# ACLK_N_I a_2838_n1371# VSS sg13_lv_nmos ad=0.1653p pd=1.25u as=0.13605p ps=1.25u w=0.87u l=0.13u
X307 a_5495_n1344# a_5495_n1622# VSS VSS sg13_lv_nmos ad=0.1577p pd=1.21u as=0.1577p ps=1.21u w=0.83u l=0.13u
X308 a_5725_n2358# a_4815_n2355# a_5623_n1992# VSS sg13_lv_nmos ad=0.13375p pd=1.23u as=0.1783p ps=1.44u w=0.85u l=0.13u
X309 ADDR_N_O<3> a_1619_n780# VDD VDD sg13_lv_pmos ad=0.3078p pd=2u as=0.3078p ps=2u w=1.62u l=0.13u
X310 VDD a_1619_n780# ADDR_N_O<3> VDD sg13_lv_pmos ad=0.3078p pd=2u as=0.3078p ps=2u w=1.62u l=0.13u
X311 a_13_n1582# a_n285_n1582# a_n89_n1200# VDD sg13_lv_pmos ad=0.14927p pd=1.355u as=0.18525p ps=1.355u w=0.975u l=0.13u
X312 VSS a_1041_n1582# ADDR_N_O<4> VSS sg13_lv_nmos ad=0.13395p pd=1.085u as=0.13395p ps=1.085u w=0.705u l=0.13u
X313 a_1989_n1403# ACLK_N_I a_2359_n1506# VSS sg13_lv_nmos ad=0.13375p pd=1.23u as=91.2f ps=0.86u w=0.48u l=0.13u
X314 VSS a_191_n2360# a_115_n1952# VSS sg13_lv_nmos ad=91.2f pd=0.86u as=91.2f ps=0.86u w=0.48u l=0.13u
X315 VDD a_6141_n2424# ADDR_N_O<6> VDD sg13_lv_pmos ad=0.3078p pd=2u as=0.3078p ps=2u w=1.62u l=0.13u
X316 a_2563_n270# a_2401_n746# a_1989_n373# VSS sg13_lv_nmos ad=0.1783p pd=1.44u as=0.13375p ps=1.23u w=0.85u l=0.13u
X317 VSS a_625_n1580# a_1041_n1582# VSS sg13_lv_nmos ad=0.13395p pd=1.085u as=0.2397p ps=2.09u w=0.705u l=0.13u
X318 a_3251_n2391# BIST_EN_I a_3583_n1950# VSS sg13_lv_nmos ad=0.1064p pd=0.94u as=0.1064p ps=0.94u w=0.56u l=0.13u
X319 a_13_n2355# ACLK_N_I a_n89_n1952# VSS sg13_lv_nmos ad=0.13605p pd=1.25u as=0.1653p ps=1.25u w=0.87u l=0.13u
X320 a_5011_n2355# a_4501_n2355# VDD VDD sg13_lv_pmos ad=0.18525p pd=1.355u as=0.14812p ps=1.355u w=0.975u l=0.13u
X321 a_2971_n2262# a_2639_n2394# VDD VDD sg13_lv_pmos ad=91.2f pd=0.86u as=91.2f ps=0.86u w=0.48u l=0.13u
X322 a_1619_n2460# a_1989_n2053# VDD VDD sg13_lv_pmos ad=0.5508p pd=3.92u as=0.3078p ps=2u w=1.62u l=0.13u
X323 ADDR_N_O<5> a_1041_n744# VDD VDD sg13_lv_pmos ad=0.3078p pd=2u as=0.3078p ps=2u w=1.62u l=0.13u
X324 a_2971_n582# a_2639_n714# VDD VDD sg13_lv_pmos ad=91.2f pd=0.86u as=91.2f ps=0.86u w=0.48u l=0.13u
X325 a_n89_n1200# a_n599_n1522# VDD VDD sg13_lv_pmos ad=0.18525p pd=1.355u as=0.14812p ps=1.355u w=0.975u l=0.13u
X326 a_4603_n2355# a_4203_n2355# a_4501_n2355# VDD sg13_lv_pmos ad=0.18715p pd=1.365u as=0.18715p ps=1.365u w=0.985u l=0.13u
X327 ADDR_N_O<5> a_1041_n744# VSS VSS sg13_lv_nmos ad=0.13395p pd=1.085u as=0.13395p ps=1.085u w=0.705u l=0.13u
X328 VSS a_1619_n780# ADDR_N_O<3> VSS sg13_lv_nmos ad=0.13395p pd=1.085u as=0.13395p ps=1.085u w=0.705u l=0.13u
X329 a_5291_n2360# a_5113_n2355# VSS VSS sg13_lv_nmos ad=0.1632p pd=1.64u as=91.2f ps=0.86u w=0.48u l=0.13u
X330 a_n497_n270# BIST_EN_I a_n599_n675# VSS sg13_lv_nmos ad=0.1064p pd=0.94u as=0.1064p ps=0.94u w=0.56u l=0.13u
X331 VSS a_625_n678# a_1041_n744# VSS sg13_lv_nmos ad=0.13395p pd=1.085u as=0.2397p ps=2.09u w=0.705u l=0.13u
X332 VDD a_191_n680# a_115_n582# VDD sg13_lv_pmos ad=91.2f pd=0.86u as=91.2f ps=0.86u w=0.48u l=0.13u
X333 VDD ACLK_N_I a_n285_n1582# VDD sg13_lv_pmos ad=0.14812p pd=1.355u as=0.1632p ps=1.64u w=0.48u l=0.13u
X334 a_4883_n1344# a_4883_n1622# VSS VSS sg13_lv_nmos ad=0.1577p pd=1.21u as=0.1577p ps=1.21u w=0.83u l=0.13u
X335 a_n89_n1952# a_n599_n2355# VSS VSS sg13_lv_nmos ad=0.1653p pd=1.25u as=0.13717p ps=1.25u w=0.87u l=0.13u
X336 a_625_n678# ACLK_N_I a_523_n678# VDD sg13_lv_pmos ad=0.1511p pd=1.37u as=0.1881p ps=1.37u w=0.99u l=0.13u
X337 a_3175_n272# ACLK_N_I a_2838_n405# VSS sg13_lv_nmos ad=0.1653p pd=1.25u as=0.13605p ps=1.25u w=0.87u l=0.13u
X338 VSS a_3251_n1620# a_3175_n1582# VSS sg13_lv_nmos ad=0.13717p pd=1.25u as=0.1653p ps=1.25u w=0.87u l=0.13u
X339 a_n497_n1950# BIST_EN_I a_n599_n2355# VSS sg13_lv_nmos ad=0.1064p pd=0.94u as=0.1064p ps=0.94u w=0.56u l=0.13u
X340 VDD a_2639_n714# a_2563_n678# VDD sg13_lv_pmos ad=0.3366p pd=2.66u as=0.1881p ps=1.37u w=0.99u l=0.13u
X341 VDD a_6141_n744# ADDR_N_O<7> VDD sg13_lv_pmos ad=0.5508p pd=3.92u as=0.3078p ps=2u w=1.62u l=0.13u
X342 a_n599_n1522# BIST_EN_I a_n701_n1202# VDD sg13_lv_pmos ad=0.18715p pd=1.365u as=0.18715p ps=1.365u w=0.985u l=0.13u
X343 VDD a_5495_n1344# a_5495_n1622# VDD sg13_lv_pmos ad=0.3078p pd=2u as=0.3078p ps=2u w=1.62u l=0.385u
X344 a_5903_n2357# a_5725_n2358# VDD VDD sg13_lv_pmos ad=0.1632p pd=1.64u as=91.2f ps=0.86u w=0.48u l=0.13u
X345 a_3787_n1950# a_3624_n2429# a_3251_n2391# VSS sg13_lv_nmos ad=0.1064p pd=0.94u as=0.1064p ps=0.94u w=0.56u l=0.13u
X346 a_2563_n2358# ACLK_N_I a_1989_n2053# VDD sg13_lv_pmos ad=0.1881p pd=1.37u as=0.1511p ps=1.37u w=0.99u l=0.13u
X347 a_1989_n2053# a_2401_n2426# a_2359_n2258# VDD sg13_lv_pmos ad=0.1511p pd=1.37u as=91.2f ps=0.86u w=0.48u l=0.13u
X348 a_3787_n270# a_3624_n749# a_3251_n711# VSS sg13_lv_nmos ad=0.1064p pd=0.94u as=0.1064p ps=0.94u w=0.56u l=0.13u
X349 ADDR_N_O<4> a_1041_n1582# VSS VSS sg13_lv_nmos ad=0.13395p pd=1.085u as=0.13395p ps=1.085u w=0.705u l=0.13u
X350 a_4271_n1622# a_4271_n1344# VDD VDD sg13_lv_pmos ad=0.3078p pd=2u as=0.3078p ps=2u w=1.62u l=0.385u
X351 a_n599_n675# BIST_EN_I a_n701_n675# VDD sg13_lv_pmos ad=0.18715p pd=1.365u as=0.18715p ps=1.365u w=0.985u l=0.13u
X352 VSS a_803_n1620# a_727_n1506# VSS sg13_lv_nmos ad=91.2f pd=0.86u as=91.2f ps=0.86u w=0.48u l=0.13u
X353 VDD ADDR_I<2> a_3787_n1202# VDD sg13_lv_pmos ad=0.16165p pd=1.365u as=0.18715p ps=1.365u w=0.985u l=0.13u
X354 VSS a_6141_n744# ADDR_N_O<7> VSS sg13_lv_nmos ad=0.13395p pd=1.085u as=0.13395p ps=1.085u w=0.705u l=0.13u
X355 a_6107_n1622# a_6107_n1344# VDD VDD sg13_lv_pmos ad=0.3078p pd=2u as=0.3078p ps=2u w=1.62u l=0.385u
X356 VSS a_6141_n2424# ADDR_N_O<6> VSS sg13_lv_nmos ad=0.2397p pd=2.09u as=0.13395p ps=1.085u w=0.705u l=0.13u
X357 VDD BIST_EN_I a_4203_n2355# VDD sg13_lv_pmos ad=0.16165p pd=1.365u as=0.2193p ps=1.97u w=0.645u l=0.13u
X358 a_1619_n780# a_1989_n373# VSS VSS sg13_lv_nmos ad=0.2397p pd=2.09u as=0.13395p ps=1.085u w=0.705u l=0.13u
X359 VDD ADDR_I<3> a_3787_n675# VDD sg13_lv_pmos ad=0.16165p pd=1.365u as=0.18715p ps=1.365u w=0.985u l=0.13u
X360 VSS a_5725_n2358# a_6141_n2424# VSS sg13_lv_nmos ad=0.13395p pd=1.085u as=0.2397p ps=2.09u w=0.705u l=0.13u
X361 a_803_n677# a_625_n678# VDD VDD sg13_lv_pmos ad=0.1632p pd=1.64u as=91.2f ps=0.86u w=0.48u l=0.13u
X362 a_3583_n675# BIST_ADDR_I<3> VDD VDD sg13_lv_pmos ad=0.18715p pd=1.365u as=0.3349p ps=2.65u w=0.985u l=0.13u
X363 VSS BIST_EN_I a_n897_n1522# VSS sg13_lv_nmos ad=0.1064p pd=0.94u as=0.1904p ps=1.8u w=0.56u l=0.13u
X364 a_2971_n1194# a_2639_n1574# VDD VDD sg13_lv_pmos ad=91.2f pd=0.86u as=91.2f ps=0.86u w=0.48u l=0.13u
X365 a_625_n2358# ACLK_N_I a_523_n2358# VDD sg13_lv_pmos ad=0.1511p pd=1.37u as=0.1881p ps=1.37u w=0.99u l=0.13u
X366 a_4271_n1622# a_4271_n1344# VDD VDD sg13_lv_pmos ad=0.3078p pd=2u as=0.5508p ps=3.92u w=1.62u l=0.385u
X367 ADDR_N_O<0> a_1619_n2460# VDD VDD sg13_lv_pmos ad=0.3078p pd=2u as=0.3078p ps=2u w=1.62u l=0.13u
X368 a_4399_n270# ADDR_I<7> VSS VSS sg13_lv_nmos ad=0.1064p pd=0.94u as=0.1064p ps=0.94u w=0.56u l=0.13u
X369 a_3251_n1620# BIST_EN_I a_3583_n1522# VSS sg13_lv_nmos ad=0.1064p pd=0.94u as=0.1064p ps=0.94u w=0.56u l=0.13u
X370 VDD a_803_n2357# a_727_n2258# VDD sg13_lv_pmos ad=91.2f pd=0.86u as=91.2f ps=0.86u w=0.48u l=0.13u
X371 a_4883_n1344# a_4883_n1622# VSS VSS sg13_lv_nmos ad=0.1577p pd=1.21u as=0.1577p ps=1.21u w=0.83u l=0.13u
X372 ADDR_N_O<6> a_6141_n2424# VSS VSS sg13_lv_nmos ad=0.13395p pd=1.085u as=0.13395p ps=1.085u w=0.705u l=0.13u
X373 a_5011_n1952# a_4501_n2355# VSS VSS sg13_lv_nmos ad=0.1653p pd=1.25u as=0.13717p ps=1.25u w=0.87u l=0.13u
X374 a_191_n2360# a_13_n2355# VDD VDD sg13_lv_pmos ad=0.1632p pd=1.64u as=91.2f ps=0.86u w=0.48u l=0.13u
X375 a_115_n2262# ACLK_N_I a_13_n2355# VDD sg13_lv_pmos ad=91.2f pd=0.86u as=0.14927p ps=1.355u w=0.48u l=0.13u
.ends

.subckt RM_IHPSG13_1P_BLDRV BLT BLC BLT_SEL BLC_SEL SEL_P WR_ONE WR_ZERO PRE_N VDD
+ VDD_uq0 VSS
X0 VSS SEL_P a_115_n294# VSS sg13_lv_nmos ad=0.1862p pd=1.36u as=0.1862p ps=1.36u w=0.98u l=0.13u
X1 a_89_945# SEL_P VSS VSS sg13_lv_nmos ad=0.5831p pd=3.15u as=0.1862p ps=1.36u w=0.98u l=0.13u
X2 VDD_uq0 SEL_P a_21_n294# VDD_uq0 sg13_lv_pmos ad=0.3078p pd=2u as=0.3078p ps=2u w=1.62u l=0.13u
X3 VDD a_21_n294# BLT VDD sg13_lv_pmos ad=0.285p pd=1.88u as=0.285p ps=1.88u w=1.5u l=0.13u
X4 a_115_n294# WR_ONE a_21_n294# VSS sg13_lv_nmos ad=0.1862p pd=1.36u as=0.3332p ps=2.64u w=0.98u l=0.13u
X5 a_21_n294# WR_ONE VDD_uq0 VDD_uq0 sg13_lv_pmos ad=0.3078p pd=2u as=0.5508p ps=3.92u w=1.62u l=0.13u
X6 VSS a_21_1865# BLT VSS sg13_lv_nmos ad=0.4579p pd=2.79u as=0.4579p ps=2.79u w=2.41u l=0.13u
X7 a_319_n294# SEL_P VSS VSS sg13_lv_nmos ad=0.1862p pd=1.36u as=0.1862p ps=1.36u w=0.98u l=0.13u
X8 VDD PRE_N BLT VDD sg13_lv_pmos ad=0.285p pd=1.88u as=0.285p ps=1.88u w=1.5u l=0.13u
X9 a_293_60# SEL_P VDD_uq0 VDD_uq0 sg13_lv_pmos ad=0.3078p pd=2u as=0.3078p ps=2u w=1.62u l=0.13u
X10 BLT a_89_945# BLT_SEL VDD sg13_lv_pmos ad=0.285p pd=1.88u as=0.51p ps=3.68u w=1.5u l=0.13u
X11 BLT a_21_1865# VSS VSS sg13_lv_nmos ad=0.4579p pd=2.79u as=0.8194p ps=5.5u w=2.41u l=0.13u
X12 BLC a_293_60# VDD VDD sg13_lv_pmos ad=0.285p pd=1.88u as=0.285p ps=1.88u w=1.5u l=0.13u
X13 VSS a_293_60# a_21_1865# VSS sg13_lv_nmos ad=0.1862p pd=1.36u as=0.3332p ps=2.64u w=0.98u l=0.13u
X14 BLT PRE_N VDD VDD sg13_lv_pmos ad=0.285p pd=1.88u as=0.51p ps=3.68u w=1.5u l=0.13u
X15 BLC a_115_98# VSS VSS sg13_lv_nmos ad=0.4579p pd=2.79u as=0.4579p ps=2.79u w=2.41u l=0.13u
X16 a_293_60# WR_ZERO a_319_n294# VSS sg13_lv_nmos ad=0.3332p pd=2.64u as=0.1862p ps=1.36u w=0.98u l=0.13u
X17 BLC PRE_N VDD VDD sg13_lv_pmos ad=0.285p pd=1.88u as=0.285p ps=1.88u w=1.5u l=0.13u
X18 VDD a_293_60# a_21_1865# VDD sg13_lv_pmos ad=0.3078p pd=2u as=0.5508p ps=3.92u w=1.62u l=0.13u
X19 VDD_uq0 WR_ZERO a_293_60# VDD_uq0 sg13_lv_pmos ad=0.5508p pd=3.92u as=0.3078p ps=2u w=1.62u l=0.13u
X20 a_89_945# SEL_P VDD VDD sg13_lv_pmos ad=0.9639p pd=4.43u as=0.3078p ps=2u w=1.62u l=0.13u
X21 BLC_SEL a_89_945# BLC VDD sg13_lv_pmos ad=0.51p pd=3.68u as=0.285p ps=1.88u w=1.5u l=0.13u
X22 VSS a_115_98# BLC VSS sg13_lv_nmos ad=0.8194p pd=5.5u as=0.4579p ps=2.79u w=2.41u l=0.13u
X23 a_115_98# a_21_n294# VSS VSS sg13_lv_nmos ad=0.3332p pd=2.64u as=0.3332p ps=2.64u w=0.98u l=0.13u
X24 VDD PRE_N BLC VDD sg13_lv_pmos ad=0.51p pd=3.68u as=0.285p ps=1.88u w=1.5u l=0.13u
X25 a_115_98# a_21_n294# VDD VDD sg13_lv_pmos ad=0.5508p pd=3.92u as=0.5508p ps=3.92u w=1.62u l=0.13u
.ends

.subckt RM_IHPSG13_1P_COLCTRL2 A_TIEH_O A_BM_I A_BLT<3> A_BLC<1> A_BLC<2> A_DR_O A_BIST_BM_I
+ A_BLC<0> A_BLT<2> A_DW_I A_BLC<3> A_BIST_DW_I A_BLT<0> A_DCLK_B_L A_BIST_EN_I A_RCLK_R
+ A_ADDR_DEC<0> A_DCLK_B_R A_ADDR_DEC<2> A_RCLK_B_R A_RCLK_B_L A_ADDR_DEC<1> A_RCLK_L
+ A_DCLK_R A_WCLK_R A_WCLK_B_L A_DCLK_L A_WCLK_L A_ADDR_DEC<3> A_WCLK_B_R m3_0_n5090#
+ A_BLT<1> m3_0_n4988# m3_0_n5294# m3_0_n4478# m3_0_n5192# VSS VDD
XRM_IHPSG13_1P_BLDRV_0[0] A_BLT<3> A_BLC<3> RM_IHPSG13_1P_BLDRV_1[1]/BLT_SEL RM_IHPSG13_1P_BLDRV_1[1]/BLC_SEL
+ A_ADDR_DEC<3> RM_IHPSG13_1P_BLDRV_1[1]/WR_ONE RM_IHPSG13_1P_BLDRV_1[1]/WR_ZERO RM_IHPSG13_1P_BLDRV_1[1]/PRE_N
+ VDD VDD VSS RM_IHPSG13_1P_BLDRV
XRM_IHPSG13_1P_BLDRV_0[1] A_BLT<1> A_BLC<1> RM_IHPSG13_1P_BLDRV_1[1]/BLT_SEL RM_IHPSG13_1P_BLDRV_1[1]/BLC_SEL
+ A_ADDR_DEC<1> RM_IHPSG13_1P_BLDRV_1[1]/WR_ONE RM_IHPSG13_1P_BLDRV_1[1]/WR_ZERO RM_IHPSG13_1P_BLDRV_1[1]/PRE_N
+ VDD VDD VSS RM_IHPSG13_1P_BLDRV
XRM_IHPSG13_1P_BLDRV_1[0] A_BLT<0> A_BLC<0> RM_IHPSG13_1P_BLDRV_1[1]/BLT_SEL RM_IHPSG13_1P_BLDRV_1[1]/BLC_SEL
+ A_ADDR_DEC<0> RM_IHPSG13_1P_BLDRV_1[1]/WR_ONE RM_IHPSG13_1P_BLDRV_1[1]/WR_ZERO RM_IHPSG13_1P_BLDRV_1[1]/PRE_N
+ VDD VDD VSS RM_IHPSG13_1P_BLDRV
XRM_IHPSG13_1P_BLDRV_1[1] A_BLT<2> A_BLC<2> RM_IHPSG13_1P_BLDRV_1[1]/BLT_SEL RM_IHPSG13_1P_BLDRV_1[1]/BLC_SEL
+ A_ADDR_DEC<2> RM_IHPSG13_1P_BLDRV_1[1]/WR_ONE RM_IHPSG13_1P_BLDRV_1[1]/WR_ZERO RM_IHPSG13_1P_BLDRV_1[1]/PRE_N
+ VDD VDD VSS RM_IHPSG13_1P_BLDRV
X0 VDD a_1313_n4980# RM_IHPSG13_1P_BLDRV_1[1]/PRE_N VDD sg13_lv_pmos ad=0.5508p pd=3.92u as=0.3078p ps=2u w=1.62u l=0.13u
X1 VDD A_BIST_BM_I a_523_n9075# VDD sg13_lv_pmos ad=0.3349p pd=2.65u as=0.18715p ps=1.365u w=0.985u l=0.13u
X2 VDD a_225_n6984# a_263_n7064# VDD sg13_lv_pmos ad=0.3078p pd=2u as=0.3078p ps=2u w=1.62u l=0.385u
X3 a_931_n9075# a_421_n9075# VDD VDD sg13_lv_pmos ad=0.18525p pd=1.355u as=0.14812p ps=1.355u w=0.975u l=0.13u
X4 VDD a_766_n4732# a_21_n4942# VDD sg13_lv_pmos ad=0.2508p pd=2u as=0.1634p ps=1.24u w=0.86u l=0.13u
X5 VSS a_766_n4732# a_115_n4942# VSS sg13_lv_nmos ad=0.1502p pd=1.36u as=95f ps=0.88u w=0.5u l=0.13u
X6 VSS a_1619_n4980# a_1313_n4980# VSS sg13_lv_nmos ad=0.1502p pd=1.36u as=0.3332p ps=2.64u w=0.98u l=0.13u
X7 a_225_n6984# a_263_n7064# VSS VSS sg13_lv_nmos ad=0.1577p pd=1.21u as=0.1577p ps=1.21u w=0.83u l=0.13u
X8 VSS a_1313_n8340# a_1237_n8302# VSS sg13_lv_nmos ad=0.13717p pd=1.25u as=0.1653p ps=1.25u w=0.87u l=0.13u
X9 a_900_n8091# a_463_n7750# a_1033_n8224# VSS sg13_lv_nmos ad=0.13605p pd=1.25u as=91.2f ps=0.86u w=0.48u l=0.13u
X10 a_1645_n8242# A_BIST_DW_I VSS VSS sg13_lv_nmos ad=0.1064p pd=0.94u as=0.1904p ps=1.8u w=0.56u l=0.13u
X11 VSS a_599_n7024# a_599_n7500# VSS sg13_lv_nmos ad=0.1577p pd=1.21u as=0.1577p ps=1.21u w=0.83u l=0.13u
X12 VDD a_89_n8340# a_21_n8302# VDD sg13_lv_pmos ad=0.5508p pd=3.92u as=0.5508p ps=3.92u w=1.62u l=0.13u
X13 a_319_n9075# A_BM_I VDD VDD sg13_lv_pmos ad=0.18715p pd=1.365u as=0.16165p ps=1.365u w=0.985u l=0.13u
X14 a_1619_n4980# A_RCLK_B_R VDD VDD sg13_lv_pmos ad=0.1634p pd=1.24u as=0.2508p ps=2u w=0.86u l=0.13u
X15 a_1747_n4942# A_RCLK_B_R VSS VSS sg13_lv_nmos ad=95f pd=0.88u as=0.1502p ps=1.36u w=0.5u l=0.13u
X16 VDD a_481_n5378# a_293_n6660# VDD sg13_lv_pmos ad=0.171p pd=1.28u as=0.306p ps=2.48u w=0.9u l=0.13u
X17 a_1925_n7500# a_1925_n7024# VSS VSS sg13_lv_nmos ad=0.1577p pd=1.21u as=0.1577p ps=1.21u w=0.83u l=0.13u
X18 RM_IHPSG13_1P_BLDRV_1[1]/PRE_N a_1313_n4980# VSS VSS sg13_lv_nmos ad=0.31725p pd=2.31u as=0.2397p ps=2.09u w=0.705u l=0.13u
X19 a_1747_n8978# a_735_n9075# a_1645_n9078# VDD sg13_lv_pmos ad=91.2f pd=0.86u as=0.1511p ps=1.37u w=0.48u l=0.13u
X20 VDD a_1551_n6984# a_1589_n7064# VDD sg13_lv_pmos ad=0.3078p pd=2u as=0.3078p ps=2u w=1.62u l=0.385u
X21 a_1543_n8712# a_1211_n9080# VSS VSS sg13_lv_nmos ad=0.1783p pd=1.44u as=0.289p ps=2.38u w=0.85u l=0.13u
X22 a_1313_n8340# A_BIST_EN_I a_1645_n8242# VSS sg13_lv_nmos ad=0.1064p pd=0.94u as=0.1064p ps=0.94u w=0.56u l=0.13u
X23 VDD a_1143_n6984# a_1181_n7064# VDD sg13_lv_pmos ad=0.5508p pd=3.92u as=0.3078p ps=2u w=1.62u l=0.385u
X24 VSS a_293_n6660# A_DR_O VSS sg13_lv_nmos ad=0.3332p pd=2.64u as=0.1862p ps=1.36u w=0.98u l=0.13u
X25 a_1135_n5784# a_481_n5378# a_441_n5469# VSS sg13_lv_nmos ad=0.408p pd=3.08u as=0.228p ps=1.58u w=1.2u l=0.2u
X26 a_727_n6622# a_481_n5378# VSS VSS sg13_lv_nmos ad=0.1862p pd=1.36u as=0.3332p ps=2.64u w=0.98u l=0.13u
X27 a_1033_n9075# a_735_n9075# a_931_n9075# VDD sg13_lv_pmos ad=0.14927p pd=1.355u as=0.18525p ps=1.355u w=0.975u l=0.13u
X28 a_2092_n4732# a_1645_n9078# VSS VSS sg13_lv_nmos ad=0.3332p pd=2.64u as=0.3332p ps=2.64u w=0.98u l=0.13u
X29 a_931_n8672# a_421_n9075# VSS VSS sg13_lv_nmos ad=0.1653p pd=1.25u as=0.13717p ps=1.25u w=0.87u l=0.13u
X30 VSS A_BIST_BM_I a_523_n8670# VSS sg13_lv_nmos ad=0.1904p pd=1.8u as=0.1064p ps=0.94u w=0.56u l=0.13u
X31 VSS a_1181_n7064# a_1143_n6984# VSS sg13_lv_nmos ad=0.1577p pd=1.21u as=0.2822p ps=2.34u w=0.83u l=0.13u
X32 a_1823_n6660# A_RCLK_B_R VSS VSS sg13_lv_nmos ad=0.1836p pd=1.76u as=0.12157p ps=1.085u w=0.54u l=0.13u
X33 VSS a_2092_n4732# a_766_n4732# VSS sg13_lv_nmos ad=0.3332p pd=2.64u as=0.1862p ps=1.36u w=0.98u l=0.13u
X34 VDD a_441_n5469# a_803_n6660# VDD sg13_lv_pmos ad=0.171p pd=1.28u as=0.171p ps=1.28u w=0.9u l=0.13u
R0 A_WCLK_L A_WCLK_R 0.203077
X35 a_2092_n4732# a_1645_n9078# VDD VDD sg13_lv_pmos ad=0.5508p pd=3.92u as=0.5508p ps=3.92u w=1.62u l=0.13u
X36 VDD a_89_n8340# a_225_n8226# VDD sg13_lv_pmos ad=91.2f pd=0.86u as=0.1632p ps=1.64u w=0.48u l=0.13u
X37 a_319_n8670# A_BM_I VSS VSS sg13_lv_nmos ad=0.1064p pd=0.94u as=0.1064p ps=0.94u w=0.56u l=0.13u
X38 VDD a_701_n8294# a_625_n7920# VDD sg13_lv_pmos ad=0.3366p pd=2.66u as=0.1881p ps=1.37u w=0.99u l=0.13u
X39 VSS A_DCLK_B_L a_735_n9075# VSS sg13_lv_nmos ad=0.13717p pd=1.25u as=0.1683p ps=1.67u w=0.495u l=0.13u
X40 VDD A_DW_I a_1849_n7922# VDD sg13_lv_pmos ad=0.16165p pd=1.365u as=0.18715p ps=1.365u w=0.985u l=0.13u
X41 a_1925_n7024# a_1925_n7500# VDD VDD sg13_lv_pmos ad=0.3078p pd=2u as=0.3078p ps=2u w=1.62u l=0.385u
X42 a_900_n8091# A_DCLK_B_L a_1033_n7914# VDD sg13_lv_pmos ad=0.14927p pd=1.355u as=91.2f ps=0.86u w=0.48u l=0.13u
X43 VSS a_89_n8340# a_21_n8302# VSS sg13_lv_nmos ad=0.3332p pd=2.64u as=0.3332p ps=2.64u w=0.98u l=0.13u
X44 VSS a_1823_n9077# a_1747_n8670# VSS sg13_lv_nmos ad=91.2f pd=0.86u as=91.2f ps=0.86u w=0.48u l=0.13u
X45 a_1033_n9075# A_DCLK_B_L a_931_n8672# VSS sg13_lv_nmos ad=0.13605p pd=1.25u as=0.1653p ps=1.25u w=0.87u l=0.13u
X46 VSS a_1925_n7024# a_1925_n7500# VSS sg13_lv_nmos ad=0.1577p pd=1.21u as=0.1577p ps=1.21u w=0.83u l=0.13u
X47 RM_IHPSG13_1P_BLDRV_1[1]/WR_ONE a_633_n4942# VSS VSS sg13_lv_nmos ad=0.3332p pd=2.64u as=0.1502p ps=1.36u w=0.98u l=0.13u
X48 a_1181_n7064# a_1143_n6984# VDD VDD sg13_lv_pmos ad=0.3078p pd=2u as=0.5508p ps=3.92u w=1.62u l=0.385u
X49 a_21_n4942# a_21_n8302# VDD VDD sg13_lv_pmos ad=0.1634p pd=1.24u as=0.2924p ps=2.4u w=0.86u l=0.13u
X50 a_707_n5378# RM_IHPSG13_1P_BLDRV_1[1]/BLC_SEL a_373_n5378# VSS sg13_lv_nmos ad=0.228p pd=1.58u as=0.228p ps=1.58u w=1.2u l=0.2u
X51 VSS a_89_n8340# a_225_n8226# VSS sg13_lv_nmos ad=91.2f pd=0.86u as=0.1632p ps=1.64u w=0.48u l=0.13u
X52 a_115_n4942# a_21_n8302# a_21_n4942# VSS sg13_lv_nmos ad=95f pd=0.88u as=0.17p ps=1.68u w=0.5u l=0.13u
X53 a_481_n5378# a_441_n5469# VDD VDD sg13_lv_pmos ad=0.152p pd=1.18u as=0.3p ps=2.35u w=0.8u l=0.13u
X54 RM_IHPSG13_1P_BLDRV_1[1]/WR_ZERO a_21_n4942# VSS VSS sg13_lv_nmos ad=0.3332p pd=2.64u as=0.1502p ps=1.36u w=0.98u l=0.13u
X55 VSS a_263_n7064# a_225_n6984# VSS sg13_lv_nmos ad=0.1577p pd=1.21u as=0.1577p ps=1.21u w=0.83u l=0.13u
X56 a_463_n7750# A_DCLK_B_L VSS VSS sg13_lv_nmos ad=0.1683p pd=1.67u as=0.13717p ps=1.25u w=0.495u l=0.13u
X57 a_1237_n7920# a_463_n7750# a_900_n8091# VDD sg13_lv_pmos ad=0.18525p pd=1.355u as=0.14927p ps=1.355u w=0.975u l=0.13u
X58 VSS a_701_n5820# a_707_n5378# VSS sg13_lv_nmos ad=0.228p pd=1.58u as=0.228p ps=1.58u w=1.2u l=0.13u
X59 a_599_n7500# a_599_n7024# VSS VSS sg13_lv_nmos ad=0.2822p pd=2.34u as=0.1577p ps=1.21u w=0.83u l=0.13u
X60 a_421_n9075# A_BIST_EN_I a_319_n9075# VDD sg13_lv_pmos ad=0.18715p pd=1.365u as=0.18715p ps=1.365u w=0.985u l=0.13u
R1 A_DCLK_L A_DCLK_R 0.203077
X61 a_1135_n8982# A_DCLK_B_L a_1033_n9075# VDD sg13_lv_pmos ad=91.2f pd=0.86u as=0.14927p ps=1.355u w=0.48u l=0.13u
X62 VDD A_WCLK_B_R a_1619_n4980# VDD sg13_lv_pmos ad=0.2924p pd=2.4u as=0.1634p ps=1.24u w=0.86u l=0.13u
X63 a_1619_n4980# A_WCLK_B_R a_1747_n4942# VSS sg13_lv_nmos ad=0.17p pd=1.68u as=95f ps=0.88u w=0.5u l=0.13u
X64 A_WCLK_B_R A_WCLK_L VDD VDD sg13_lv_pmos ad=0.5508p pd=3.92u as=0.5508p ps=3.92u w=1.62u l=0.13u
X65 VDD a_1823_n9077# a_1747_n8978# VDD sg13_lv_pmos ad=91.2f pd=0.86u as=91.2f ps=0.86u w=0.48u l=0.13u
X66 VSS a_1589_n7064# a_1551_n6984# VSS sg13_lv_nmos ad=0.1577p pd=1.21u as=0.2822p ps=2.34u w=0.83u l=0.13u
X67 a_1849_n8242# a_1686_n7711# a_1313_n8340# VSS sg13_lv_nmos ad=0.1064p pd=0.94u as=0.1064p ps=0.94u w=0.56u l=0.13u
X68 A_DCLK_B_L A_DCLK_L VSS VSS sg13_lv_nmos ad=0.2397p pd=2.09u as=0.2397p ps=2.09u w=0.705u l=0.13u
X69 VSS a_701_n8294# a_625_n8300# VSS sg13_lv_nmos ad=0.289p pd=2.38u as=0.1783p ps=1.44u w=0.85u l=0.13u
X70 VDD a_1211_n9080# a_1135_n8982# VDD sg13_lv_pmos ad=91.2f pd=0.86u as=91.2f ps=0.86u w=0.48u l=0.13u
X71 a_293_n6660# a_803_n6660# a_727_n6622# VSS sg13_lv_nmos ad=0.3332p pd=2.64u as=0.1862p ps=1.36u w=0.98u l=0.13u
X72 a_1543_n9078# a_1211_n9080# VDD VDD sg13_lv_pmos ad=0.1881p pd=1.37u as=0.3366p ps=2.66u w=0.99u l=0.13u
X73 a_441_n5469# a_701_n5820# VDD VDD sg13_lv_pmos ad=0.152p pd=1.18u as=0.3p ps=2.35u w=0.8u l=0.13u
X74 a_1551_n6984# a_1589_n7064# VSS VSS sg13_lv_nmos ad=0.1577p pd=1.21u as=0.1577p ps=1.21u w=0.83u l=0.13u
X75 VDD a_701_n5820# a_373_n5378# VDD sg13_lv_pmos ad=0.152p pd=1.18u as=0.348p ps=2.47u w=0.8u l=0.13u
X76 a_625_n8300# a_463_n7750# a_89_n8340# VSS sg13_lv_nmos ad=0.1783p pd=1.44u as=0.13375p ps=1.23u w=0.85u l=0.13u
X77 a_1143_n6984# a_1181_n7064# VSS VSS sg13_lv_nmos ad=0.1577p pd=1.21u as=0.1577p ps=1.21u w=0.83u l=0.13u
X78 VSS A_RCLK_R A_RCLK_B_R VSS sg13_lv_nmos ad=0.2397p pd=2.09u as=0.2397p ps=2.09u w=0.705u l=0.13u
X79 a_293_n6660# a_481_n5378# VDD VDD sg13_lv_pmos ad=0.171p pd=1.28u as=0.171p ps=1.28u w=0.9u l=0.13u
X80 a_2053_n4620# A_WCLK_B_R VDD VDD sg13_lv_pmos ad=0.3078p pd=2u as=0.5508p ps=3.92u w=1.62u l=0.13u
X81 a_1686_n7711# A_BIST_EN_I VDD VDD sg13_lv_pmos ad=0.2193p pd=1.97u as=0.16165p ps=1.365u w=0.645u l=0.13u
X82 a_441_n5469# a_481_n5378# a_1135_n5784# VSS sg13_lv_nmos ad=0.228p pd=1.58u as=0.408p ps=3.08u w=1.2u l=0.2u
X83 a_803_n6660# a_441_n5469# VDD VDD sg13_lv_pmos ad=0.306p pd=2.48u as=0.171p ps=1.28u w=0.9u l=0.13u
X84 a_421_n7918# a_225_n8226# VDD VDD sg13_lv_pmos ad=91.2f pd=0.86u as=91.2f ps=0.86u w=0.48u l=0.13u
X85 a_421_n9075# a_123_n9075# a_319_n8670# VSS sg13_lv_nmos ad=0.1064p pd=0.94u as=0.1064p ps=0.94u w=0.56u l=0.13u
X86 a_1589_n7064# a_1551_n6984# VDD VDD sg13_lv_pmos ad=0.3078p pd=2u as=0.5508p ps=3.92u w=1.62u l=0.385u
X87 a_1339_n6622# a_293_n6660# a_803_n6660# VSS sg13_lv_nmos ad=0.1862p pd=1.36u as=0.3332p ps=2.64u w=0.98u l=0.13u
X88 a_1645_n7922# A_BIST_DW_I VDD VDD sg13_lv_pmos ad=0.18715p pd=1.365u as=0.3349p ps=2.65u w=0.985u l=0.13u
X89 a_707_n5378# RM_IHPSG13_1P_BLDRV_1[1]/BLT_SEL a_1135_n5784# VSS sg13_lv_nmos ad=0.408p pd=3.08u as=0.228p ps=1.58u w=1.2u l=0.2u
R2 A_RCLK_L A_RCLK_R 0.203077
X90 a_1135_n8672# a_735_n9075# a_1033_n9075# VSS sg13_lv_nmos ad=91.2f pd=0.86u as=0.13605p ps=1.25u w=0.48u l=0.13u
X91 a_1823_n9077# a_1645_n9078# VSS VSS sg13_lv_nmos ad=0.1632p pd=1.64u as=91.2f ps=0.86u w=0.48u l=0.13u
X92 VSS a_900_n8091# a_701_n8294# VSS sg13_lv_nmos ad=91.2f pd=0.86u as=0.1632p ps=1.64u w=0.48u l=0.13u
X93 a_1925_n7500# a_1925_n7024# VSS VSS sg13_lv_nmos ad=0.2822p pd=2.34u as=0.1577p ps=1.21u w=0.83u l=0.13u
X94 VDD a_1619_n4980# a_1313_n4980# VDD sg13_lv_pmos ad=0.2508p pd=2u as=0.5508p ps=3.92u w=1.62u l=0.13u
X95 a_1313_n8340# a_1686_n7711# a_1645_n7922# VDD sg13_lv_pmos ad=0.18715p pd=1.365u as=0.18715p ps=1.365u w=0.985u l=0.13u
X96 A_DR_O a_293_n6660# VDD VDD sg13_lv_pmos ad=0.3078p pd=2u as=0.5508p ps=3.92u w=1.62u l=0.13u
X97 a_421_n8226# a_225_n8226# VSS VSS sg13_lv_nmos ad=91.2f pd=0.86u as=91.2f ps=0.86u w=0.48u l=0.13u
X98 VSS a_1211_n9080# a_1135_n8672# VSS sg13_lv_nmos ad=91.2f pd=0.86u as=91.2f ps=0.86u w=0.48u l=0.13u
X99 a_707_n5378# a_701_n5820# VSS VSS sg13_lv_nmos ad=0.228p pd=1.58u as=0.228p ps=1.58u w=1.2u l=0.13u
X100 a_599_n7500# a_599_n7024# VSS VSS sg13_lv_nmos ad=0.1577p pd=1.21u as=0.1577p ps=1.21u w=0.83u l=0.13u
X101 VDD a_1313_n8340# a_1237_n7920# VDD sg13_lv_pmos ad=0.14812p pd=1.355u as=0.18525p ps=1.355u w=0.975u l=0.13u
X102 a_633_n4942# a_89_n8340# VDD VDD sg13_lv_pmos ad=0.1634p pd=1.24u as=0.2924p ps=2.4u w=0.86u l=0.13u
X103 a_727_n4942# a_89_n8340# a_633_n4942# VSS sg13_lv_nmos ad=95f pd=0.88u as=0.17p ps=1.68u w=0.5u l=0.13u
X104 RM_IHPSG13_1P_BLDRV_1[1]/PRE_N a_1313_n4980# VDD VDD sg13_lv_pmos ad=0.3078p pd=2u as=0.5508p ps=3.92u w=1.62u l=0.13u
X105 a_523_n9075# a_123_n9075# a_421_n9075# VDD sg13_lv_pmos ad=0.18715p pd=1.365u as=0.18715p ps=1.365u w=0.985u l=0.13u
X106 VDD a_599_n7500# a_599_n7024# VDD sg13_lv_pmos ad=0.5508p pd=3.92u as=0.3078p ps=2u w=1.62u l=0.385u
X107 VDD a_1823_n6660# a_701_n5820# VDD sg13_lv_pmos ad=0.2688p pd=2u as=0.5508p ps=3.92u w=1.62u l=0.13u
X108 a_373_n5378# RM_IHPSG13_1P_BLDRV_1[1]/BLC_SEL a_707_n5378# VSS sg13_lv_nmos ad=0.228p pd=1.58u as=0.408p ps=3.08u w=1.2u l=0.2u
X109 a_1823_n9077# a_1645_n9078# VDD VDD sg13_lv_pmos ad=0.1632p pd=1.64u as=91.2f ps=0.86u w=0.48u l=0.13u
X110 VDD A_DCLK_B_L a_735_n9075# VDD sg13_lv_pmos ad=0.14812p pd=1.355u as=0.1632p ps=1.64u w=0.48u l=0.13u
X111 a_1135_n5784# RM_IHPSG13_1P_BLDRV_1[1]/BLT_SEL a_707_n5378# VSS sg13_lv_nmos ad=0.228p pd=1.58u as=0.228p ps=1.58u w=1.2u l=0.2u
X112 VSS a_263_n7064# a_225_n6984# VSS sg13_lv_nmos ad=0.1577p pd=1.21u as=0.2822p ps=2.34u w=0.83u l=0.13u
X113 a_1237_n8302# A_DCLK_B_L a_900_n8091# VSS sg13_lv_nmos ad=0.1653p pd=1.25u as=0.13605p ps=1.25u w=0.87u l=0.13u
X114 VSS A_DW_I a_1849_n8242# VSS sg13_lv_nmos ad=0.1064p pd=0.94u as=0.1064p ps=0.94u w=0.56u l=0.13u
X115 a_1033_n8224# a_701_n8294# VSS VSS sg13_lv_nmos ad=91.2f pd=0.86u as=91.2f ps=0.86u w=0.48u l=0.13u
X116 VDD a_701_n5820# a_481_n5378# VDD sg13_lv_pmos ad=0.3p pd=2.35u as=0.152p ps=1.18u w=0.8u l=0.13u
X117 a_1211_n9080# a_1033_n9075# VDD VDD sg13_lv_pmos ad=0.1632p pd=1.64u as=91.2f ps=0.86u w=0.48u l=0.13u
X118 VDD A_BIST_EN_I a_123_n9075# VDD sg13_lv_pmos ad=0.16165p pd=1.365u as=0.2193p ps=1.97u w=0.645u l=0.13u
X119 a_373_n5378# a_441_n5469# a_481_n5378# VSS sg13_lv_nmos ad=0.408p pd=3.08u as=0.228p ps=1.58u w=1.2u l=0.2u
X120 a_1645_n9078# A_DCLK_B_L a_1543_n9078# VDD sg13_lv_pmos ad=0.1511p pd=1.37u as=0.1881p ps=1.37u w=0.99u l=0.13u
X121 VDD a_481_n5378# a_441_n5469# VDD sg13_lv_pmos ad=0.3p pd=2.35u as=0.152p ps=1.18u w=0.8u l=0.13u
X122 VSS a_1589_n7064# a_1551_n6984# VSS sg13_lv_nmos ad=0.1577p pd=1.21u as=0.1577p ps=1.21u w=0.83u l=0.13u
X123 a_1135_n5784# a_701_n5820# VDD VDD sg13_lv_pmos ad=0.348p pd=2.47u as=0.152p ps=1.18u w=0.8u l=0.13u
X124 VDD a_803_n6660# a_293_n6660# VDD sg13_lv_pmos ad=0.306p pd=2.48u as=0.171p ps=1.28u w=0.9u l=0.13u
X125 VSS a_1181_n7064# a_1143_n6984# VSS sg13_lv_nmos ad=0.2822p pd=2.34u as=0.1577p ps=1.21u w=0.83u l=0.13u
R3 A_DCLK_B_L A_DCLK_B_R 0.203077
R4 A_RCLK_B_L A_RCLK_B_R 0.203077
X126 a_766_n4732# a_2092_n4732# a_2053_n4620# VDD sg13_lv_pmos ad=0.5508p pd=3.92u as=0.3078p ps=2u w=1.62u l=0.13u
X127 a_599_n7024# a_599_n7500# VDD VDD sg13_lv_pmos ad=0.3078p pd=2u as=0.3078p ps=2u w=1.62u l=0.385u
X128 A_DR_O a_293_n6660# VSS VSS sg13_lv_nmos ad=0.1862p pd=1.36u as=0.3332p ps=2.64u w=0.98u l=0.13u
X129 VDD a_900_n8091# a_701_n8294# VDD sg13_lv_pmos ad=91.2f pd=0.86u as=0.1632p ps=1.64u w=0.48u l=0.13u
X130 a_625_n7920# A_DCLK_B_L a_89_n8340# VDD sg13_lv_pmos ad=0.1881p pd=1.37u as=0.1511p ps=1.37u w=0.99u l=0.13u
X131 a_89_n8340# a_463_n7750# a_421_n7918# VDD sg13_lv_pmos ad=0.1511p pd=1.37u as=91.2f ps=0.86u w=0.48u l=0.13u
X132 a_523_n8670# A_BIST_EN_I a_421_n9075# VSS sg13_lv_nmos ad=0.1064p pd=0.94u as=0.1064p ps=0.94u w=0.56u l=0.13u
X133 VSS a_1823_n6660# a_701_n5820# VSS sg13_lv_nmos ad=0.12157p pd=1.085u as=0.2397p ps=2.09u w=0.705u l=0.13u
X134 a_89_n7500# a_89_n7500# VSS VSS sg13_lv_nmos ad=0.1632p pd=1.64u as=0.1632p ps=1.64u w=0.48u l=0.13u
R5 A_WCLK_B_L A_WCLK_B_R 0.203077
X135 A_TIEH_O a_89_n7500# VDD VDD sg13_lv_pmos ad=0.1632p pd=1.64u as=0.1632p ps=1.64u w=0.48u l=0.13u
X136 VSS a_441_n5469# a_1339_n6622# VSS sg13_lv_nmos ad=0.3332p pd=2.64u as=0.1862p ps=1.36u w=0.98u l=0.13u
X137 a_263_n7064# a_225_n6984# VDD VDD sg13_lv_pmos ad=0.3078p pd=2u as=0.5508p ps=3.92u w=1.62u l=0.385u
X138 RM_IHPSG13_1P_BLDRV_1[1]/WR_ONE a_633_n4942# VDD VDD sg13_lv_pmos ad=0.5508p pd=3.92u as=0.2508p ps=2u w=1.62u l=0.13u
X139 a_766_n4732# A_WCLK_B_R VSS VSS sg13_lv_nmos ad=0.1862p pd=1.36u as=0.3332p ps=2.64u w=0.98u l=0.13u
X140 a_481_n5378# a_441_n5469# a_373_n5378# VSS sg13_lv_nmos ad=0.228p pd=1.58u as=0.408p ps=3.08u w=1.2u l=0.2u
X141 a_803_n6660# a_293_n6660# VDD VDD sg13_lv_pmos ad=0.171p pd=1.28u as=0.306p ps=2.48u w=0.9u l=0.13u
X142 a_1645_n9078# a_735_n9075# a_1543_n8712# VSS sg13_lv_nmos ad=0.13375p pd=1.23u as=0.1783p ps=1.44u w=0.85u l=0.13u
X143 VSS A_BIST_EN_I a_123_n9075# VSS sg13_lv_nmos ad=0.1064p pd=0.94u as=0.1904p ps=1.8u w=0.56u l=0.13u
X144 a_463_n7750# A_DCLK_B_L VDD VDD sg13_lv_pmos ad=0.1632p pd=1.64u as=0.14812p ps=1.355u w=0.48u l=0.13u
X145 A_WCLK_B_R A_WCLK_L VSS VSS sg13_lv_nmos ad=0.2397p pd=2.09u as=0.2397p ps=2.09u w=0.705u l=0.13u
X146 a_1686_n7711# A_BIST_EN_I VSS VSS sg13_lv_nmos ad=0.1904p pd=1.8u as=0.1064p ps=0.94u w=0.56u l=0.13u
X147 VDD a_1925_n7500# a_1925_n7024# VDD sg13_lv_pmos ad=0.5508p pd=3.92u as=0.3078p ps=2u w=1.62u l=0.385u
X148 RM_IHPSG13_1P_BLDRV_1[1]/WR_ZERO a_21_n4942# VDD VDD sg13_lv_pmos ad=0.5508p pd=3.92u as=0.2508p ps=2u w=1.62u l=0.13u
X149 a_1849_n7922# A_BIST_EN_I a_1313_n8340# VDD sg13_lv_pmos ad=0.18715p pd=1.365u as=0.18715p ps=1.365u w=0.985u l=0.13u
X150 a_1033_n7914# a_701_n8294# VDD VDD sg13_lv_pmos ad=91.2f pd=0.86u as=91.2f ps=0.86u w=0.48u l=0.13u
X151 A_DCLK_B_L A_DCLK_L VDD VDD sg13_lv_pmos ad=0.5508p pd=3.92u as=0.5508p ps=3.92u w=1.62u l=0.13u
X152 VDD a_293_n6660# A_DR_O VDD sg13_lv_pmos ad=0.5508p pd=3.92u as=0.3078p ps=2u w=1.62u l=0.13u
X153 a_89_n8340# A_DCLK_B_L a_421_n8226# VSS sg13_lv_nmos ad=0.13375p pd=1.23u as=91.2f ps=0.86u w=0.48u l=0.13u
X154 a_1823_n6660# A_RCLK_B_R VDD VDD sg13_lv_pmos ad=0.374p pd=2.88u as=0.2688p ps=2u w=1.1u l=0.13u
X155 a_1211_n9080# a_1033_n9075# VSS VSS sg13_lv_nmos ad=0.1632p pd=1.64u as=91.2f ps=0.86u w=0.48u l=0.13u
X156 VDD A_RCLK_R A_RCLK_B_R VDD sg13_lv_pmos ad=0.5508p pd=3.92u as=0.5508p ps=3.92u w=1.62u l=0.13u
X157 VDD a_766_n4732# a_633_n4942# VDD sg13_lv_pmos ad=0.2508p pd=2u as=0.1634p ps=1.24u w=0.86u l=0.13u
X158 a_1747_n8670# A_DCLK_B_L a_1645_n9078# VSS sg13_lv_nmos ad=91.2f pd=0.86u as=0.13375p ps=1.23u w=0.48u l=0.13u
X159 VSS a_766_n4732# a_727_n4942# VSS sg13_lv_nmos ad=0.1502p pd=1.36u as=95f ps=0.88u w=0.5u l=0.13u
.ends

.subckt RM_IHPSG13_1P_COLDRV13_FILL4 m3_0_n3297# m3_0_n3969# m3_0_n2709# m3_0_n6405#
+ m3_0_n3549# m3_0_n6741# m3_0_n4137# m3_0_n6657# m3_0_n2625# m3_0_n3213# m3_0_n3129#
+ m3_0_n6321# m3_0_n3465# m3_0_n6237# m3_0_n6573# m3_0_n4053# m3_0_n6489# m3_0_n861#
+ m3_0_n273# m3_0_n693#
X0 a_59_n1402# a_21_n1582# m3_0_n861# m3_0_n861# sg13_lv_pmos ad=0.3078p pd=2u as=0.5508p ps=3.92u w=1.62u l=0.385u
X1 a_21_n4942# a_59_n4762# m3_0_n693# m3_0_n693# sg13_lv_nmos ad=0.1577p pd=1.21u as=0.1577p ps=1.21u w=0.83u l=0.13u
X2 a_21_n264# a_59_n344# m3_0_n693# m3_0_n693# sg13_lv_nmos ad=0.1577p pd=1.21u as=0.1577p ps=1.21u w=0.83u l=0.13u
X3 m3_0_n693# a_59_n5384# a_21_n5304# m3_0_n693# sg13_lv_nmos ad=0.1577p pd=1.21u as=0.2822p ps=2.34u w=0.83u l=0.13u
X4 m3_0_n693# a_59_n5384# a_21_n5304# m3_0_n693# sg13_lv_nmos ad=0.2822p pd=2.34u as=0.1577p ps=1.21u w=0.83u l=0.13u
X5 m3_0_n693# a_59_n2024# a_21_n1944# m3_0_n693# sg13_lv_nmos ad=0.1577p pd=1.21u as=0.2822p ps=2.34u w=0.83u l=0.13u
X6 m3_0_n693# a_59_n2024# a_21_n1944# m3_0_n693# sg13_lv_nmos ad=0.2822p pd=2.34u as=0.1577p ps=1.21u w=0.83u l=0.13u
X7 m3_0_n861# a_21_n264# a_59_n344# m3_0_n861# sg13_lv_pmos ad=0.5508p pd=3.92u as=0.3078p ps=2u w=1.62u l=0.385u
X8 a_21_n1582# a_59_n1402# m3_0_n693# m3_0_n693# sg13_lv_nmos ad=0.1577p pd=1.21u as=0.1577p ps=1.21u w=0.83u l=0.13u
X9 m3_0_n861# a_21_n6622# a_59_n6442# m3_0_n861# sg13_lv_pmos ad=0.5508p pd=3.92u as=0.3078p ps=2u w=1.62u l=0.385u
X10 m3_0_n693# a_59_n344# a_21_n264# m3_0_n693# sg13_lv_nmos ad=0.1577p pd=1.21u as=0.2822p ps=2.34u w=0.83u l=0.13u
X11 m3_0_n861# a_21_n3624# a_59_n3704# m3_0_n861# sg13_lv_pmos ad=0.5508p pd=3.92u as=0.3078p ps=2u w=1.62u l=0.385u
X12 a_59_n2024# a_21_n1944# m3_0_n861# m3_0_n861# sg13_lv_pmos ad=0.3078p pd=2u as=0.5508p ps=3.92u w=1.62u l=0.385u
X13 a_21_n3624# a_59_n3704# m3_0_n693# m3_0_n693# sg13_lv_nmos ad=0.1577p pd=1.21u as=0.1577p ps=1.21u w=0.83u l=0.13u
X14 m3_0_n693# a_59_n344# a_21_n264# m3_0_n693# sg13_lv_nmos ad=0.2822p pd=2.34u as=0.1577p ps=1.21u w=0.83u l=0.13u
X15 a_59_n344# a_21_n264# m3_0_n861# m3_0_n861# sg13_lv_pmos ad=0.3078p pd=2u as=0.5508p ps=3.92u w=1.62u l=0.385u
X16 m3_0_n693# a_59_n4762# a_21_n4942# m3_0_n693# sg13_lv_nmos ad=0.1577p pd=1.21u as=0.2822p ps=2.34u w=0.83u l=0.13u
X17 m3_0_n693# a_59_n4762# a_21_n4942# m3_0_n693# sg13_lv_nmos ad=0.2822p pd=2.34u as=0.1577p ps=1.21u w=0.83u l=0.13u
X18 m3_0_n861# a_21_n6984# a_59_n7064# m3_0_n861# sg13_lv_pmos ad=0.5508p pd=3.92u as=0.3078p ps=2u w=1.62u l=0.385u
X19 a_59_n5384# a_21_n5304# m3_0_n861# m3_0_n861# sg13_lv_pmos ad=0.3078p pd=2u as=0.5508p ps=3.92u w=1.62u l=0.385u
X20 a_21_n6984# a_59_n7064# m3_0_n693# m3_0_n693# sg13_lv_nmos ad=0.1577p pd=1.21u as=0.1577p ps=1.21u w=0.83u l=0.13u
X21 m3_0_n693# a_59_n1402# a_21_n1582# m3_0_n693# sg13_lv_nmos ad=0.1577p pd=1.21u as=0.2822p ps=2.34u w=0.83u l=0.13u
X22 m3_0_n693# a_59_n1402# a_21_n1582# m3_0_n693# sg13_lv_nmos ad=0.2822p pd=2.34u as=0.1577p ps=1.21u w=0.83u l=0.13u
X23 m3_0_n861# a_21_n4942# a_59_n4762# m3_0_n861# sg13_lv_pmos ad=0.5508p pd=3.92u as=0.3078p ps=2u w=1.62u l=0.385u
X24 a_59_n3082# a_21_n3262# m3_0_n861# m3_0_n861# sg13_lv_pmos ad=0.3078p pd=2u as=0.5508p ps=3.92u w=1.62u l=0.385u
X25 a_21_n6622# a_59_n6442# m3_0_n693# m3_0_n693# sg13_lv_nmos ad=0.1577p pd=1.21u as=0.1577p ps=1.21u w=0.83u l=0.13u
X26 m3_0_n861# a_21_n1582# a_59_n1402# m3_0_n861# sg13_lv_pmos ad=0.5508p pd=3.92u as=0.3078p ps=2u w=1.62u l=0.385u
X27 a_21_n3262# a_59_n3082# m3_0_n693# m3_0_n693# sg13_lv_nmos ad=0.1577p pd=1.21u as=0.1577p ps=1.21u w=0.83u l=0.13u
X28 m3_0_n693# a_59_n3704# a_21_n3624# m3_0_n693# sg13_lv_nmos ad=0.1577p pd=1.21u as=0.2822p ps=2.34u w=0.83u l=0.13u
X29 m3_0_n693# a_59_n3704# a_21_n3624# m3_0_n693# sg13_lv_nmos ad=0.2822p pd=2.34u as=0.1577p ps=1.21u w=0.83u l=0.13u
X30 a_59_n6442# a_21_n6622# m3_0_n861# m3_0_n861# sg13_lv_pmos ad=0.3078p pd=2u as=0.5508p ps=3.92u w=1.62u l=0.385u
X31 m3_0_n693# a_59_n7064# a_21_n6984# m3_0_n693# sg13_lv_nmos ad=0.1577p pd=1.21u as=0.2822p ps=2.34u w=0.83u l=0.13u
X32 m3_0_n693# a_59_n7064# a_21_n6984# m3_0_n693# sg13_lv_nmos ad=0.2822p pd=2.34u as=0.1577p ps=1.21u w=0.83u l=0.13u
X33 a_59_n3704# a_21_n3624# m3_0_n861# m3_0_n861# sg13_lv_pmos ad=0.3078p pd=2u as=0.5508p ps=3.92u w=1.62u l=0.385u
X34 a_21_n5304# a_59_n5384# m3_0_n693# m3_0_n693# sg13_lv_nmos ad=0.1577p pd=1.21u as=0.1577p ps=1.21u w=0.83u l=0.13u
X35 m3_0_n861# a_21_n1944# a_59_n2024# m3_0_n861# sg13_lv_pmos ad=0.5508p pd=3.92u as=0.3078p ps=2u w=1.62u l=0.385u
X36 a_21_n1944# a_59_n2024# m3_0_n693# m3_0_n693# sg13_lv_nmos ad=0.1577p pd=1.21u as=0.1577p ps=1.21u w=0.83u l=0.13u
X37 m3_0_n693# a_59_n6442# a_21_n6622# m3_0_n693# sg13_lv_nmos ad=0.1577p pd=1.21u as=0.2822p ps=2.34u w=0.83u l=0.13u
X38 m3_0_n693# a_59_n6442# a_21_n6622# m3_0_n693# sg13_lv_nmos ad=0.2822p pd=2.34u as=0.1577p ps=1.21u w=0.83u l=0.13u
X39 a_59_n7064# a_21_n6984# m3_0_n861# m3_0_n861# sg13_lv_pmos ad=0.3078p pd=2u as=0.5508p ps=3.92u w=1.62u l=0.385u
X40 m3_0_n693# a_59_n3082# a_21_n3262# m3_0_n693# sg13_lv_nmos ad=0.1577p pd=1.21u as=0.2822p ps=2.34u w=0.83u l=0.13u
X41 m3_0_n693# a_59_n3082# a_21_n3262# m3_0_n693# sg13_lv_nmos ad=0.2822p pd=2.34u as=0.1577p ps=1.21u w=0.83u l=0.13u
X42 m3_0_n861# a_21_n5304# a_59_n5384# m3_0_n861# sg13_lv_pmos ad=0.5508p pd=3.92u as=0.3078p ps=2u w=1.62u l=0.385u
X43 a_59_n4762# a_21_n4942# m3_0_n861# m3_0_n861# sg13_lv_pmos ad=0.3078p pd=2u as=0.5508p ps=3.92u w=1.62u l=0.385u
X44 m3_0_n861# a_21_n3262# a_59_n3082# m3_0_n861# sg13_lv_pmos ad=0.5508p pd=3.92u as=0.3078p ps=2u w=1.62u l=0.385u
.ends

* Black-box entry subcircuit for RM_IHPSG13_1P_1024x8_c2_bm_bist abstract view
.subckt RM_IHPSG13_1P_1024x8_c2_bm_bist A_ADDR<9> A_ADDR<8> A_ADDR<7> A_ADDR<6> A_ADDR<5>
+ A_ADDR<4> A_ADDR<3> A_ADDR<2> A_ADDR<1> A_ADDR<0> A_BIST_ADDR<9> A_BIST_ADDR<8>
+ A_BIST_ADDR<7> A_BIST_ADDR<6> A_BIST_ADDR<5> A_BIST_ADDR<4> A_BIST_ADDR<3> A_BIST_ADDR<2>
+ A_BIST_ADDR<1> A_BIST_ADDR<0> A_BIST_BM<7> A_BIST_BM<6> A_BIST_BM<5> A_BIST_BM<4>
+ A_BIST_BM<3> A_BIST_BM<2> A_BIST_BM<1> A_BIST_BM<0> A_BIST_CLK A_BIST_DIN<7> A_BIST_DIN<6>
+ A_BIST_DIN<5> A_BIST_DIN<4> A_BIST_DIN<3> A_BIST_DIN<2> A_BIST_DIN<1> A_BIST_DIN<0>
+ A_BIST_EN A_BIST_MEN A_BIST_REN A_BIST_WEN A_BM<7> A_BM<6> A_BM<5> A_BM<4> A_BM<3>
+ A_BM<2> A_BM<1> A_BM<0> A_CLK A_DIN<7> A_DIN<6> A_DIN<5> A_DIN<4> A_DIN<3> A_DIN<2>
+ A_DIN<1> A_DIN<0> A_DLY A_DOUT<7> A_DOUT<6> A_DOUT<5> A_DOUT<4> A_DOUT<3> A_DOUT<2>
+ A_DOUT<1> A_DOUT<0> A_MEN A_REN A_WEN VDD VDDARRAY VSS
.ends

.subckt sg13_hv_nmos_2RYP69 D S G sub
X0 S G D sub sg13_hv_nmos ad=0.34p pd=2.68u as=0.34p ps=2.68u w=1u l=1u
.ends

.subckt bias_nstack itail shld2 shld3 avss a_1030_2157# nbias ncasc ena
Xsg13_hv_nmos_2RYP69_0[0] sg13_hv_nmos_2RYP69_0[5]/D itail ena avss sg13_hv_nmos_2RYP69
Xsg13_hv_nmos_2RYP69_0[1] sg13_hv_nmos_2RYP69_0[5]/D itail ena avss sg13_hv_nmos_2RYP69
Xsg13_hv_nmos_2RYP69_0[2] sg13_hv_nmos_2RYP69_0[5]/D itail ena avss sg13_hv_nmos_2RYP69
Xsg13_hv_nmos_2RYP69_0[3] sg13_hv_nmos_2RYP69_0[5]/D sg13_hv_nmos_2RYP69_0[8]/S ncasc
+ avss sg13_hv_nmos_2RYP69
Xsg13_hv_nmos_2RYP69_0[4] sg13_hv_nmos_2RYP69_0[5]/D sg13_hv_nmos_2RYP69_0[8]/S ncasc
+ avss sg13_hv_nmos_2RYP69
Xsg13_hv_nmos_2RYP69_0[5] sg13_hv_nmos_2RYP69_0[5]/D sg13_hv_nmos_2RYP69_0[8]/S ncasc
+ avss sg13_hv_nmos_2RYP69
Xsg13_hv_nmos_2RYP69_0[6] avss sg13_hv_nmos_2RYP69_0[8]/S nbias avss sg13_hv_nmos_2RYP69
Xsg13_hv_nmos_2RYP69_0[7] avss sg13_hv_nmos_2RYP69_0[8]/S nbias avss sg13_hv_nmos_2RYP69
Xsg13_hv_nmos_2RYP69_0[8] avss sg13_hv_nmos_2RYP69_0[8]/S nbias avss sg13_hv_nmos_2RYP69
.ends

.subckt sg13_hv_pmos_KGSGVN D S G w_n292_n205#
X0 S G D w_n292_n205# sg13_hv_pmos ad=0.34p pd=2.68u as=0.34p ps=2.68u w=1u l=1u
.ends

.subckt bias_pstack avdd itail shld2 shld3 enb pbias pcasc
Xsg13_hv_pmos_KGSGVN_0[0] sg13_hv_pmos_KGSGVN_0[5]/D itail enb avdd sg13_hv_pmos_KGSGVN
Xsg13_hv_pmos_KGSGVN_0[1] sg13_hv_pmos_KGSGVN_0[5]/D itail enb avdd sg13_hv_pmos_KGSGVN
Xsg13_hv_pmos_KGSGVN_0[2] sg13_hv_pmos_KGSGVN_0[5]/D itail enb avdd sg13_hv_pmos_KGSGVN
Xsg13_hv_pmos_KGSGVN_0[3] sg13_hv_pmos_KGSGVN_0[5]/D sg13_hv_pmos_KGSGVN_0[8]/S pcasc
+ avdd sg13_hv_pmos_KGSGVN
Xsg13_hv_pmos_KGSGVN_0[4] sg13_hv_pmos_KGSGVN_0[5]/D sg13_hv_pmos_KGSGVN_0[8]/S pcasc
+ avdd sg13_hv_pmos_KGSGVN
Xsg13_hv_pmos_KGSGVN_0[5] sg13_hv_pmos_KGSGVN_0[5]/D sg13_hv_pmos_KGSGVN_0[8]/S pcasc
+ avdd sg13_hv_pmos_KGSGVN
Xsg13_hv_pmos_KGSGVN_0[6] avdd sg13_hv_pmos_KGSGVN_0[8]/S pbias avdd sg13_hv_pmos_KGSGVN
Xsg13_hv_pmos_KGSGVN_0[7] avdd sg13_hv_pmos_KGSGVN_0[8]/S pbias avdd sg13_hv_pmos_KGSGVN
Xsg13_hv_pmos_KGSGVN_0[8] avdd sg13_hv_pmos_KGSGVN_0[8]/S pbias avdd sg13_hv_pmos_KGSGVN
.ends

.subckt sg13_hv_pmos_DNCZKC D0 G0 S1 G1 w_n330_n224# a_138_n100#
X0 a_138_n100# G1 S1 w_n330_n224# sg13_hv_pmos ad=0.34p pd=2.68u as=0.19p ps=1.38u w=1u l=0.5u
X1 S1 G0 D0 w_n330_n224# sg13_hv_pmos ad=0.19p pd=1.38u as=0.34p ps=2.68u w=1u l=0.5u
.ends

.subckt sg13_hv_nmos_QHASHE D0 G0 S1 G1 a_138_n400# sub
X0 S1 G0 D0 sub sg13_hv_nmos ad=0.76p pd=4.38u as=1.36p ps=8.68u w=4u l=0.5u
X1 a_138_n400# G1 S1 sub sg13_hv_nmos ad=1.36p pd=8.68u as=0.76p ps=4.38u w=4u l=0.5u
.ends

.subckt sg13_hv_nmos_QBGVHE D0 G0 S1 G1 a_138_n100# sub
X0 a_138_n100# G1 S1 sub sg13_hv_nmos ad=0.34p pd=2.68u as=0.19p ps=1.38u w=1u l=0.5u
X1 S1 G0 D0 sub sg13_hv_nmos ad=0.19p pd=1.38u as=0.34p ps=2.68u w=1u l=0.5u
.ends

.subckt sg13_hv_pmos_ZPCZKC D0 G0 S1 G1 D2 S2 G2 w_n418_n324#
X0 S1 G0 D0 w_n418_n324# sg13_hv_pmos ad=0.38p pd=2.38u as=0.68p ps=4.68u w=2u l=0.5u
X1 S2 G2 D2 w_n418_n324# sg13_hv_pmos ad=0.68p pd=4.68u as=0.38p ps=2.38u w=2u l=0.5u
X2 D2 G1 S1 w_n418_n324# sg13_hv_pmos ad=0.38p pd=2.38u as=0.38p ps=2.38u w=2u l=0.5u
.ends

.subckt level_shift in_n in_p out vss vdd
Xsg13_hv_pmos_DNCZKC_0 XM2/G1 XM7/G0 vdd XM2/G1 vdd XM7/G0 sg13_hv_pmos_DNCZKC
XXM1 XM2/G1 in_p vss in_p XM2/G1 vss sg13_hv_nmos_QHASHE
XXM2 XM2/G1 XM7/G0 vdd XM2/G1 vdd XM7/G0 sg13_hv_pmos_DNCZKC
XXM3 XM7/G0 in_n vss in_n XM7/G0 vss sg13_hv_nmos_QHASHE
XXM6 vss XM7/G0 XM7/G2 XM7/G0 vss vss sg13_hv_nmos_QBGVHE
XXM7 XM7/G2 XM7/G0 vdd XM7/G2 out vdd XM7/G2 vdd sg13_hv_pmos_ZPCZKC
Xsg13_hv_nmos_QBGVHE_0 vss XM7/G2 out XM7/G2 vss vss sg13_hv_nmos_QBGVHE
Xsg13_hv_nmos_QBGVHE_1 vss XM7/G2 out XM7/G2 vss vss sg13_hv_nmos_QBGVHE
Xsg13_hv_pmos_ZPCZKC_0 XM7/G2 XM7/G0 vdd XM7/G2 out vdd XM7/G2 vdd sg13_hv_pmos_ZPCZKC
.ends

.subckt bias_generator_ben1um sink_ena[2] sink_ena[1] sink_ena[0] sink_ibias ncasc
+ bias_nstack_0[9]/itail sub dvdd nbias bias_nstack_3/shld2 avdd dvss bias_nstack_2[2]/a_1030_2157#
+ bias_nstack_3/shld3
Xbias_nstack_0[0] bias_nstack_0[9]/itail bias_nstack_3/shld2 bias_nstack_3/shld3 sub
+ sub nbias ncasc sub bias_nstack
Xbias_nstack_0[1] bias_nstack_0[9]/itail bias_nstack_3/shld2 bias_nstack_3/shld3 sub
+ sub nbias ncasc sub bias_nstack
Xbias_nstack_0[2] bias_nstack_0[9]/itail bias_nstack_3/shld2 bias_nstack_3/shld3 sub
+ sub nbias ncasc sub bias_nstack
Xbias_nstack_0[3] bias_nstack_0[9]/itail bias_nstack_3/shld2 bias_nstack_3/shld3 sub
+ sub nbias ncasc sub bias_nstack
Xbias_nstack_0[4] bias_nstack_0[9]/itail bias_nstack_3/shld2 bias_nstack_3/shld3 sub
+ sub nbias ncasc sub bias_nstack
Xbias_nstack_0[5] bias_nstack_0[9]/itail bias_nstack_3/shld2 bias_nstack_3/shld3 sub
+ sub nbias ncasc sub bias_nstack
Xbias_nstack_0[6] bias_nstack_0[9]/itail bias_nstack_3/shld2 bias_nstack_3/shld3 sub
+ sub nbias ncasc sub bias_nstack
Xbias_nstack_0[7] bias_nstack_0[9]/itail bias_nstack_3/shld2 bias_nstack_3/shld3 sub
+ sub nbias ncasc sub bias_nstack
Xbias_nstack_0[8] bias_nstack_0[9]/itail bias_nstack_3/shld2 bias_nstack_3/shld3 sub
+ sub nbias ncasc sub bias_nstack
Xbias_nstack_0[9] bias_nstack_0[9]/itail bias_nstack_3/shld2 bias_nstack_3/shld3 sub
+ sub nbias ncasc sub bias_nstack
Xsg13cmos5l_inv_2_0 level_shift_0/in_n sink_ena[1] dvdd dvss sg13cmos5l_inv_2
Xbias_nstack_1 sink_ibias bias_nstack_3/shld2 bias_nstack_3/shld3 sub sub nbias ncasc
+ level_shift_0/out bias_nstack
Xsg13cmos5l_inv_2_1 level_shift_1/in_n sink_ena[2] dvdd dvss sg13cmos5l_inv_2
Xbias_nstack_2[0] sink_ibias bias_nstack_3/shld2 bias_nstack_3/shld3 sub bias_nstack_2[2]/a_1030_2157#
+ nbias ncasc level_shift_4/out bias_nstack
Xbias_nstack_2[1] sink_ibias bias_nstack_3/shld2 bias_nstack_3/shld3 sub bias_nstack_2[2]/a_1030_2157#
+ nbias ncasc level_shift_4/out bias_nstack
Xbias_nstack_2[2] sink_ibias bias_nstack_3/shld2 bias_nstack_3/shld3 sub bias_nstack_2[2]/a_1030_2157#
+ nbias ncasc level_shift_4/out bias_nstack
Xbias_nstack_3 sink_ibias bias_nstack_3/shld2 bias_nstack_3/shld3 sub bias_nstack_3/a_1030_2157#
+ nbias ncasc level_shift_1/out bias_nstack
Xsg13cmos5l_inv_2_4 level_shift_4/in_n sink_ena[0] dvdd dvss sg13cmos5l_inv_2
Xsg13cmos5l_antennanp_0 sink_ena[1] dvdd dvss sg13cmos5l_antennanp
Xsg13cmos5l_antennanp_1 sink_ena[2] dvdd dvss sg13cmos5l_antennanp
Xsg13cmos5l_antennanp_4 sink_ena[0] dvdd dvss sg13cmos5l_antennanp
Xlevel_shift_0 level_shift_0/in_n sink_ena[1] level_shift_0/out sub avdd level_shift
Xlevel_shift_1 level_shift_1/in_n sink_ena[2] level_shift_1/out sub avdd level_shift
Xsg13cmos5l_decap_4_0 dvdd dvss sg13cmos5l_decap_4
Xsg13cmos5l_decap_4_1 dvdd dvss sg13cmos5l_decap_4
Xlevel_shift_4 level_shift_4/in_n sink_ena[0] level_shift_4/out sub avdd level_shift
Xsg13cmos5l_decap_4_2 dvdd dvss sg13cmos5l_decap_4
.ends

.subckt sg13_hv_pmos_7A8CUW D0 S0 G0 D1 S1 G1 D2 S2 G2 D3 S3 G3 D4 S4 G4 D5 S5 G5
+ D6 S6 G6 D7 S7 G7 D8 S8 G8 D9 S9 G9 D10 S10 G10 D11 S11 G11 w_n1771_n224#
X0 S6 G6 D6 w_n1771_n224# sg13_hv_pmos ad=0.34p pd=2.68u as=0.34p ps=2.68u w=1u l=0.5u
X1 S8 G8 D8 w_n1771_n224# sg13_hv_pmos ad=0.34p pd=2.68u as=0.34p ps=2.68u w=1u l=0.5u
X2 D1 G1 S1 w_n1771_n224# sg13_hv_pmos ad=0.34p pd=2.68u as=0.34p ps=2.68u w=1u l=0.5u
X3 S0 G0 D0 w_n1771_n224# sg13_hv_pmos ad=0.34p pd=2.68u as=0.34p ps=2.68u w=1u l=0.5u
X4 D5 G5 S5 w_n1771_n224# sg13_hv_pmos ad=0.34p pd=2.68u as=0.34p ps=2.68u w=1u l=0.5u
X5 D9 G9 S9 w_n1771_n224# sg13_hv_pmos ad=0.34p pd=2.68u as=0.34p ps=2.68u w=1u l=0.5u
X6 S4 G4 D4 w_n1771_n224# sg13_hv_pmos ad=0.34p pd=2.68u as=0.34p ps=2.68u w=1u l=0.5u
X7 D3 G3 S3 w_n1771_n224# sg13_hv_pmos ad=0.34p pd=2.68u as=0.34p ps=2.68u w=1u l=0.5u
X8 S10 G10 D10 w_n1771_n224# sg13_hv_pmos ad=0.34p pd=2.68u as=0.34p ps=2.68u w=1u l=0.5u
X9 D11 G11 S11 w_n1771_n224# sg13_hv_pmos ad=0.34p pd=2.68u as=0.34p ps=2.68u w=1u l=0.5u
X10 S2 G2 D2 w_n1771_n224# sg13_hv_pmos ad=0.34p pd=2.68u as=0.34p ps=2.68u w=1u l=0.5u
X11 D7 G7 S7 w_n1771_n224# sg13_hv_pmos ad=0.34p pd=2.68u as=0.34p ps=2.68u w=1u l=0.5u
.ends

.subckt sg13_hv_nmos_XVVFQX D0_0 S0_0 G0_0 D0_1 S0_1 G0_1 D1_0 S1_0 G1_0 D1_1 S1_1
+ G1_1 D2_0 S2_0 G2_0 D2_1 S2_1 G2_1 D3_0 S3_0 G3_0 D3_1 S3_1 G3_1 D4_0 S4_0 G4_0
+ D4_1 S4_1 G4_1 D5_0 S5_0 G5_0 D5_1 S5_1 G5_1 D6_0 S6_0 G6_0 D6_1 S6_1 G6_1 D7_0
+ S7_0 G7_0 D7_1 S7_1 G7_1 D8_0 S8_0 G8_0 D8_1 S8_1 G8_1 D9_0 S9_0 G9_0 D9_1 S9_1
+ G9_1 sub
X0 D7_1 G7_1 S7_1 sub sg13_hv_nmos ad=0.34p pd=2.68u as=0.34p ps=2.68u w=1u l=1u
X1 S2_0 G2_0 D2_0 sub sg13_hv_nmos ad=0.34p pd=2.68u as=0.34p ps=2.68u w=1u l=1u
X2 D1_0 G1_0 S1_0 sub sg13_hv_nmos ad=0.34p pd=2.68u as=0.34p ps=2.68u w=1u l=1u
X3 S6_0 G6_0 D6_0 sub sg13_hv_nmos ad=0.34p pd=2.68u as=0.34p ps=2.68u w=1u l=1u
X4 D1_1 G1_1 S1_1 sub sg13_hv_nmos ad=0.34p pd=2.68u as=0.34p ps=2.68u w=1u l=1u
X5 D9_1 G9_1 S9_1 sub sg13_hv_nmos ad=0.34p pd=2.68u as=0.34p ps=2.68u w=1u l=1u
X6 S0_0 G0_0 D0_0 sub sg13_hv_nmos ad=0.34p pd=2.68u as=0.34p ps=2.68u w=1u l=1u
X7 D7_0 G7_0 S7_0 sub sg13_hv_nmos ad=0.34p pd=2.68u as=0.34p ps=2.68u w=1u l=1u
X8 S6_1 G6_1 D6_1 sub sg13_hv_nmos ad=0.34p pd=2.68u as=0.34p ps=2.68u w=1u l=1u
X9 D3_1 G3_1 S3_1 sub sg13_hv_nmos ad=0.34p pd=2.68u as=0.34p ps=2.68u w=1u l=1u
X10 S8_0 G8_0 D8_0 sub sg13_hv_nmos ad=0.34p pd=2.68u as=0.34p ps=2.68u w=1u l=1u
X11 S2_1 G2_1 D2_1 sub sg13_hv_nmos ad=0.34p pd=2.68u as=0.34p ps=2.68u w=1u l=1u
X12 D9_0 G9_0 S9_0 sub sg13_hv_nmos ad=0.34p pd=2.68u as=0.34p ps=2.68u w=1u l=1u
X13 S8_1 G8_1 D8_1 sub sg13_hv_nmos ad=0.34p pd=2.68u as=0.34p ps=2.68u w=1u l=1u
X14 D5_0 G5_0 S5_0 sub sg13_hv_nmos ad=0.34p pd=2.68u as=0.34p ps=2.68u w=1u l=1u
X15 S4_1 G4_1 D4_1 sub sg13_hv_nmos ad=0.34p pd=2.68u as=0.34p ps=2.68u w=1u l=1u
X16 S4_0 G4_0 D4_0 sub sg13_hv_nmos ad=0.34p pd=2.68u as=0.34p ps=2.68u w=1u l=1u
X17 D3_0 G3_0 S3_0 sub sg13_hv_nmos ad=0.34p pd=2.68u as=0.34p ps=2.68u w=1u l=1u
X18 S0_1 G0_1 D0_1 sub sg13_hv_nmos ad=0.34p pd=2.68u as=0.34p ps=2.68u w=1u l=1u
X19 D5_1 G5_1 S5_1 sub sg13_hv_nmos ad=0.34p pd=2.68u as=0.34p ps=2.68u w=1u l=1u
.ends

.subckt sg13_hv_nmos_666RAL D0 G0 S1 G1 D2 G2 S3 G3 D4 G4 S5 G5 D6 G6 S7 G7 D8 G8
+ S9 G9 D10 G10 S11 G11 D12 G12 S13 G13 D14 G14 S15 G15 D16 G16 S17 G17 D18 G18 S19
+ G19 a_1722_n100# sub
X0 D4 G3 S3 sub sg13_hv_nmos ad=0.19p pd=1.38u as=0.19p ps=1.38u w=1u l=0.5u
X1 S19 G18 D18 sub sg13_hv_nmos ad=0.19p pd=1.38u as=0.19p ps=1.38u w=1u l=0.5u
X2 S5 G4 D4 sub sg13_hv_nmos ad=0.19p pd=1.38u as=0.19p ps=1.38u w=1u l=0.5u
X3 S11 G10 D10 sub sg13_hv_nmos ad=0.19p pd=1.38u as=0.19p ps=1.38u w=1u l=0.5u
X4 D14 G13 S13 sub sg13_hv_nmos ad=0.19p pd=1.38u as=0.19p ps=1.38u w=1u l=0.5u
X5 a_1722_n100# G19 S19 sub sg13_hv_nmos ad=0.34p pd=2.68u as=0.19p ps=1.38u w=1u l=0.5u
X6 S3 G2 D2 sub sg13_hv_nmos ad=0.19p pd=1.38u as=0.19p ps=1.38u w=1u l=0.5u
X7 D10 G9 S9 sub sg13_hv_nmos ad=0.19p pd=1.38u as=0.19p ps=1.38u w=1u l=0.5u
X8 S15 G14 D14 sub sg13_hv_nmos ad=0.19p pd=1.38u as=0.19p ps=1.38u w=1u l=0.5u
X9 D2 G1 S1 sub sg13_hv_nmos ad=0.19p pd=1.38u as=0.19p ps=1.38u w=1u l=0.5u
X10 D8 G7 S7 sub sg13_hv_nmos ad=0.19p pd=1.38u as=0.19p ps=1.38u w=1u l=0.5u
X11 S9 G8 D8 sub sg13_hv_nmos ad=0.19p pd=1.38u as=0.19p ps=1.38u w=1u l=0.5u
X12 D16 G15 S15 sub sg13_hv_nmos ad=0.19p pd=1.38u as=0.19p ps=1.38u w=1u l=0.5u
X13 S17 G16 D16 sub sg13_hv_nmos ad=0.19p pd=1.38u as=0.19p ps=1.38u w=1u l=0.5u
X14 S1 G0 D0 sub sg13_hv_nmos ad=0.19p pd=1.38u as=0.34p ps=2.68u w=1u l=0.5u
X15 S7 G6 D6 sub sg13_hv_nmos ad=0.19p pd=1.38u as=0.19p ps=1.38u w=1u l=0.5u
X16 D18 G17 S17 sub sg13_hv_nmos ad=0.19p pd=1.38u as=0.19p ps=1.38u w=1u l=0.5u
X17 S13 G12 D12 sub sg13_hv_nmos ad=0.19p pd=1.38u as=0.19p ps=1.38u w=1u l=0.5u
X18 D6 G5 S5 sub sg13_hv_nmos ad=0.19p pd=1.38u as=0.19p ps=1.38u w=1u l=0.5u
X19 D12 G11 S11 sub sg13_hv_nmos ad=0.19p pd=1.38u as=0.19p ps=1.38u w=1u l=0.5u
.ends

.subckt bias_amp_large avdd out inn inp nbias ena avss
Xsg13_hv_pmos_7A8CUW_0 avdd avdd avdd XM6/S7 avdd XM6/S7 avdd out XM6/S7 XM6/S7 avdd
+ XM6/S7 avdd out XM6/S7 XM6/S7 avdd XM6/S7 avdd out XM6/S7 XM6/S7 avdd XM6/S7 avdd
+ out XM6/S7 XM6/S7 avdd XM6/S7 avdd out XM6/S7 avdd avdd avdd avdd sg13_hv_pmos_7A8CUW
XXM1 avss XM1/S8_1 nbias avss XM1/S8_1 nbias XM1/S8_1 avss nbias XM1/S8_1 avss nbias
+ avss XM1/S8_1 nbias avss XM1/S8_1 nbias XM1/S8_1 avss nbias XM1/S8_1 avss nbias
+ avss XM1/S8_1 nbias avss XM1/S8_1 nbias XM1/S8_1 avss nbias XM1/S8_1 avss nbias
+ avss XM1/S8_1 nbias avss XM1/S8_1 nbias XM1/S8_1 avss nbias XM1/S8_1 avss nbias
+ avss XM1/S8_1 nbias avss XM1/S8_1 nbias XM1/S8_1 avss nbias XM1/S8_1 avss nbias
+ avss sg13_hv_nmos_XVVFQX
XXM2 avdd avdd avdd out avdd XM6/S7 avdd XM6/S7 XM6/S7 out avdd XM6/S7 avdd XM6/S7
+ XM6/S7 out avdd XM6/S7 avdd XM6/S7 XM6/S7 out avdd XM6/S7 avdd XM6/S7 XM6/S7 out
+ avdd XM6/S7 avdd XM6/S7 XM6/S7 avdd avdd avdd avdd sg13_hv_pmos_7A8CUW
XXM5 XM6/D8 inp XM6/S7 inp XM6/D8 inn out inn XM6/D8 inp XM6/S7 inp XM6/D8 inn out
+ inn XM6/D8 inp XM6/S7 inp XM6/D8 inn out inn XM6/D8 inp XM6/S7 inp XM6/D8 inn out
+ inn XM6/D8 inp XM6/S7 inp XM6/D8 inn out inn XM6/D8 avss sg13_hv_nmos_666RAL
XXM6 XM6/D8 inn out inn XM6/D8 inp XM6/S7 inp XM6/D8 inn out inn XM6/D8 inp XM6/S7
+ inp XM6/D8 inn out inn XM6/D8 inp XM6/S7 inp XM6/D8 inn out inn XM6/D8 inp XM6/S7
+ inp XM6/D8 inn out inn XM6/D8 inp XM6/S7 inp XM6/D8 avss sg13_hv_nmos_666RAL
Xsg13_hv_nmos_666RAL_0 XM1/S8_1 ena XM6/D8 ena XM1/S8_1 ena XM6/D8 ena XM1/S8_1 ena
+ XM6/D8 ena XM1/S8_1 ena XM6/D8 ena XM1/S8_1 ena XM6/D8 ena XM1/S8_1 ena XM6/D8 ena
+ XM1/S8_1 ena XM6/D8 ena XM1/S8_1 ena XM6/D8 ena XM1/S8_1 ena XM6/D8 ena XM1/S8_1
+ ena XM6/D8 ena XM1/S8_1 avss sg13_hv_nmos_666RAL
.ends

.subckt bias_pset pcasc enb itail shld3 avdd pbias
Xsg13_hv_pmos_KGSGVN_0[0] pcasc itail enb avdd sg13_hv_pmos_KGSGVN
Xsg13_hv_pmos_KGSGVN_0[1] pcasc itail enb avdd sg13_hv_pmos_KGSGVN
Xsg13_hv_pmos_KGSGVN_0[2] pcasc itail enb avdd sg13_hv_pmos_KGSGVN
Xsg13_hv_pmos_KGSGVN_0[3] pcasc pbias pcasc avdd sg13_hv_pmos_KGSGVN
Xsg13_hv_pmos_KGSGVN_0[4] pcasc pbias pcasc avdd sg13_hv_pmos_KGSGVN
Xsg13_hv_pmos_KGSGVN_0[5] pcasc pbias pcasc avdd sg13_hv_pmos_KGSGVN
Xsg13_hv_pmos_KGSGVN_0[6] avdd pbias pbias avdd sg13_hv_pmos_KGSGVN
Xsg13_hv_pmos_KGSGVN_0[7] avdd pbias pbias avdd sg13_hv_pmos_KGSGVN
Xsg13_hv_pmos_KGSGVN_0[8] avdd pbias pbias avdd sg13_hv_pmos_KGSGVN
.ends

.subckt rhigh_GJN3VD B R1_0 R2_0 R1_1 R2_1 R1_2 R2_2 R1_3 R2_3 R1_4 R2_4 R1_5 R2_5
+ R1_6 R2_6 R1_7 R2_7
X0 R1_5 R2_5 B rhigh l=17.32u w=0.5u
X1 R1_6 R2_6 B rhigh l=17.32u w=0.5u
X2 R1_3 R2_3 B rhigh l=17.32u w=0.5u
X3 R1_2 R2_2 B rhigh l=17.32u w=0.5u
X4 R1_7 R2_7 B rhigh l=17.32u w=0.5u
X5 R1_4 R2_4 B rhigh l=17.32u w=0.5u
X6 R1_1 R2_1 B rhigh l=17.32u w=0.5u
X7 R1_0 R2_0 B rhigh l=17.32u w=0.5u
.ends

.subckt bias_pset2 pbias pcasc enb itail shld2 shld3 avdd
Xsg13_hv_pmos_KGSGVN_0[0] pcasc itail enb avdd sg13_hv_pmos_KGSGVN
Xsg13_hv_pmos_KGSGVN_0[1] pcasc itail enb avdd sg13_hv_pmos_KGSGVN
Xsg13_hv_pmos_KGSGVN_0[2] pcasc itail enb avdd sg13_hv_pmos_KGSGVN
Xsg13_hv_pmos_KGSGVN_0[3] pcasc pbias pcasc avdd sg13_hv_pmos_KGSGVN
Xsg13_hv_pmos_KGSGVN_0[4] pcasc pbias pcasc avdd sg13_hv_pmos_KGSGVN
Xsg13_hv_pmos_KGSGVN_0[5] pcasc pbias pcasc avdd sg13_hv_pmos_KGSGVN
Xsg13_hv_pmos_KGSGVN_0[6] avdd pbias pbias avdd sg13_hv_pmos_KGSGVN
Xsg13_hv_pmos_KGSGVN_0[7] avdd pbias pbias avdd sg13_hv_pmos_KGSGVN
Xsg13_hv_pmos_KGSGVN_0[8] avdd pbias pbias avdd sg13_hv_pmos_KGSGVN
.ends

.subckt capacitor_UPRECB c1 c2
X0 c1 c2 cap_cmomf mm_ok=1 subblock=0 mmax=4 mmin=1 l=11u w=16u
.ends

.subckt rhigh_AFSZTU B R1_0 R2_0 R1_1 R2_1 R1_2 R2_2 R1_3 R2_3 R1_4 R2_4 R1_5 R2_5
+ R1_6 R2_6 R1_7 R2_7 R1_8 R2_8 R1_9 R2_9 R1_10 R2_10 R1_11 R2_11 R1_12 R2_12 R1_13
+ R2_13 R1_14 R2_14 R1_15 R2_15 R1_16 R2_16 R1_17 R2_17 R1_18 R2_18 R1_19 R2_19
X0 R1_18 R2_18 B rhigh l=16.86u w=0.5u
X1 R1_19 R2_19 B rhigh l=16.86u w=0.5u
X2 R1_4 R2_4 B rhigh l=16.86u w=0.5u
X3 R1_3 R2_3 B rhigh l=16.86u w=0.5u
X4 R1_2 R2_2 B rhigh l=16.86u w=0.5u
X5 R1_11 R2_11 B rhigh l=16.86u w=0.5u
X6 R1_12 R2_12 B rhigh l=16.86u w=0.5u
X7 R1_0 R2_0 B rhigh l=16.86u w=0.5u
X8 R1_1 R2_1 B rhigh l=16.86u w=0.5u
X9 R1_9 R2_9 B rhigh l=16.86u w=0.5u
X10 R1_8 R2_8 B rhigh l=16.86u w=0.5u
X11 R1_13 R2_13 B rhigh l=16.86u w=0.5u
X12 R1_14 R2_14 B rhigh l=16.86u w=0.5u
X13 R1_10 R2_10 B rhigh l=16.86u w=0.5u
X14 R1_15 R2_15 B rhigh l=16.86u w=0.5u
X15 R1_16 R2_16 B rhigh l=16.86u w=0.5u
X16 R1_17 R2_17 B rhigh l=16.86u w=0.5u
X17 R1_7 R2_7 B rhigh l=16.86u w=0.5u
X18 R1_5 R2_5 B rhigh l=16.86u w=0.5u
X19 R1_6 R2_6 B rhigh l=16.86u w=0.5u
.ends

.subckt bias_nset itail shld2 shld3 a_1043_n1378# avss nbias ncasc ena
Xsg13_hv_nmos_2RYP69_0[0] ncasc itail ena avss sg13_hv_nmos_2RYP69
Xsg13_hv_nmos_2RYP69_0[1] ncasc itail ena avss sg13_hv_nmos_2RYP69
Xsg13_hv_nmos_2RYP69_0[2] ncasc itail ena avss sg13_hv_nmos_2RYP69
Xsg13_hv_nmos_2RYP69_0[3] ncasc nbias ncasc avss sg13_hv_nmos_2RYP69
Xsg13_hv_nmos_2RYP69_0[4] ncasc nbias ncasc avss sg13_hv_nmos_2RYP69
Xsg13_hv_nmos_2RYP69_0[5] ncasc nbias ncasc avss sg13_hv_nmos_2RYP69
Xsg13_hv_nmos_2RYP69_0[6] avss nbias nbias avss sg13_hv_nmos_2RYP69
Xsg13_hv_nmos_2RYP69_0[7] avss nbias nbias avss sg13_hv_nmos_2RYP69
Xsg13_hv_nmos_2RYP69_0[8] avss nbias nbias avss sg13_hv_nmos_2RYP69
.ends

.subckt sg13cmos5l_nand2_1 Y A B VDD VSS
X0 a_154_118# B VSS VSS sg13_lv_nmos ad=0.1406p pd=1.12u as=0.2516p ps=2.16u w=0.74u l=0.13u
X1 Y A a_154_118# VSS sg13_lv_nmos ad=0.2516p pd=2.16u as=0.1406p ps=1.12u w=0.74u l=0.13u
X2 Y B VDD VDD sg13_lv_pmos ad=0.2128p pd=1.5u as=0.3808p ps=2.92u w=1.12u l=0.13u
X3 VDD A Y VDD sg13_lv_pmos ad=0.3808p pd=2.92u as=0.2128p ps=1.5u w=1.12u l=0.13u
.ends

.subckt sg13cmos5l_nor2_1 Y A B VDD VSS
X0 Y A VSS VSS sg13_lv_nmos ad=0.1406p pd=1.12u as=0.2516p ps=2.16u w=0.74u l=0.13u
X1 VSS B Y VSS sg13_lv_nmos ad=0.2516p pd=2.16u as=0.1406p ps=1.12u w=0.74u l=0.13u
X2 a_170_412# A VDD VDD sg13_lv_pmos ad=0.1176p pd=1.33u as=0.4032p ps=2.96u w=1.12u l=0.13u
X3 Y B a_170_412# VDD sg13_lv_pmos ad=0.3808p pd=2.92u as=0.1176p ps=1.33u w=1.12u l=0.13u
.ends

.subckt bias_generator_fe_v2 ena vbg src_test0 ena_src_test0 ref_in nbias pcasc pbias
+ snk_test0 ena_snk_test0 ncasc ref_sel_fine ref_sel_coarse x13[9]/shld2 ref_sel_vbg
+ x4[1]/a_1030_2157# dvdd x3/avdd avss dvss
Xbias_nstack_0 bias_pset_1/itail avss avss avss bias_nstack_0/a_1030_2157# nbias ncasc
+ ena_3v3 bias_nstack
Xsg13cmos5l_inv_2_0 level_shift_4/in_n level_shift_4/in_p dvdd dvss sg13cmos5l_inv_2
Xbias_nstack_1[0] XR4/R2_0 avss avss avss bias_nstack_1[1]/a_1030_2157# nbias ncasc
+ avss bias_nstack
Xbias_nstack_1[1] XR4/R2_0 avss avss avss bias_nstack_1[1]/a_1030_2157# nbias ncasc
+ avss bias_nstack
Xsg13cmos5l_inv_2_1 x12/in_n ena_snk_test0 dvdd dvss sg13cmos5l_inv_2
Xx3 x3/avdd pbias vbg C2/c2 nbias ena_vbg_3v3 avss bias_amp_large
Xsg13cmos5l_inv_2_2 level_shift_0/in_n ena dvdd dvss sg13cmos5l_inv_2
Xx4[0] snk_test0 avss avss avss x4[1]/a_1030_2157# nbias ncasc ena_test0_3v3 bias_nstack
Xx4[1] snk_test0 avss avss avss x4[1]/a_1030_2157# nbias ncasc ena_test0_3v3 bias_nstack
Xsg13cmos5l_inv_2_3 level_shift_6/in_p ena_src_test0 dvdd dvss sg13cmos5l_inv_2
Xbias_pset_1 pcasc ena_vbg_3v3 bias_pset_1/itail x3/avdd x3/avdd pbias bias_pset
Xsg13cmos5l_inv_2_4 level_shift_2/in_n ref_sel_vbg dvdd dvss sg13cmos5l_inv_2
Xsg13cmos5l_inv_2_5 level_shift_3/in_n level_shift_3/in_p dvdd dvss sg13cmos5l_inv_2
Xsg13cmos5l_inv_2_6 level_shift_5/in_n level_shift_5/in_p dvdd dvss sg13cmos5l_inv_2
Xsg13cmos5l_inv_2_7 sg13cmos5l_inv_2_7/Y ref_sel_fine dvdd dvss sg13cmos5l_inv_2
XXR4 avss XR4/R1_1 XR4/R2_0 XR4/R1_1 XR4/R2_2 XR4/R1_3 XR4/R2_2 XR4/R1_3 XR4/R2_4
+ XR4/R1_5 XR4/R2_4 XR4/R1_5 XR4/R2_6 XR4/R1_7 XR4/R2_6 XR4/R1_7 ref_in rhigh_GJN3VD
Xsg13cmos5l_antennanp_0 ref_sel_coarse dvdd dvss sg13cmos5l_antennanp
Xbias_pstack_0[0] x3/avdd C2/c2 x13[9]/shld2 x3/avdd enb_std_3v3 pbias pcasc bias_pstack
Xbias_pstack_0[1] x3/avdd C2/c2 x13[9]/shld2 x3/avdd enb_std_3v3 pbias pcasc bias_pstack
Xbias_pstack_0[2] x3/avdd C2/c2 x13[9]/shld2 x3/avdd enb_std_3v3 pbias pcasc bias_pstack
Xsg13cmos5l_antennanp_1 ena_snk_test0 dvdd dvss sg13cmos5l_antennanp
Xbias_pstack_1 x3/avdd C2/c2 x13[9]/shld2 x3/avdd enb_coarse_3v3 pbias pcasc bias_pstack
Xsg13cmos5l_antennanp_2 ena dvdd dvss sg13cmos5l_antennanp
Xsg13cmos5l_antennanp_3 ena_src_test0 dvdd dvss sg13cmos5l_antennanp
Xbias_pstack_2[0] x3/avdd src_test0 x13[9]/shld2 x3/avdd level_shift_6/out pbias pcasc
+ bias_pstack
Xbias_pstack_2[1] x3/avdd src_test0 x13[9]/shld2 x3/avdd level_shift_6/out pbias pcasc
+ bias_pstack
Xbias_pstack_3[0] x3/avdd C2/c2 pbias x3/avdd x3/avdd bias_pset2_0/pbias pcasc bias_pstack
Xbias_pstack_3[1] x3/avdd C2/c2 pbias x3/avdd x3/avdd bias_pset2_0/pbias pcasc bias_pstack
Xsg13cmos5l_antennanp_4 ref_sel_vbg dvdd dvss sg13cmos5l_antennanp
Xbias_pset2_0 bias_pset2_0/pbias pcasc enb_vbg_3v3 bias_pset_1/itail pbias x3/avdd
+ x3/avdd bias_pset2
Xsg13cmos5l_antennanp_5 ref_sel_fine dvdd dvss sg13cmos5l_antennanp
XC2 pbias C2/c2 capacitor_UPRECB
Xlevel_shift_0 level_shift_0/in_n ena ena_3v3 avss x3/avdd level_shift
Xlevel_shift_1 ref_sel_vbg level_shift_2/in_n enb_vbg_3v3 avss x3/avdd level_shift
Xlevel_shift_2 level_shift_2/in_n ref_sel_vbg ena_vbg_3v3 avss x3/avdd level_shift
Xsg13cmos5l_decap_4_0 dvdd dvss sg13cmos5l_decap_4
Xrhigh_AFSZTU_0 avss C2/c2 rhigh_AFSZTU_0/R2_1 rhigh_AFSZTU_0/R1_2 rhigh_AFSZTU_0/R2_1
+ rhigh_AFSZTU_0/R1_2 rhigh_AFSZTU_0/R2_3 rhigh_AFSZTU_0/R1_4 rhigh_AFSZTU_0/R2_3
+ rhigh_AFSZTU_0/R1_4 rhigh_AFSZTU_0/R2_5 rhigh_AFSZTU_0/R1_6 rhigh_AFSZTU_0/R2_5
+ rhigh_AFSZTU_0/R1_6 rhigh_AFSZTU_0/R2_7 rhigh_AFSZTU_0/R1_8 rhigh_AFSZTU_0/R2_7
+ rhigh_AFSZTU_0/R1_8 rhigh_AFSZTU_0/R2_9 rhigh_AFSZTU_0/R1_9 rhigh_AFSZTU_0/R2_9
+ rhigh_AFSZTU_0/R1_9 rhigh_AFSZTU_0/R2_11 rhigh_AFSZTU_0/R1_12 rhigh_AFSZTU_0/R2_11
+ rhigh_AFSZTU_0/R1_12 rhigh_AFSZTU_0/R2_13 rhigh_AFSZTU_0/R1_14 rhigh_AFSZTU_0/R2_13
+ rhigh_AFSZTU_0/R1_14 rhigh_AFSZTU_0/R2_15 rhigh_AFSZTU_0/R1_16 rhigh_AFSZTU_0/R2_15
+ rhigh_AFSZTU_0/R1_16 rhigh_AFSZTU_0/R2_17 rhigh_AFSZTU_0/R1_18 rhigh_AFSZTU_0/R2_17
+ rhigh_AFSZTU_0/R1_18 rhigh_AFSZTU_0/R2_19 avss rhigh_AFSZTU_0/R2_19 rhigh_AFSZTU
Xsg13cmos5l_decap_4_1 dvdd dvss sg13cmos5l_decap_4
Xlevel_shift_3 level_shift_3/in_n level_shift_3/in_p enb_coarse_3v3 avss x3/avdd level_shift
Xx12 x12/in_n ena_snk_test0 ena_test0_3v3 avss x3/avdd level_shift
Xlevel_shift_4 level_shift_4/in_n level_shift_4/in_p enb_std_3v3 avss x3/avdd level_shift
Xbias_nset_0[0] XR4/R2_0 avss avss avss avss nbias ncasc ena_3v3 bias_nset
Xbias_nset_0[1] XR4/R2_0 avss avss avss avss nbias ncasc ena_3v3 bias_nset
Xbias_nset_0[2] XR4/R2_0 avss avss avss avss nbias ncasc ena_3v3 bias_nset
Xbias_nset_0[3] XR4/R2_0 avss avss avss avss nbias ncasc ena_3v3 bias_nset
Xbias_nset_0[4] XR4/R2_0 avss avss avss avss nbias ncasc ena_3v3 bias_nset
Xbias_nset_0[5] XR4/R2_0 avss avss avss avss nbias ncasc ena_3v3 bias_nset
Xbias_nset_0[6] XR4/R2_0 avss avss avss avss nbias ncasc ena_3v3 bias_nset
Xbias_nset_0[7] XR4/R2_0 avss avss avss avss nbias ncasc ena_3v3 bias_nset
Xbias_nset_0[8] XR4/R2_0 avss avss avss avss nbias ncasc ena_3v3 bias_nset
Xbias_nset_0[9] XR4/R2_0 avss avss avss avss nbias ncasc ena_3v3 bias_nset
Xbias_nset_0[10] XR4/R2_0 avss avss avss avss nbias ncasc ena_3v3 bias_nset
Xbias_nset_0[11] XR4/R2_0 avss avss avss avss nbias ncasc ena_3v3 bias_nset
Xbias_nset_0[12] XR4/R2_0 avss avss avss avss nbias ncasc ena_3v3 bias_nset
Xbias_nset_0[13] XR4/R2_0 avss avss avss avss nbias ncasc ena_3v3 bias_nset
Xbias_nset_0[14] XR4/R2_0 avss avss avss avss nbias ncasc ena_3v3 bias_nset
Xbias_nset_0[15] XR4/R2_0 avss avss avss avss nbias ncasc ena_3v3 bias_nset
Xsg13cmos5l_decap_4_2 dvdd dvss sg13cmos5l_decap_4
Xsg13cmos5l_nand2_1_0 level_shift_4/in_p sg13cmos5l_nand2_1_3/Y ref_sel_vbg dvdd dvss
+ sg13cmos5l_nand2_1
Xx13[0] x3/avdd C2/c2 x13[9]/shld2 x3/avdd enb_fine_3v3 pbias pcasc bias_pstack
Xx13[1] x3/avdd C2/c2 x13[9]/shld2 x3/avdd enb_fine_3v3 pbias pcasc bias_pstack
Xx13[2] x3/avdd C2/c2 x13[9]/shld2 x3/avdd enb_fine_3v3 pbias pcasc bias_pstack
Xx13[3] x3/avdd C2/c2 x13[9]/shld2 x3/avdd enb_fine_3v3 pbias pcasc bias_pstack
Xx13[4] x3/avdd C2/c2 x13[9]/shld2 x3/avdd enb_fine_3v3 pbias pcasc bias_pstack
Xx13[5] x3/avdd C2/c2 x13[9]/shld2 x3/avdd enb_fine_3v3 pbias pcasc bias_pstack
Xx13[6] x3/avdd C2/c2 x13[9]/shld2 x3/avdd enb_fine_3v3 pbias pcasc bias_pstack
Xx13[7] x3/avdd C2/c2 x13[9]/shld2 x3/avdd enb_fine_3v3 pbias pcasc bias_pstack
Xx13[8] x3/avdd C2/c2 x13[9]/shld2 x3/avdd enb_fine_3v3 pbias pcasc bias_pstack
Xx13[9] x3/avdd C2/c2 x13[9]/shld2 x3/avdd enb_fine_3v3 pbias pcasc bias_pstack
Xx13[10] x3/avdd C2/c2 x13[9]/shld2 x3/avdd enb_fine_3v3 pbias pcasc bias_pstack
Xx13[11] x3/avdd C2/c2 x13[9]/shld2 x3/avdd enb_fine_3v3 pbias pcasc bias_pstack
Xx13[12] x3/avdd C2/c2 x13[9]/shld2 x3/avdd enb_fine_3v3 pbias pcasc bias_pstack
Xx13[13] x3/avdd C2/c2 x13[9]/shld2 x3/avdd enb_fine_3v3 pbias pcasc bias_pstack
Xx13[14] x3/avdd C2/c2 x13[9]/shld2 x3/avdd enb_fine_3v3 pbias pcasc bias_pstack
Xx13[15] x3/avdd C2/c2 x13[9]/shld2 x3/avdd enb_fine_3v3 pbias pcasc bias_pstack
Xlevel_shift_5 level_shift_5/in_n level_shift_5/in_p enb_fine_3v3 avss x3/avdd level_shift
Xsg13cmos5l_decap_4_3 dvdd dvss sg13cmos5l_decap_4
Xsg13cmos5l_nand2_1_1 level_shift_3/in_p sg13cmos5l_nand2_1_4/Y ref_sel_vbg dvdd dvss
+ sg13cmos5l_nand2_1
Xlevel_shift_6 ena_src_test0 level_shift_6/in_p level_shift_6/out avss x3/avdd level_shift
Xsg13cmos5l_nor2_1_1 sg13cmos5l_nor2_1_1/Y ref_sel_coarse sg13cmos5l_inv_2_7/Y dvdd
+ dvss sg13cmos5l_nor2_1
Xsg13cmos5l_decap_4_4 dvdd dvss sg13cmos5l_decap_4
Xsg13cmos5l_nand2_1_2 level_shift_5/in_p sg13cmos5l_nor2_1_1/Y ref_sel_vbg dvdd dvss
+ sg13cmos5l_nand2_1
Xsg13cmos5l_decap_4_5 dvdd dvss sg13cmos5l_decap_4
Xsg13cmos5l_nand2_1_3 sg13cmos5l_nand2_1_3/Y sg13cmos5l_inv_2_7/Y ref_sel_coarse dvdd
+ dvss sg13cmos5l_nand2_1
Xsg13cmos5l_decap_4_6 dvdd dvss sg13cmos5l_decap_4
Xsg13cmos5l_nand2_1_4 sg13cmos5l_nand2_1_4/Y ref_sel_coarse ref_sel_fine dvdd dvss
+ sg13cmos5l_nand2_1
.ends

.subckt bias_generator_ben250nm sink_ena[1] sink_ena[0] sink_ibias nbias bias_nstack_3/shld2
+ bias_nstack_3/shld3 ncasc bias_nstack_1/a_1030_2157# avdd dvdd dvss sub
Xbias_nstack_0[0] bias_nstack_0[7]/itail bias_nstack_3/shld2 bias_nstack_3/shld3 sub
+ sub nbias ncasc sub bias_nstack
Xbias_nstack_0[1] bias_nstack_0[7]/itail bias_nstack_3/shld2 bias_nstack_3/shld3 sub
+ sub nbias ncasc sub bias_nstack
Xbias_nstack_0[2] bias_nstack_0[7]/itail bias_nstack_3/shld2 bias_nstack_3/shld3 sub
+ sub nbias ncasc sub bias_nstack
Xbias_nstack_0[3] bias_nstack_0[7]/itail bias_nstack_3/shld2 bias_nstack_3/shld3 sub
+ sub nbias ncasc sub bias_nstack
Xbias_nstack_0[4] bias_nstack_0[7]/itail bias_nstack_3/shld2 bias_nstack_3/shld3 sub
+ sub nbias ncasc sub bias_nstack
Xbias_nstack_0[5] bias_nstack_0[7]/itail bias_nstack_3/shld2 bias_nstack_3/shld3 sub
+ sub nbias ncasc sub bias_nstack
Xbias_nstack_0[6] bias_nstack_0[7]/itail bias_nstack_3/shld2 bias_nstack_3/shld3 sub
+ sub nbias ncasc sub bias_nstack
Xbias_nstack_0[7] bias_nstack_0[7]/itail bias_nstack_3/shld2 bias_nstack_3/shld3 sub
+ sub nbias ncasc sub bias_nstack
Xsg13cmos5l_inv_2_0 level_shift_0/in_n sink_ena[1] dvdd dvss sg13cmos5l_inv_2
Xbias_nstack_1 sink_ibias bias_nstack_3/shld2 bias_nstack_3/shld3 sub bias_nstack_1/a_1030_2157#
+ nbias ncasc level_shift_4/out bias_nstack
Xbias_nstack_3 sink_ibias bias_nstack_3/shld2 bias_nstack_3/shld3 sub bias_nstack_3/a_1030_2157#
+ nbias ncasc level_shift_0/out bias_nstack
Xsg13cmos5l_inv_2_4 level_shift_4/in_n sink_ena[0] dvdd dvss sg13cmos5l_inv_2
Xsg13cmos5l_antennanp_0 sink_ena[1] dvdd dvss sg13cmos5l_antennanp
Xsg13cmos5l_antennanp_4 sink_ena[0] dvdd dvss sg13cmos5l_antennanp
Xlevel_shift_0 level_shift_0/in_n sink_ena[1] level_shift_0/out sub avdd level_shift
Xsg13cmos5l_decap_4_0 dvdd dvss sg13cmos5l_decap_4
Xlevel_shift_4 level_shift_4/in_n sink_ena[0] level_shift_4/out sub avdd level_shift
Xsg13cmos5l_decap_4_2 dvdd dvss sg13cmos5l_decap_4
.ends

.subckt bias_generator_be0p_v2 pcasc source_ena[4] source_ena[3] source_ena[2] source_ena[1]
+ source_ibias sub dvdd avdd bias_pstack_3/shld3 pbias bias_pstack_3/shld2 source_ena[0]
+ dvss
Xsg13cmos5l_inv_2_0 sg13cmos5l_inv_2_0/Y source_ena[1] dvdd dvss sg13cmos5l_inv_2
Xsg13cmos5l_inv_2_1 sg13cmos5l_inv_2_1/Y source_ena[2] dvdd dvss sg13cmos5l_inv_2
Xsg13cmos5l_inv_2_2 sg13cmos5l_inv_2_2/Y source_ena[3] dvdd dvss sg13cmos5l_inv_2
Xsg13cmos5l_inv_2_4 sg13cmos5l_inv_2_4/Y source_ena[4] dvdd dvss sg13cmos5l_inv_2
Xsg13cmos5l_inv_2_3 sg13cmos5l_inv_2_3/Y source_ena[0] dvdd dvss sg13cmos5l_inv_2
Xsg13cmos5l_antennanp_0 source_ena[1] dvdd dvss sg13cmos5l_antennanp
Xsg13cmos5l_antennanp_1 source_ena[2] dvdd dvss sg13cmos5l_antennanp
Xbias_pstack_0[0] avdd source_ibias bias_pstack_3/shld2 bias_pstack_3/shld3 level_shift_4[1]/out
+ pbias pcasc bias_pstack
Xbias_pstack_0[1] avdd source_ibias bias_pstack_3/shld2 bias_pstack_3/shld3 level_shift_4[1]/out
+ pbias pcasc bias_pstack
Xbias_pstack_0[2] avdd source_ibias bias_pstack_3/shld2 bias_pstack_3/shld3 level_shift_4[1]/out
+ pbias pcasc bias_pstack
Xbias_pstack_0[3] avdd source_ibias bias_pstack_3/shld2 bias_pstack_3/shld3 level_shift_4[1]/out
+ pbias pcasc bias_pstack
Xbias_pstack_0[4] avdd source_ibias bias_pstack_3/shld2 bias_pstack_3/shld3 level_shift_4[1]/out
+ pbias pcasc bias_pstack
Xbias_pstack_0[5] avdd source_ibias bias_pstack_3/shld2 bias_pstack_3/shld3 level_shift_4[1]/out
+ pbias pcasc bias_pstack
Xbias_pstack_0[6] avdd source_ibias bias_pstack_3/shld2 bias_pstack_3/shld3 level_shift_4[1]/out
+ pbias pcasc bias_pstack
Xbias_pstack_0[7] avdd source_ibias bias_pstack_3/shld2 bias_pstack_3/shld3 level_shift_4[1]/out
+ pbias pcasc bias_pstack
Xsg13cmos5l_antennanp_2 source_ena[3] dvdd dvss sg13cmos5l_antennanp
Xbias_pstack_1[0] avdd source_ibias bias_pstack_3/shld2 bias_pstack_3/shld3 level_shift_4[2]/out
+ pbias pcasc bias_pstack
Xbias_pstack_1[1] avdd source_ibias bias_pstack_3/shld2 bias_pstack_3/shld3 level_shift_4[2]/out
+ pbias pcasc bias_pstack
Xbias_pstack_1[2] avdd source_ibias bias_pstack_3/shld2 bias_pstack_3/shld3 level_shift_4[2]/out
+ pbias pcasc bias_pstack
Xbias_pstack_1[3] avdd source_ibias bias_pstack_3/shld2 bias_pstack_3/shld3 level_shift_4[2]/out
+ pbias pcasc bias_pstack
Xsg13cmos5l_antennanp_3 source_ena[0] dvdd dvss sg13cmos5l_antennanp
Xbias_pstack_2[0] avdd source_ibias bias_pstack_3/shld2 bias_pstack_3/shld3 level_shift_4[3]/out
+ pbias pcasc bias_pstack
Xbias_pstack_2[1] avdd source_ibias bias_pstack_3/shld2 bias_pstack_3/shld3 level_shift_4[3]/out
+ pbias pcasc bias_pstack
Xsg13cmos5l_antennanp_4 source_ena[4] dvdd dvss sg13cmos5l_antennanp
Xbias_pstack_4[0] avdd source_ibias bias_pstack_3/shld2 bias_pstack_3/shld3 level_shift_4[0]/out
+ pbias pcasc bias_pstack
Xbias_pstack_4[1] avdd source_ibias bias_pstack_3/shld2 bias_pstack_3/shld3 level_shift_4[0]/out
+ pbias pcasc bias_pstack
Xbias_pstack_4[2] avdd source_ibias bias_pstack_3/shld2 bias_pstack_3/shld3 level_shift_4[0]/out
+ pbias pcasc bias_pstack
Xbias_pstack_4[3] avdd source_ibias bias_pstack_3/shld2 bias_pstack_3/shld3 level_shift_4[0]/out
+ pbias pcasc bias_pstack
Xbias_pstack_4[4] avdd source_ibias bias_pstack_3/shld2 bias_pstack_3/shld3 level_shift_4[0]/out
+ pbias pcasc bias_pstack
Xbias_pstack_4[5] avdd source_ibias bias_pstack_3/shld2 bias_pstack_3/shld3 level_shift_4[0]/out
+ pbias pcasc bias_pstack
Xbias_pstack_4[6] avdd source_ibias bias_pstack_3/shld2 bias_pstack_3/shld3 level_shift_4[0]/out
+ pbias pcasc bias_pstack
Xbias_pstack_4[7] avdd source_ibias bias_pstack_3/shld2 bias_pstack_3/shld3 level_shift_4[0]/out
+ pbias pcasc bias_pstack
Xbias_pstack_4[8] avdd source_ibias bias_pstack_3/shld2 bias_pstack_3/shld3 level_shift_4[0]/out
+ pbias pcasc bias_pstack
Xbias_pstack_4[9] avdd source_ibias bias_pstack_3/shld2 bias_pstack_3/shld3 level_shift_4[0]/out
+ pbias pcasc bias_pstack
Xbias_pstack_4[10] avdd source_ibias bias_pstack_3/shld2 bias_pstack_3/shld3 level_shift_4[0]/out
+ pbias pcasc bias_pstack
Xbias_pstack_4[11] avdd source_ibias bias_pstack_3/shld2 bias_pstack_3/shld3 level_shift_4[0]/out
+ pbias pcasc bias_pstack
Xbias_pstack_4[12] avdd source_ibias bias_pstack_3/shld2 bias_pstack_3/shld3 level_shift_4[0]/out
+ pbias pcasc bias_pstack
Xbias_pstack_4[13] avdd source_ibias bias_pstack_3/shld2 bias_pstack_3/shld3 level_shift_4[0]/out
+ pbias pcasc bias_pstack
Xbias_pstack_4[14] avdd source_ibias bias_pstack_3/shld2 bias_pstack_3/shld3 level_shift_4[0]/out
+ pbias pcasc bias_pstack
Xbias_pstack_4[15] avdd source_ibias bias_pstack_3/shld2 bias_pstack_3/shld3 level_shift_4[0]/out
+ pbias pcasc bias_pstack
Xbias_pstack_3 avdd source_ibias bias_pstack_3/shld2 bias_pstack_3/shld3 bias_pstack_3/enb
+ pbias pcasc bias_pstack
Xsg13cmos5l_decap_4_0 dvdd dvss sg13cmos5l_decap_4
Xsg13cmos5l_decap_4_1 dvdd dvss sg13cmos5l_decap_4
Xlevel_shift_4[0] source_ena[4] sg13cmos5l_inv_2_4/Y level_shift_4[0]/out sub avdd
+ level_shift
Xlevel_shift_4[1] source_ena[3] sg13cmos5l_inv_2_2/Y level_shift_4[1]/out sub avdd
+ level_shift
Xlevel_shift_4[2] source_ena[2] sg13cmos5l_inv_2_1/Y level_shift_4[2]/out sub avdd
+ level_shift
Xlevel_shift_4[3] source_ena[1] sg13cmos5l_inv_2_0/Y level_shift_4[3]/out sub avdd
+ level_shift
Xlevel_shift_4[4] source_ena[0] sg13cmos5l_inv_2_3/Y bias_pstack_3/enb sub avdd level_shift
Xsg13cmos5l_decap_4_2 dvdd dvss sg13cmos5l_decap_4
Xsg13cmos5l_decap_4_3 dvdd dvss sg13cmos5l_decap_4
Xsg13cmos5l_decap_4_4 dvdd dvss sg13cmos5l_decap_4
.ends

.subckt sg13cmos5l_ocd_ip__biasgen2 ena vbg ref_sel_vbg idac1_source_ibias idac2_source[4]
+ idac2_source[3] idac2_source[2] idac2_source[1] idac2_source[0] idac2_source_ibias
+ idac1_source[0] idac1_source[1] idac1_source[2] idac1_source[3] idac1_source[4]
+ voltgen_source[4] voltgen_source[3] voltgen_source[2] voltgen_source[1] voltgen_source[0]
+ voltgen_source_ibias ref_sel_coarse ref_sel_fine bandgap_sink2_ibias bandgap_sink2[0]
+ bandgap_sink2[1] bandgap_sink1[0] bandgap_sink1[1] bandgap_sink1[2] voltgen_sink1[0]
+ voltgen_sink1[1] voltgen_sink1[2] voltgen_sink2[0] voltgen_sink2[1] voltgen_sink2[2]
+ voltgen_sink2_ibias voltgen_sink1_ibias bandgap_sink1_ibias ref_in avdd sub dvss
+ dvdd
Xbias_nstack_0[0] bias_nstack_0[4]/itail sub sub sub bias_nstack_0[4]/a_1030_2157#
+ bias_nstack_0[4]/nbias bias_nstack_0[4]/ncasc sub bias_nstack
Xbias_nstack_0[1] bias_nstack_0[4]/itail sub sub sub bias_nstack_0[4]/a_1030_2157#
+ bias_nstack_0[4]/nbias bias_nstack_0[4]/ncasc sub bias_nstack
Xbias_nstack_0[2] bias_nstack_0[4]/itail sub sub sub bias_nstack_0[4]/a_1030_2157#
+ bias_nstack_0[4]/nbias bias_nstack_0[4]/ncasc sub bias_nstack
Xbias_nstack_0[3] bias_nstack_0[4]/itail sub sub sub bias_nstack_0[4]/a_1030_2157#
+ bias_nstack_0[4]/nbias bias_nstack_0[4]/ncasc sub bias_nstack
Xbias_nstack_0[4] bias_nstack_0[4]/itail sub sub sub bias_nstack_0[4]/a_1030_2157#
+ bias_nstack_0[4]/nbias bias_nstack_0[4]/ncasc sub bias_nstack
Xbias_pstack_0[0] avdd bias_pstack_0[4]/itail avdd avdd avdd bias_pstack_0[4]/pbias
+ bias_pstack_0[4]/pcasc bias_pstack
Xbias_pstack_0[1] avdd bias_pstack_0[4]/itail avdd avdd avdd bias_pstack_0[4]/pbias
+ bias_pstack_0[4]/pcasc bias_pstack
Xbias_pstack_0[2] avdd bias_pstack_0[4]/itail avdd avdd avdd bias_pstack_0[4]/pbias
+ bias_pstack_0[4]/pcasc bias_pstack
Xbias_pstack_0[3] avdd bias_pstack_0[4]/itail avdd avdd avdd bias_pstack_0[4]/pbias
+ bias_pstack_0[4]/pcasc bias_pstack
Xbias_pstack_0[4] avdd bias_pstack_0[4]/itail avdd avdd avdd bias_pstack_0[4]/pbias
+ bias_pstack_0[4]/pcasc bias_pstack
Xbias_generator_ben1um_0 voltgen_sink2[2] voltgen_sink2[1] voltgen_sink2[0] voltgen_sink2_ibias
+ bias_nstack_0[4]/ncasc bias_generator_ben1um_0/bias_nstack_0[9]/itail sub dvdd bias_nstack_0[4]/nbias
+ sub avdd dvss sub sub bias_generator_ben1um
Xbias_generator_ben1um_1 voltgen_sink1[2] voltgen_sink1[1] voltgen_sink1[0] voltgen_sink1_ibias
+ bias_nstack_0[4]/ncasc bias_generator_ben1um_1/bias_nstack_0[9]/itail sub dvdd bias_nstack_0[4]/nbias
+ sub avdd dvss sub sub bias_generator_ben1um
Xbias_generator_ben1um_2 bandgap_sink1[2] bandgap_sink1[1] bandgap_sink1[0] bandgap_sink1_ibias
+ bias_nstack_0[4]/ncasc bias_generator_ben1um_2/bias_nstack_0[9]/itail sub dvdd bias_nstack_0[4]/nbias
+ sub avdd dvss sub sub bias_generator_ben1um
Xbias_generator_fe_v2_0 ena vbg bias_generator_fe_v2_0/src_test0 dvss ref_in bias_nstack_0[4]/nbias
+ bias_pstack_0[4]/pcasc bias_pstack_0[4]/pbias bias_generator_fe_v2_0/snk_test0 dvss
+ bias_nstack_0[4]/ncasc ref_sel_fine ref_sel_coarse avdd ref_sel_vbg sub dvdd avdd
+ sub dvss bias_generator_fe_v2
Xbias_generator_ben250nm_0 bandgap_sink2[1] bandgap_sink2[0] bandgap_sink2_ibias bias_nstack_0[4]/nbias
+ sub sub bias_nstack_0[4]/ncasc bias_nstack_0[4]/a_1030_2157# avdd dvdd dvss sub
+ bias_generator_ben250nm
Xbias_generator_be0p_v2_0 bias_pstack_0[4]/pcasc voltgen_source[4] voltgen_source[3]
+ voltgen_source[2] voltgen_source[1] voltgen_source_ibias sub dvdd avdd avdd bias_pstack_0[4]/pbias
+ avdd voltgen_source[0] dvss bias_generator_be0p_v2
Xbias_generator_be0p_v2_1 bias_pstack_0[4]/pcasc idac2_source[4] idac2_source[3] idac2_source[2]
+ idac2_source[1] idac2_source_ibias sub dvdd avdd avdd bias_pstack_0[4]/pbias avdd
+ idac2_source[0] dvss bias_generator_be0p_v2
Xbias_generator_be0p_v2_2 bias_pstack_0[4]/pcasc idac1_source[4] idac1_source[3] idac1_source[2]
+ idac1_source[1] idac1_source_ibias sub dvdd avdd avdd bias_pstack_0[4]/pbias avdd
+ idac1_source[0] dvss bias_generator_be0p_v2
.ends

* Black-box entry subcircuit for slot2_wrapper abstract view
.subckt slot2_wrapper s2_an[0] s2_an[1] s2_an_0_esd s2_an_1_esd vbias dig_in[23] dig_in[22]
+ dig_in[21] dig_in[20] dig_in[19] dig_in[18] dig_in[17] dig_in[16] dig_in[15] dig_in[14]
+ dig_in[13] dig_in[12] dig_in[11] dig_in[10] dig_in[9] dig_in[8] dig_in[7] dig_in[6]
+ dig_in[5] dig_in[4] dig_in[3] dig_in[2] dig_in[1] dig_in[0] dig_out[11] dig_out[10]
+ dig_out[9] dig_out[8] dig_out[7] dig_out[6] dig_out[5] dig_out[4] dig_out[3] dig_out[2]
+ dig_out[1] dig_out[0] ibias0 ibias1 analog_bus3 analog_bus2 analog_bus1 analog_bus0
+ vss_1v2 vdd_1v2 vss_3v3 vdd_3v3 enable clk reset
.ends

* Black-box entry subcircuit for slot6_wrapper abstract view
.subckt slot6_wrapper s6_an[0] s6_an[1] s6_an_0 s6_an_1_esd vbias dig_in[23] dig_in[22]
+ dig_in[21] dig_in[20] dig_in[19] dig_in[18] dig_in[17] dig_in[16] dig_in[15] dig_in[14]
+ dig_in[13] dig_in[12] dig_in[11] dig_in[10] dig_in[9] dig_in[8] dig_in[7] dig_in[6]
+ dig_in[5] dig_in[4] dig_in[3] dig_in[2] dig_in[1] dig_in[0] dig_out[11] dig_out[10]
+ dig_out[9] dig_out[8] dig_out[7] dig_out[6] dig_out[5] dig_out[4] dig_out[3] dig_out[2]
+ dig_out[1] dig_out[0] ibias0 ibias1 analog_bus3 analog_bus2 analog_bus1 analog_bus0
+ vss_1v2 vdd_1v2 vss_3v3 vdd_3v3 enable clk reset
.ends

* Black-box entry subcircuit for slot10_wrapper abstract view
.subckt slot10_wrapper s10_an[0] s10_an[1] s10_an[2] s10_an_0_esd s10_an_1_esd s10_an_2_esd
+ vbias dig_in[23] dig_in[22] dig_in[21] dig_in[20] dig_in[19] dig_in[18] dig_in[17]
+ dig_in[16] dig_in[15] dig_in[14] dig_in[13] dig_in[12] dig_in[11] dig_in[10] dig_in[9]
+ dig_in[8] dig_in[7] dig_in[6] dig_in[5] dig_in[4] dig_in[3] dig_in[2] dig_in[1]
+ dig_in[0] dig_out[11] dig_out[10] dig_out[9] dig_out[8] dig_out[7] dig_out[6] dig_out[5]
+ dig_out[4] dig_out[3] dig_out[2] dig_out[1] dig_out[0] ibias0 ibias1 analog_bus3
+ analog_bus2 analog_bus1 analog_bus0 vss_1v2 vdd_1v2 vss_3v3 vdd_3v3 enable clk reset
.ends

* Black-box entry subcircuit for slot14_wrapper abstract view
.subckt slot14_wrapper s14_an[0] s14_an[1] s14_an[2] s14_an_0_esd s14_an_1_esd s14_an_2_esd
+ vbias dig_in[23] dig_in[22] dig_in[21] dig_in[20] dig_in[19] dig_in[18] dig_in[17]
+ dig_in[16] dig_in[15] dig_in[14] dig_in[13] dig_in[12] dig_in[11] dig_in[10] dig_in[9]
+ dig_in[8] dig_in[7] dig_in[6] dig_in[5] dig_in[4] dig_in[3] dig_in[2] dig_in[1]
+ dig_in[0] dig_out[11] dig_out[10] dig_out[9] dig_out[8] dig_out[7] dig_out[6] dig_out[5]
+ dig_out[4] dig_out[3] dig_out[2] dig_out[1] dig_out[0] ibias0 ibias1 analog_bus3
+ analog_bus2 analog_bus1 analog_bus0 vss_1v2 vdd_1v2 vss_3v3 vdd_3v3 enable clk reset
.ends

* Black-box entry subcircuit for slot18_wrapper abstract view
.subckt slot18_wrapper s18_an[0] s18_an[1] s18_an_0_esd s18_an_1_esd vbias dig_in[23]
+ dig_in[22] dig_in[21] dig_in[20] dig_in[19] dig_in[18] dig_in[17] dig_in[16] dig_in[15]
+ dig_in[14] dig_in[13] dig_in[12] dig_in[11] dig_in[10] dig_in[9] dig_in[8] dig_in[7]
+ dig_in[6] dig_in[5] dig_in[4] dig_in[3] dig_in[2] dig_in[1] dig_in[0] dig_out[11]
+ dig_out[10] dig_out[9] dig_out[8] dig_out[7] dig_out[6] dig_out[5] dig_out[4] dig_out[3]
+ dig_out[2] dig_out[1] dig_out[0] ibias0 ibias1 analog_bus3 analog_bus2 analog_bus1
+ analog_bus0 vss_1v2 vdd_1v2 vss_3v3 vdd_3v3 enable clk reset
.ends

* Black-box entry subcircuit for slot1_wrapper abstract view
.subckt slot1_wrapper s1_an[0] s1_an[1] s1_an_0_esd vbias dig_in[23] dig_in[22] dig_in[21]
+ dig_in[20] dig_in[19] dig_in[18] dig_in[17] dig_in[16] dig_in[15] dig_in[14] dig_in[13]
+ dig_in[12] dig_in[11] dig_in[10] dig_in[9] dig_in[8] dig_in[7] dig_in[6] dig_in[5]
+ dig_in[4] dig_in[3] dig_in[2] dig_in[1] dig_in[0] dig_out[11] dig_out[10] dig_out[9]
+ dig_out[8] dig_out[7] dig_out[6] dig_out[5] dig_out[4] dig_out[3] dig_out[2] dig_out[1]
+ dig_out[0] ibias0 ibias1 analog_bus3 analog_bus2 analog_bus1 analog_bus0 vss_1v2
+ vdd_1v2 vss_3v3 vdd_3v3 enable clk reset
.ends

* Black-box entry subcircuit for slot5_wrapper abstract view
.subckt slot5_wrapper s5_an[0] s5_an[1] s5_an[2] s5_an_0_esd s5_an_1_esd vbias dig_in[23]
+ dig_in[22] dig_in[21] dig_in[20] dig_in[19] dig_in[18] dig_in[17] dig_in[16] dig_in[15]
+ dig_in[14] dig_in[13] dig_in[12] dig_in[11] dig_in[10] dig_in[9] dig_in[8] dig_in[7]
+ dig_in[6] dig_in[5] dig_in[4] dig_in[3] dig_in[2] dig_in[1] dig_in[0] dig_out[11]
+ dig_out[10] dig_out[9] dig_out[8] dig_out[7] dig_out[6] dig_out[5] dig_out[4] dig_out[3]
+ dig_out[2] dig_out[1] dig_out[0] ibias0 ibias1 analog_bus3 analog_bus2 analog_bus1
+ analog_bus0 vss_1v2 vdd_1v2 vss_3v3 vdd_3v3 enable clk reset
.ends

* Black-box entry subcircuit for slot9_wrapper abstract view
.subckt slot9_wrapper s9_an[0] s9_an[1] s9_an[2] s9_an_0_esd s9_an_1_esd vbias dig_in[23]
+ dig_in[22] dig_in[21] dig_in[20] dig_in[19] dig_in[18] dig_in[17] dig_in[16] dig_in[15]
+ dig_in[14] dig_in[13] dig_in[12] dig_in[11] dig_in[10] dig_in[9] dig_in[8] dig_in[7]
+ dig_in[6] dig_in[5] dig_in[4] dig_in[3] dig_in[2] dig_in[1] dig_in[0] dig_out[11]
+ dig_out[10] dig_out[9] dig_out[8] dig_out[7] dig_out[6] dig_out[5] dig_out[4] dig_out[3]
+ dig_out[2] dig_out[1] dig_out[0] ibias0 ibias1 analog_bus3 analog_bus2 analog_bus1
+ analog_bus0 vss_1v2 vdd_1v2 vss_3v3 vdd_3v3 enable clk reset
.ends

.subckt capacitor_KK7B53 c1 c2
X0 c1 c2 cap_cmomf mm_ok=1 subblock=0 mmax=4 mmin=1 l=23u w=8u
.ends

.subckt sg13_hv_pmos_CVGX38 D S G w_n232_n305#
X0 S G D w_n232_n305# sg13_hv_pmos ad=0.68p pd=4.68u as=0.68p ps=4.68u w=2u l=0.4u
.ends

.subckt sg13_hv_nmos_83DLAQ D S G sub
X0 S G D sub sg13_hv_nmos ad=0.34p pd=2.68u as=0.34p ps=2.68u w=1u l=0.45u
.ends

.subckt hv_inv_1 vdd X vss A
XXM1 X vdd A vdd sg13_hv_pmos_CVGX38
XXM2 vss X A vss sg13_hv_nmos_83DLAQ
.ends

.subckt sg13_hv_pmos_NNMDLU D0 S0 G0 D1 S1 G1 D2 S2 G2 D3 S3 G3 w_n292_n2006#
X0 S2 G2 D2 w_n292_n2006# sg13_hv_pmos ad=1.36p pd=8.68u as=1.36p ps=8.68u w=4u l=1u
X1 S1 G1 D1 w_n292_n2006# sg13_hv_pmos ad=1.36p pd=8.68u as=1.36p ps=8.68u w=4u l=1u
X2 S0 G0 D0 w_n292_n2006# sg13_hv_pmos ad=1.36p pd=8.68u as=1.36p ps=8.68u w=4u l=1u
X3 S3 G3 D3 w_n292_n2006# sg13_hv_pmos ad=1.36p pd=8.68u as=1.36p ps=8.68u w=4u l=1u
.ends

.subckt sg13_hv_pmos_ZKTCY2 D0 S0 G0 D1 S1 G1 D2 S2 G2 D3 S3 G3 D4 S4 G4 D5 S5 G5
+ D6 S6 G6 D7 S7 G7 D8 S8 G8 D9 S9 G9 D10 S10 G10 D11 S11 G11 D12 S12 G12 D13 S13
+ G13 D14 S14 G14 D15 S15 G15 w_n3127_n224#
X0 D7 G7 S7 w_n3127_n224# sg13_hv_pmos ad=0.34p pd=2.68u as=0.34p ps=2.68u w=1u l=1u
X1 D15 G15 S15 w_n3127_n224# sg13_hv_pmos ad=0.34p pd=2.68u as=0.34p ps=2.68u w=1u l=1u
X2 S8 G8 D8 w_n3127_n224# sg13_hv_pmos ad=0.34p pd=2.68u as=0.34p ps=2.68u w=1u l=1u
X3 S14 G14 D14 w_n3127_n224# sg13_hv_pmos ad=0.34p pd=2.68u as=0.34p ps=2.68u w=1u l=1u
X4 S0 G0 D0 w_n3127_n224# sg13_hv_pmos ad=0.34p pd=2.68u as=0.34p ps=2.68u w=1u l=1u
X5 D1 G1 S1 w_n3127_n224# sg13_hv_pmos ad=0.34p pd=2.68u as=0.34p ps=2.68u w=1u l=1u
X6 S2 G2 D2 w_n3127_n224# sg13_hv_pmos ad=0.34p pd=2.68u as=0.34p ps=2.68u w=1u l=1u
X7 D13 G13 S13 w_n3127_n224# sg13_hv_pmos ad=0.34p pd=2.68u as=0.34p ps=2.68u w=1u l=1u
X8 S10 G10 D10 w_n3127_n224# sg13_hv_pmos ad=0.34p pd=2.68u as=0.34p ps=2.68u w=1u l=1u
X9 S12 G12 D12 w_n3127_n224# sg13_hv_pmos ad=0.34p pd=2.68u as=0.34p ps=2.68u w=1u l=1u
X10 D9 G9 S9 w_n3127_n224# sg13_hv_pmos ad=0.34p pd=2.68u as=0.34p ps=2.68u w=1u l=1u
X11 D11 G11 S11 w_n3127_n224# sg13_hv_pmos ad=0.34p pd=2.68u as=0.34p ps=2.68u w=1u l=1u
X12 D3 G3 S3 w_n3127_n224# sg13_hv_pmos ad=0.34p pd=2.68u as=0.34p ps=2.68u w=1u l=1u
X13 S4 G4 D4 w_n3127_n224# sg13_hv_pmos ad=0.34p pd=2.68u as=0.34p ps=2.68u w=1u l=1u
X14 D5 G5 S5 w_n3127_n224# sg13_hv_pmos ad=0.34p pd=2.68u as=0.34p ps=2.68u w=1u l=1u
X15 S6 G6 D6 w_n3127_n224# sg13_hv_pmos ad=0.34p pd=2.68u as=0.34p ps=2.68u w=1u l=1u
.ends

.subckt sg13_hv_pmos_NWNELU D0_0 S0_0 G0_0 D0_1 S0_1 G0_1 D0_2 S0_2 G0_2 D0_3 S0_3
+ G0_3 D1_0 S1_0 G1_0 D1_1 S1_1 G1_1 D1_2 S1_2 G1_2 D1_3 S1_3 G1_3 w_n481_n2006#
X0 S0_0 G0_0 D0_0 w_n481_n2006# sg13_hv_pmos ad=1.36p pd=8.68u as=1.36p ps=8.68u w=4u l=1u
X1 S0_2 G0_2 D0_2 w_n481_n2006# sg13_hv_pmos ad=1.36p pd=8.68u as=1.36p ps=8.68u w=4u l=1u
X2 S0_1 G0_1 D0_1 w_n481_n2006# sg13_hv_pmos ad=1.36p pd=8.68u as=1.36p ps=8.68u w=4u l=1u
X3 D1_1 G1_1 S1_1 w_n481_n2006# sg13_hv_pmos ad=1.36p pd=8.68u as=1.36p ps=8.68u w=4u l=1u
X4 D1_0 G1_0 S1_0 w_n481_n2006# sg13_hv_pmos ad=1.36p pd=8.68u as=1.36p ps=8.68u w=4u l=1u
X5 D1_2 G1_2 S1_2 w_n481_n2006# sg13_hv_pmos ad=1.36p pd=8.68u as=1.36p ps=8.68u w=4u l=1u
X6 D1_3 G1_3 S1_3 w_n481_n2006# sg13_hv_pmos ad=1.36p pd=8.68u as=1.36p ps=8.68u w=4u l=1u
X7 S0_3 G0_3 D0_3 w_n481_n2006# sg13_hv_pmos ad=1.36p pd=8.68u as=1.36p ps=8.68u w=4u l=1u
.ends

.subckt sg13_hv_nmos_XAAXMC D0 S0 G0 D1 S1 G1 D2 S2 G2 D3 S3 G3 D4 S4 G4 D5 S5 G5
+ D6 S6 G6 D7 S7 G7 D8 S8 G8 D9 S9 G9 D10 S10 G10 D11 S11 G11 D12 S12 G12 D13 S13
+ G13 D14 S14 G14 D15 S15 G15 sub
X0 D15 G15 S15 sub sg13_hv_nmos ad=0.34p pd=2.68u as=0.34p ps=2.68u w=1u l=1u
X1 S8 G8 D8 sub sg13_hv_nmos ad=0.34p pd=2.68u as=0.34p ps=2.68u w=1u l=1u
X2 S14 G14 D14 sub sg13_hv_nmos ad=0.34p pd=2.68u as=0.34p ps=2.68u w=1u l=1u
X3 S0 G0 D0 sub sg13_hv_nmos ad=0.34p pd=2.68u as=0.34p ps=2.68u w=1u l=1u
X4 D1 G1 S1 sub sg13_hv_nmos ad=0.34p pd=2.68u as=0.34p ps=2.68u w=1u l=1u
X5 S2 G2 D2 sub sg13_hv_nmos ad=0.34p pd=2.68u as=0.34p ps=2.68u w=1u l=1u
X6 D13 G13 S13 sub sg13_hv_nmos ad=0.34p pd=2.68u as=0.34p ps=2.68u w=1u l=1u
X7 S10 G10 D10 sub sg13_hv_nmos ad=0.34p pd=2.68u as=0.34p ps=2.68u w=1u l=1u
X8 S12 G12 D12 sub sg13_hv_nmos ad=0.34p pd=2.68u as=0.34p ps=2.68u w=1u l=1u
X9 D9 G9 S9 sub sg13_hv_nmos ad=0.34p pd=2.68u as=0.34p ps=2.68u w=1u l=1u
X10 D11 G11 S11 sub sg13_hv_nmos ad=0.34p pd=2.68u as=0.34p ps=2.68u w=1u l=1u
X11 D3 G3 S3 sub sg13_hv_nmos ad=0.34p pd=2.68u as=0.34p ps=2.68u w=1u l=1u
X12 S4 G4 D4 sub sg13_hv_nmos ad=0.34p pd=2.68u as=0.34p ps=2.68u w=1u l=1u
X13 D5 G5 S5 sub sg13_hv_nmos ad=0.34p pd=2.68u as=0.34p ps=2.68u w=1u l=1u
X14 S6 G6 D6 sub sg13_hv_nmos ad=0.34p pd=2.68u as=0.34p ps=2.68u w=1u l=1u
X15 D7 G7 S7 sub sg13_hv_nmos ad=0.34p pd=2.68u as=0.34p ps=2.68u w=1u l=1u
.ends

.subckt sg13_hv_nmos_TYJME3 D0 S0 G0 D1 S1 G1 D2 S2 G2 D3 S3 G3 D4 S4 G4 D5 S5 G5
+ D6 S6 G6 D7 S7 G7 sub
X0 S4 G4 D4 sub sg13_hv_nmos ad=0.34p pd=2.68u as=0.34p ps=2.68u w=1u l=4u
X1 S0 G0 D0 sub sg13_hv_nmos ad=0.34p pd=2.68u as=0.34p ps=2.68u w=1u l=4u
X2 D1 G1 S1 sub sg13_hv_nmos ad=0.34p pd=2.68u as=0.34p ps=2.68u w=1u l=4u
X3 D3 G3 S3 sub sg13_hv_nmos ad=0.34p pd=2.68u as=0.34p ps=2.68u w=1u l=4u
X4 S2 G2 D2 sub sg13_hv_nmos ad=0.34p pd=2.68u as=0.34p ps=2.68u w=1u l=4u
X5 D7 G7 S7 sub sg13_hv_nmos ad=0.34p pd=2.68u as=0.34p ps=2.68u w=1u l=4u
X6 S6 G6 D6 sub sg13_hv_nmos ad=0.34p pd=2.68u as=0.34p ps=2.68u w=1u l=4u
X7 D5 G5 S5 sub sg13_hv_nmos ad=0.34p pd=2.68u as=0.34p ps=2.68u w=1u l=4u
.ends

.subckt sg13_hv_pmos_H5F6DG D0_0 S0_0 G0_0 D0_1 S0_1 G0_1 D1_0 S1_0 G1_0 D1_1 S1_1
+ G1_1 w_n1081_n618#
X0 S0_0 G0_0 D0_0 w_n1081_n618# sg13_hv_pmos ad=0.68p pd=4.68u as=0.68p ps=4.68u w=2u l=4u
X1 D1_1 G1_1 S1_1 w_n1081_n618# sg13_hv_pmos ad=0.68p pd=4.68u as=0.68p ps=4.68u w=2u l=4u
X2 D1_0 G1_0 S1_0 w_n1081_n618# sg13_hv_pmos ad=0.68p pd=4.68u as=0.68p ps=4.68u w=2u l=4u
X3 S0_1 G0_1 D0_1 w_n1081_n618# sg13_hv_pmos ad=0.68p pd=4.68u as=0.68p ps=4.68u w=2u l=4u
.ends

.subckt sg13_hv_pmos_HLS6DG D0 S0 G0 D1 S1 G1 D2 S2 G2 D3 S3 G3 D4 S4 G4 D5 S5 G5
+ D6 S6 G6 D7 S7 G7 w_n4015_n324#
X0 S2 G2 D2 w_n4015_n324# sg13_hv_pmos ad=0.68p pd=4.68u as=0.68p ps=4.68u w=2u l=4u
X1 D1 G1 S1 w_n4015_n324# sg13_hv_pmos ad=0.68p pd=4.68u as=0.68p ps=4.68u w=2u l=4u
X2 S0 G0 D0 w_n4015_n324# sg13_hv_pmos ad=0.68p pd=4.68u as=0.68p ps=4.68u w=2u l=4u
X3 D3 G3 S3 w_n4015_n324# sg13_hv_pmos ad=0.68p pd=4.68u as=0.68p ps=4.68u w=2u l=4u
X4 S4 G4 D4 w_n4015_n324# sg13_hv_pmos ad=0.68p pd=4.68u as=0.68p ps=4.68u w=2u l=4u
X5 D5 G5 S5 w_n4015_n324# sg13_hv_pmos ad=0.68p pd=4.68u as=0.68p ps=4.68u w=2u l=4u
X6 S6 G6 D6 w_n4015_n324# sg13_hv_pmos ad=0.68p pd=4.68u as=0.68p ps=4.68u w=2u l=4u
X7 D7 G7 S7 w_n4015_n324# sg13_hv_pmos ad=0.68p pd=4.68u as=0.68p ps=4.68u w=2u l=4u
.ends

.subckt sg13_hv_pmos_NQUDLU D0 S0 G0 D1 S1 G1 D2 S2 G2 D3 S3 G3 w_n859_n224#
X0 D1 G1 S1 w_n859_n224# sg13_hv_pmos ad=0.34p pd=2.68u as=0.34p ps=2.68u w=1u l=1u
X1 S2 G2 D2 w_n859_n224# sg13_hv_pmos ad=0.34p pd=2.68u as=0.34p ps=2.68u w=1u l=1u
X2 D3 G3 S3 w_n859_n224# sg13_hv_pmos ad=0.34p pd=2.68u as=0.34p ps=2.68u w=1u l=1u
X3 S0 G0 D0 w_n859_n224# sg13_hv_pmos ad=0.34p pd=2.68u as=0.34p ps=2.68u w=1u l=1u
.ends

.subckt sg13_hv_nmos_TGUME3 D0_0 S0_0 G0_0 D0_1 S0_1 G0_1 D1_0 S1_0 G1_0 D1_1 S1_1
+ G1_1 sub
X0 D1_0 G1_0 S1_0 sub sg13_hv_nmos ad=0.34p pd=2.68u as=0.34p ps=2.68u w=1u l=4u
X1 D1_1 G1_1 S1_1 sub sg13_hv_nmos ad=0.34p pd=2.68u as=0.34p ps=2.68u w=1u l=4u
X2 S0_1 G0_1 D0_1 sub sg13_hv_nmos ad=0.34p pd=2.68u as=0.34p ps=2.68u w=1u l=4u
X3 S0_0 G0_0 D0_0 sub sg13_hv_nmos ad=0.34p pd=2.68u as=0.34p ps=2.68u w=1u l=4u
.ends

.subckt sg13_hv_nmos_BE9VUZ D0_0 S0_0 G0_0 D0_1 S0_1 G0_1 D1_0 S1_0 G1_0 D1_1 S1_1
+ G1_1 sub
X0 D1_0 G1_0 S1_0 sub sg13_hv_nmos ad=0.34p pd=2.68u as=0.34p ps=2.68u w=1u l=1u
X1 S0_1 G0_1 D0_1 sub sg13_hv_nmos ad=0.34p pd=2.68u as=0.34p ps=2.68u w=1u l=1u
X2 S0_0 G0_0 D0_0 sub sg13_hv_nmos ad=0.34p pd=2.68u as=0.34p ps=2.68u w=1u l=1u
X3 D1_1 G1_1 S1_1 sub sg13_hv_nmos ad=0.34p pd=2.68u as=0.34p ps=2.68u w=1u l=1u
.ends

.subckt sg13_hv_nmos_BEMUUZ D0_0 S0_0 G0_0 D0_1 S0_1 G0_1 D1_0 S1_0 G1_0 D1_1 S1_1
+ G1_1 D2_0 S2_0 G2_0 D2_1 S2_1 G2_1 sub
X0 D1_0 G1_0 S1_0 sub sg13_hv_nmos ad=0.34p pd=2.68u as=0.34p ps=2.68u w=1u l=1u
X1 D1_1 G1_1 S1_1 sub sg13_hv_nmos ad=0.34p pd=2.68u as=0.34p ps=2.68u w=1u l=1u
X2 S0_0 G0_0 D0_0 sub sg13_hv_nmos ad=0.34p pd=2.68u as=0.34p ps=2.68u w=1u l=1u
X3 S2_1 G2_1 D2_1 sub sg13_hv_nmos ad=0.34p pd=2.68u as=0.34p ps=2.68u w=1u l=1u
X4 S0_1 G0_1 D0_1 sub sg13_hv_nmos ad=0.34p pd=2.68u as=0.34p ps=2.68u w=1u l=1u
X5 S2_0 G2_0 D2_0 sub sg13_hv_nmos ad=0.34p pd=2.68u as=0.34p ps=2.68u w=1u l=1u
.ends

.subckt sg13_hv_pmos_N8UDLU D0 S0 G0 D1 S1 G1 w_n481_n224#
X0 S0 G0 D0 w_n481_n224# sg13_hv_pmos ad=0.34p pd=2.68u as=0.34p ps=2.68u w=1u l=1u
X1 D1 G1 S1 w_n481_n224# sg13_hv_pmos ad=0.34p pd=2.68u as=0.34p ps=2.68u w=1u l=1u
.ends

.subckt sg13_hv_nmos_BEDTUZ D0_0 S0_0 G0_0 D0_1 S0_1 G0_1 D1_0 S1_0 G1_0 D1_1 S1_1
+ G1_1 D2_0 S2_0 G2_0 D2_1 S2_1 G2_1 D3_0 S3_0 G3_0 D3_1 S3_1 G3_1 D4_0 S4_0 G4_0
+ D4_1 S4_1 G4_1 sub
X0 S2_0 G2_0 D2_0 sub sg13_hv_nmos ad=0.34p pd=2.68u as=0.34p ps=2.68u w=1u l=1u
X1 S2_1 G2_1 D2_1 sub sg13_hv_nmos ad=0.34p pd=2.68u as=0.34p ps=2.68u w=1u l=1u
X2 S4_1 G4_1 D4_1 sub sg13_hv_nmos ad=0.34p pd=2.68u as=0.34p ps=2.68u w=1u l=1u
X3 S0_1 G0_1 D0_1 sub sg13_hv_nmos ad=0.34p pd=2.68u as=0.34p ps=2.68u w=1u l=1u
X4 D1_0 G1_0 S1_0 sub sg13_hv_nmos ad=0.34p pd=2.68u as=0.34p ps=2.68u w=1u l=1u
X5 S0_0 G0_0 D0_0 sub sg13_hv_nmos ad=0.34p pd=2.68u as=0.34p ps=2.68u w=1u l=1u
X6 D3_1 G3_1 S3_1 sub sg13_hv_nmos ad=0.34p pd=2.68u as=0.34p ps=2.68u w=1u l=1u
X7 D1_1 G1_1 S1_1 sub sg13_hv_nmos ad=0.34p pd=2.68u as=0.34p ps=2.68u w=1u l=1u
X8 D3_0 G3_0 S3_0 sub sg13_hv_nmos ad=0.34p pd=2.68u as=0.34p ps=2.68u w=1u l=1u
X9 S4_0 G4_0 D4_0 sub sg13_hv_nmos ad=0.34p pd=2.68u as=0.34p ps=2.68u w=1u l=1u
.ends

.subckt se_folded_cascode_p out bias ena inn inp vdd vss
XXM3DUM vdd vdd vdd vdd vdd vdd vdd vdd vdd vdd vdd vdd vdd sg13_hv_pmos_NNMDLU
XXM1 vdd XM1/S8 vbp1 XM1/S8 vdd vbp1 vdd XM1/S8 vbp1 XM1/S8 vdd vbp1 vdd XM1/S8 vbp1
+ XM1/S8 vdd vbp1 vdd XM1/S8 vbp1 XM1/S8 vdd vbp1 vdd XM1/S8 vbp1 XM1/S8 vdd vbp1
+ vdd XM1/S8 vbp1 XM1/S8 vdd vbp1 vdd XM1/S8 vbp1 XM1/S8 vdd vbp1 vdd XM1/S8 vbp1
+ XM1/S8 vdd vbp1 vdd sg13_hv_pmos_ZKTCY2
XXM2 XM1/S8 out1n inp XM1/S8 out1p inn XM1/S8 out1n inp XM1/S8 out1p inn out1p XM1/S8
+ inn out1n XM1/S8 inp out1p XM1/S8 inn out1n XM1/S8 inp vdd sg13_hv_pmos_NWNELU
XXM3 XM1/S8 out1n inp XM1/S8 out1p inn XM1/S8 out1n inp XM1/S8 out1p inn out1p XM1/S8
+ inn out1n XM1/S8 inp out1p XM1/S8 inn out1n XM1/S8 inp vdd sg13_hv_pmos_NWNELU
XXM4 vss out1p vbn1 out1n vss vbn1 vss out1p vbn1 out1n vss vbn1 vss out1p vbn1 out1n
+ vss vbn1 vss out1p vbn1 out1n vss vbn1 vss out1p vbn1 out1n vss vbn1 vss out1p vbn1
+ out1n vss vbn1 vss out1p vbn1 out1n vss vbn1 vss out1p vbn1 out1n vss vbn1 vss sg13_hv_nmos_XAAXMC
XXM5 vss out1n vbn1 out1p vss vbn1 vss out1n vbn1 out1p vss vbn1 vss out1n vbn1 out1p
+ vss vbn1 vss out1n vbn1 out1p vss vbn1 vss out1n vbn1 out1p vss vbn1 vss out1n vbn1
+ out1p vss vbn1 vss out1n vbn1 out1p vss vbn1 vss out1n vbn1 out1p vss vbn1 vss sg13_hv_nmos_XAAXMC
XXM6 out1n XM9/S6 vbn2 out out1p vbn2 out1n XM9/S6 vbn2 out out1p vbn2 out1n XM9/S6
+ vbn2 out out1p vbn2 out1n XM9/S6 vbn2 out out1p vbn2 vss sg13_hv_nmos_TYJME3
XXM7 out1p out vbn2 XM9/S6 out1n vbn2 out1p out vbn2 XM9/S6 out1n vbn2 out1p out vbn2
+ XM9/S6 out1n vbn2 out1p out vbn2 XM9/S6 out1n vbn2 vss sg13_hv_nmos_TYJME3
XXMB1 bias vbp1 bias bias vbp1 bias vbp1 bias bias vbp1 bias bias vdd sg13_hv_pmos_H5F6DG
XXM8 XM9/S7 out bias XM9/S6 XM9/D6 bias XM9/S7 out bias XM9/S6 XM9/D6 bias XM9/S7
+ out bias XM9/S6 XM9/D6 bias XM9/S7 out bias XM9/S6 XM9/D6 bias vdd sg13_hv_pmos_HLS6DG
XXMB2 vdd vbp1 vbp1 vbn2 vdd vbp1 vdd vbp1 vbp1 vbn2 vdd vbp1 vdd sg13_hv_pmos_NQUDLU
XXM9 XM9/D6 XM9/S6 bias out XM9/S7 bias XM9/D6 XM9/S6 bias out XM9/S7 bias XM9/D6
+ XM9/S6 bias out XM9/S7 bias XM9/D6 XM9/S6 bias out XM9/S7 bias vdd sg13_hv_pmos_HLS6DG
XXMB3 vdd vbp1 vbp1 vbn2 vdd vbp1 vdd vbp1 vbp1 vbn2 vdd vbp1 vdd sg13_hv_pmos_NQUDLU
XXMB4 vbn2 vbn1 vbn2 vbn2 vbn1 vbn2 vbn1 vbn2 vbn2 vbn1 vbn2 vbn2 vss sg13_hv_nmos_TGUME3
XXMB5 vss vss vss vss vss vss vss vss vss vss vss vss vss sg13_hv_nmos_BE9VUZ
XXMB5DUM vss vbn1 vbn1 vss vbn1 vbn1 vbn1 vss vbn1 vbn1 vss vbn1 vss vss vss vss vss
+ vss vss sg13_hv_nmos_BEMUUZ
XXM1DUM bias vdd ena vdd vdd vdd vdd sg13_hv_pmos_N8UDLU
XXMB6 vdd vdd vdd vdd vdd vdd vdd vdd vdd vdd vdd vdd vdd sg13_hv_pmos_H5F6DG
XXM4DUM vss vss vss vss vss vss vss vss vss vss vss vss vss vss vss vss vss vss vss
+ vss vss vss vss vss vss vss vss vss vss vss vss sg13_hv_nmos_BEDTUZ
XXM10 XM9/S7 vdd XM9/S6 vdd XM9/D6 XM9/S6 XM9/S7 vdd XM9/S6 vdd XM9/D6 XM9/S6 XM9/S7
+ vdd XM9/S6 vdd XM9/D6 XM9/S6 XM9/S7 vdd XM9/S6 vdd XM9/D6 XM9/S6 vdd sg13_hv_pmos_HLS6DG
XXM2DUM vdd vdd vdd vdd vdd vdd vdd vdd vdd vdd vdd vdd vdd sg13_hv_pmos_NNMDLU
XXM11 XM9/D6 vdd XM9/S6 vdd XM9/S7 XM9/S6 XM9/D6 vdd XM9/S6 vdd XM9/S7 XM9/S6 XM9/D6
+ vdd XM9/S6 vdd XM9/S7 XM9/S6 XM9/D6 vdd XM9/S6 vdd XM9/S7 XM9/S6 vdd sg13_hv_pmos_HLS6DG
.ends

.subckt sg13_hv_pmos_XLVYT6 B D S G
X0 S G D B sg13_hv_pmos ad=0.68p pd=4.68u as=0.68p ps=4.68u w=2u l=0.5u
.ends

.subckt sg13_hv_nmos_MRZNPN B D S G
X0 S G D B sg13_hv_nmos ad=0.68p pd=4.68u as=0.68p ps=4.68u w=2u l=0.5u
.ends

.subckt xgate ena_b in out ena vss vdd
XXM1 vdd in out ena_b sg13_hv_pmos_XLVYT6
XXM2 vss in out ena sg13_hv_nmos_MRZNPN
.ends

.subckt rhigh_NFPZ4T B R1_0 R2_0 R1_1 R2_1 R1_2 R2_2 R1_3 R2_3 R1_4 R2_4 R1_5 R2_5
+ R1_6 R2_6 R1_7 R2_7 R1_8 R2_8 R1_9 R2_9
X0 R1_3 R2_3 B rhigh l=2.5u w=0.5u
X1 R1_6 R2_6 B rhigh l=2.5u w=0.5u
X2 R1_5 R2_5 B rhigh l=2.5u w=0.5u
X3 R1_2 R2_2 B rhigh l=2.5u w=0.5u
X4 R1_0 R2_0 B rhigh l=2.5u w=0.5u
X5 R1_9 R2_9 B rhigh l=2.5u w=0.5u
X6 R1_4 R2_4 B rhigh l=2.5u w=0.5u
X7 R1_7 R2_7 B rhigh l=2.5u w=0.5u
X8 R1_1 R2_1 B rhigh l=2.5u w=0.5u
X9 R1_8 R2_8 B rhigh l=2.5u w=0.5u
.ends

.subckt sg13_hv_pmos_QH8WBX B D S G
X0 S G D B sg13_hv_pmos ad=0.68p pd=4.68u as=0.68p ps=4.68u w=2u l=0.5u
.ends

.subckt sg13cmos5l_nand3_1 Y A B C VDD VSS
X0 Y C VDD VDD sg13_lv_pmos ad=0.2128p pd=1.5u as=0.3808p ps=2.92u w=1.12u l=0.13u
X1 VDD B Y VDD sg13_lv_pmos ad=0.2128p pd=1.5u as=0.2128p ps=1.5u w=1.12u l=0.13u
X2 Y A VDD VDD sg13_lv_pmos ad=0.3808p pd=2.92u as=0.2128p ps=1.5u w=1.12u l=0.13u
X3 a_146_122# C VSS VSS sg13_lv_nmos ad=0.1406p pd=1.12u as=0.2886p ps=2.26u w=0.74u l=0.13u
X4 a_248_122# B a_146_122# VSS sg13_lv_nmos ad=0.1406p pd=1.12u as=0.1406p ps=1.12u w=0.74u l=0.13u
X5 Y A a_248_122# VSS sg13_lv_nmos ad=0.2516p pd=2.16u as=0.1406p ps=1.12u w=0.74u l=0.13u
.ends

.subckt capacitor_BCZJG3 c1 c2
X0 c1 c2 cap_cmomf mm_ok=1 subblock=0 mmax=4 mmin=1 l=26.261u w=26.261u
.ends

.subckt cap_cmomf_H6HXXJ c1 c2
X0 c1 c2 cap_cmomf mm_ok=1 subblock=0 mmax=4 mmin=1 l=23.000u w=15.000u
.ends

.subckt n_amp_large out inn inp avss ena ibias avdd
Xsg13_hv_pmos_7A8CUW_0 avdd avdd avdd XM6/S7 avdd XM6/S7 avdd out XM6/S7 XM6/S7 avdd
+ XM6/S7 avdd out XM6/S7 XM6/S7 avdd XM6/S7 avdd out XM6/S7 XM6/S7 avdd XM6/S7 avdd
+ out XM6/S7 XM6/S7 avdd XM6/S7 avdd out XM6/S7 avdd avdd avdd avdd sg13_hv_pmos_7A8CUW
Xsg13_hv_nmos_XVVFQX_0 avss XM1/S8_0 XM1/S8_0 avss XM6/D8 XM1/S8_0 XM6/D8 avss XM1/S8_0
+ XM1/S8_0 avss XM1/S8_0 avss XM1/S8_0 XM1/S8_0 avss XM6/D8 XM1/S8_0 XM6/D8 avss XM1/S8_0
+ XM1/S8_0 avss XM1/S8_0 avss XM1/S8_0 XM1/S8_0 avss XM6/D8 XM1/S8_0 XM6/D8 avss XM1/S8_0
+ XM1/S8_0 avss XM1/S8_0 avss XM1/S8_0 XM1/S8_0 avss XM6/D8 XM1/S8_0 XM6/D8 avss XM1/S8_0
+ XM1/S8_0 avss XM1/S8_0 avss XM1/S8_0 XM1/S8_0 avss XM6/D8 XM1/S8_0 XM6/D8 avss XM1/S8_0
+ XM1/S8_0 avss XM1/S8_0 avss sg13_hv_nmos_XVVFQX
XXM1 avss XM1/S8_0 XM1/S8_0 avss XM6/D8 XM1/S8_0 XM6/D8 avss XM1/S8_0 XM1/S8_0 avss
+ XM1/S8_0 avss XM1/S8_0 XM1/S8_0 avss XM6/D8 XM1/S8_0 XM6/D8 avss XM1/S8_0 XM1/S8_0
+ avss XM1/S8_0 avss XM1/S8_0 XM1/S8_0 avss XM6/D8 XM1/S8_0 XM6/D8 avss XM1/S8_0 XM1/S8_0
+ avss XM1/S8_0 avss XM1/S8_0 XM1/S8_0 avss XM6/D8 XM1/S8_0 XM6/D8 avss XM1/S8_0 XM1/S8_0
+ avss XM1/S8_0 avss XM1/S8_0 XM1/S8_0 avss XM6/D8 XM1/S8_0 XM6/D8 avss XM1/S8_0 XM1/S8_0
+ avss XM1/S8_0 avss sg13_hv_nmos_XVVFQX
XXM2 avdd avdd avdd out avdd XM6/S7 avdd XM6/S7 XM6/S7 out avdd XM6/S7 avdd XM6/S7
+ XM6/S7 out avdd XM6/S7 avdd XM6/S7 XM6/S7 out avdd XM6/S7 avdd XM6/S7 XM6/S7 out
+ avdd XM6/S7 avdd XM6/S7 XM6/S7 avdd avdd avdd avdd sg13_hv_pmos_7A8CUW
XXM5 XM6/D8 inp XM6/S7 inp XM6/D8 inn out inn XM6/D8 inp XM6/S7 inp XM6/D8 inn out
+ inn XM6/D8 inp XM6/S7 inp XM6/D8 inn out inn XM6/D8 inp XM6/S7 inp XM6/D8 inn out
+ inn XM6/D8 inp XM6/S7 inp XM6/D8 inn out inn XM6/D8 avss sg13_hv_nmos_666RAL
XXM6 XM6/D8 inn out inn XM6/D8 inp XM6/S7 inp XM6/D8 inn out inn XM6/D8 inp XM6/S7
+ inp XM6/D8 inn out inn XM6/D8 inp XM6/S7 inp XM6/D8 inn out inn XM6/D8 inp XM6/S7
+ inp XM6/D8 inn out inn XM6/D8 inp XM6/S7 inp XM6/D8 avss sg13_hv_nmos_666RAL
Xsg13_hv_nmos_666RAL_0 XM1/S8_0 ena ibias ena XM1/S8_0 ena ibias ena XM1/S8_0 ena
+ ibias ena XM1/S8_0 ena ibias ena XM1/S8_0 ena ibias ena XM1/S8_0 ena ibias ena XM1/S8_0
+ ena ibias ena XM1/S8_0 ena ibias ena XM1/S8_0 ena ibias ena XM1/S8_0 ena ibias ena
+ XM1/S8_0 avss sg13_hv_nmos_666RAL
.ends

.subckt sg13cmos5l_ocd_ip__voltgen_v3 dvdd s[2] s[1] s[0] vbg ibias1u_1 ena ena1 ena2
+ ibias1u_2 high vgen_ena2_h vout_unbuf vout_buf vss dvss vdd
Xcapacitor_KK7B53_0 vdd XM1/G capacitor_KK7B53
Xsg13cmos5l_inv_2_0 sg13cmos5l_inv_2_0/Y sg13cmos5l_inv_2_0/A dvdd dvss sg13cmos5l_inv_2
Xhv_inv_1_0 vdd x6/ena vss x6/ena_b hv_inv_1
Xsg13cmos5l_inv_2_1 sg13cmos5l_inv_2_1/Y sg13cmos5l_inv_2_1/A dvdd dvss sg13cmos5l_inv_2
Xhv_inv_1_1 vdd hv_inv_1_1/X vss v0 hv_inv_1
Xsg13cmos5l_inv_2_2 sg13cmos5l_inv_2_2/Y sg13cmos5l_inv_2_2/A dvdd dvss sg13cmos5l_inv_2
Xhv_inv_1_2 vdd hv_inv_1_2/X vss v2 hv_inv_1
Xhv_inv_1_3 vdd hv_inv_1_3/X vss v1 hv_inv_1
Xsg13cmos5l_inv_2_3 sg13cmos5l_inv_2_3/Y sg13cmos5l_inv_2_3/A dvdd dvss sg13cmos5l_inv_2
Xsg13cmos5l_inv_2_4 sg13cmos5l_inv_2_4/Y sg13cmos5l_inv_2_4/A dvdd dvss sg13cmos5l_inv_2
Xhv_inv_1_4 vdd hv_inv_1_4/X vss v4 hv_inv_1
Xse_folded_cascode_p_0 vout_buf ibias1u_2 level_shift_3/out vout_buf vout_unbuf vdd
+ vss se_folded_cascode_p
Xx6 x6/ena_b x6/in vref3 x6/ena vss vdd xgate
Xhv_inv_1_5 vdd hv_inv_1_5/X vss v3 hv_inv_1
Xsg13cmos5l_inv_2_5 level_shift_3/in_n ena1 dvdd dvss sg13cmos5l_inv_2
XXR1 vss vss vss vss vref0 vref1 vref0 vref1 vref2 vref3 vref2 vref3 vref4 vref5 vref4
+ vref5 vref6 vref7 vref6 vss vss rhigh_NFPZ4T
Xsg13cmos5l_inv_2_6 level_shift_2/in_n ena2 dvdd dvss sg13cmos5l_inv_2
Xhv_inv_1_6 vdd hv_inv_1_6/X vss v6 hv_inv_1
Xhv_inv_1_7 vdd hv_inv_1_7/X vss v5 hv_inv_1
Xsg13cmos5l_inv_2_7 sg13cmos5l_inv_2_7/Y ena dvdd dvss sg13cmos5l_inv_2
Xsg13cmos5l_inv_2_8 s0b s[0] dvdd dvss sg13cmos5l_inv_2
Xhv_inv_1_8 vdd hv_inv_1_8/X vss v7 hv_inv_1
Xsg13cmos5l_inv_2_9 s0 s0b dvdd dvss sg13cmos5l_inv_2
Xxgate_0 x6/ena x6/in vref2 x6/ena_b vss vdd xgate
Xxgate_1 hv_inv_1_1/X vref0 vout_unbuf v0 vss vdd xgate
XXM1 vdd vref7 vdd XM1/G sg13_hv_pmos_QH8WBX
Xxgate_2 hv_inv_1_3/X vref1 vout_unbuf v1 vss vdd xgate
Xsg13cmos5l_antennanp_0 s[2] dvdd dvss sg13cmos5l_antennanp
Xsg13cmos5l_antennanp_1 s[1] dvdd dvss sg13cmos5l_antennanp
Xxgate_3 hv_inv_1_2/X vref2 vout_unbuf v2 vss vdd xgate
Xxgate_4 hv_inv_1_5/X vref3 vout_unbuf v3 vss vdd xgate
Xsg13cmos5l_antennanp_2 s[0] dvdd dvss sg13cmos5l_antennanp
Xsg13cmos5l_nand3_1_0 sg13cmos5l_inv_2_1/A s2 s1 s0b dvdd dvss sg13cmos5l_nand3_1
Xsg13cmos5l_antennanp_3 ena dvdd dvss sg13cmos5l_antennanp
Xxgate_5 hv_inv_1_7/X vref5 vout_unbuf v5 vss vdd xgate
Xxgate_6 hv_inv_1_4/X vref4 vout_unbuf v4 vss vdd xgate
Xsg13cmos5l_antennanp_4 ena2 dvdd dvss sg13cmos5l_antennanp
Xsg13cmos5l_nand3_1_1 sg13cmos5l_inv_2_0/A s2b s1 s0b dvdd dvss sg13cmos5l_nand3_1
Xsg13cmos5l_nand3_1_2 sg13cmos5l_inv_2_4/A s2 s1b s0b dvdd dvss sg13cmos5l_nand3_1
Xsg13cmos5l_antennanp_5 ena1 dvdd dvss sg13cmos5l_antennanp
XC1 vdd XM1/G capacitor_BCZJG3
Xxgate_7 hv_inv_1_6/X vref6 vout_unbuf v6 vss vdd xgate
Xxgate_8 hv_inv_1_8/X vref7 vout_unbuf v7 vss vdd xgate
Xsg13cmos5l_nand3_1_3 sg13cmos5l_inv_2_2/A s2b s1b s0b dvdd dvss sg13cmos5l_nand3_1
Xsg13cmos5l_antennanp_7 high dvdd dvss sg13cmos5l_antennanp
Xsg13cmos5l_nand3_1_4 sg13cmos5l_inv_2_3/A s2b s1b s0 dvdd dvss sg13cmos5l_nand3_1
Xsg13cmos5l_nand3_1_5 sg13cmos5l_inv_2_14/A s2 s1b s0 dvdd dvss sg13cmos5l_nand3_1
Xlevel_shift_0[0] x14/A x14/Y v7 vss vdd level_shift
Xlevel_shift_0[1] sg13cmos5l_inv_2_4/A sg13cmos5l_inv_2_4/Y v4 vss vdd level_shift
Xlevel_shift_0[2] sg13cmos5l_inv_2_0/A sg13cmos5l_inv_2_0/Y v2 vss vdd level_shift
Xlevel_shift_0[3] sg13cmos5l_inv_2_2/A sg13cmos5l_inv_2_2/Y v0 vss vdd level_shift
Xlevel_shift_0[4] sg13cmos5l_inv_2_7/Y ena x48/ena vss vdd level_shift
Xlevel_shift_1[0] sg13cmos5l_inv_2_1/A sg13cmos5l_inv_2_1/Y v6 vss vdd level_shift
Xlevel_shift_1[1] sg13cmos5l_inv_2_14/A sg13cmos5l_inv_2_14/Y v5 vss vdd level_shift
Xlevel_shift_1[2] x35/Y x34/Y v3 vss vdd level_shift
Xlevel_shift_1[3] sg13cmos5l_inv_2_3/A sg13cmos5l_inv_2_3/Y v1 vss vdd level_shift
Xlevel_shift_1[4] sg13cmos5l_inv_2_15/Y high x6/ena_b vss vdd level_shift
Xlevel_shift_2 level_shift_2/in_n ena2 vgen_ena2_h vss vdd level_shift
Xsg13cmos5l_decap_4_0 dvdd dvss sg13cmos5l_decap_4
Xlevel_shift_3 level_shift_3/in_n ena1 level_shift_3/out vss vdd level_shift
Xx34 x34/Y x35/Y dvdd dvss sg13cmos5l_inv_2
Xx13 x14/A s2 s1 s0 dvdd dvss sg13cmos5l_nand3_1
Xx35 x35/Y s2b s1 s0 dvdd dvss sg13cmos5l_nand3_1
Xx14 x14/Y x14/A dvdd dvss sg13cmos5l_inv_2
Xcap_cmomf_H6HXXJ_0 vdd XM1/G cap_cmomf_H6HXXJ
Xx48 XM1/G vbg x6/in vss x48/ena ibias1u_1 vdd n_amp_large
Xsg13cmos5l_inv_2_10 s1 s1b dvdd dvss sg13cmos5l_inv_2
Xsg13cmos5l_inv_2_11 s2 s2b dvdd dvss sg13cmos5l_inv_2
Xsg13cmos5l_inv_2_12 s2b s[2] dvdd dvss sg13cmos5l_inv_2
Xsg13cmos5l_inv_2_13 s1b s[1] dvdd dvss sg13cmos5l_inv_2
Xsg13cmos5l_inv_2_14 sg13cmos5l_inv_2_14/Y sg13cmos5l_inv_2_14/A dvdd dvss sg13cmos5l_inv_2
Xsg13cmos5l_inv_2_15 sg13cmos5l_inv_2_15/Y high dvdd dvss sg13cmos5l_inv_2
.ends

* Black-box entry subcircuit for slot13_wrapper abstract view
.subckt slot13_wrapper s13_an[0] s13_an[1] s13_an_0_esd s13_an_1_esd s13_an_0 s13_an_1
+ vbias dig_in[23] dig_in[22] dig_in[21] dig_in[20] dig_in[19] dig_in[18] dig_in[17]
+ dig_in[16] dig_in[15] dig_in[14] dig_in[13] dig_in[12] dig_in[11] dig_in[10] dig_in[9]
+ dig_in[8] dig_in[7] dig_in[6] dig_in[5] dig_in[4] dig_in[3] dig_in[2] dig_in[1]
+ dig_in[0] dig_out[11] dig_out[10] dig_out[9] dig_out[8] dig_out[7] dig_out[6] dig_out[5]
+ dig_out[4] dig_out[3] dig_out[2] dig_out[1] dig_out[0] ibias0 ibias1 analog_bus3
+ analog_bus2 analog_bus1 analog_bus0 vss_1v2 vdd_1v2 vss_3v3 vdd_3v3 enable clk reset
.ends

* Black-box entry subcircuit for slot17_wrapper abstract view
.subckt slot17_wrapper s17_an[0] s17_an[1] s17_an_0_esd s17_an_1_esd s17_an_0 s17_an_1
+ vbias dig_in[23] dig_in[22] dig_in[21] dig_in[20] dig_in[19] dig_in[18] dig_in[17]
+ dig_in[16] dig_in[15] dig_in[14] dig_in[13] dig_in[12] dig_in[11] dig_in[10] dig_in[9]
+ dig_in[8] dig_in[7] dig_in[6] dig_in[5] dig_in[4] dig_in[3] dig_in[2] dig_in[1]
+ dig_in[0] dig_out[11] dig_out[10] dig_out[9] dig_out[8] dig_out[7] dig_out[6] dig_out[5]
+ dig_out[4] dig_out[3] dig_out[2] dig_out[1] dig_out[0] ibias0 ibias1 analog_bus3
+ analog_bus2 analog_bus1 analog_bus0 vss_1v2 vdd_1v2 vss_3v3 vdd_3v3 enable clk reset
.ends

* Black-box entry subcircuit for slot4_wrapper abstract view
.subckt slot4_wrapper s4_an[0] vss_1v2 s4_an_0_esd vbias dig_in[23] dig_in[22] dig_in[21]
+ dig_in[20] dig_in[19] dig_in[18] dig_in[17] dig_in[16] dig_in[15] dig_in[14] dig_in[13]
+ dig_in[12] dig_in[11] dig_in[10] dig_in[9] dig_in[8] dig_in[7] dig_in[6] dig_in[5]
+ dig_in[4] dig_in[3] dig_in[2] dig_in[1] dig_in[0] dig_out[11] dig_out[10] dig_out[9]
+ dig_out[8] dig_out[7] dig_out[6] dig_out[5] dig_out[4] dig_out[3] dig_out[2] dig_out[1]
+ dig_out[0] ibias0 ibias1 analog_bus3 analog_bus2 analog_bus1 analog_bus0 vdd_1v2
+ vss_3v3 vdd_3v3 enable clk reset
.ends

* Black-box entry subcircuit for slot8_wrapper abstract view
.subckt slot8_wrapper vss_3v3 s8_an[0] s8_an_0_esd vbias dig_in[23] dig_in[22] dig_in[21]
+ dig_in[20] dig_in[19] dig_in[18] dig_in[17] dig_in[16] dig_in[15] dig_in[14] dig_in[13]
+ dig_in[12] dig_in[11] dig_in[10] dig_in[9] dig_in[8] dig_in[7] dig_in[6] dig_in[5]
+ dig_in[4] dig_in[3] dig_in[2] dig_in[1] dig_in[0] dig_out[11] dig_out[10] dig_out[9]
+ dig_out[8] dig_out[7] dig_out[6] dig_out[5] dig_out[4] dig_out[3] dig_out[2] dig_out[1]
+ dig_out[0] ibias0 ibias1 analog_bus3 analog_bus2 analog_bus1 analog_bus0 vss_1v2
+ vdd_1v2 vdd_3v3 enable clk reset
.ends

.subckt sg13_hv_pmos_QWE845 D0_0 S0_0 G0_0 D0_1 S0_1 G0_1 D1_0 S1_0 G1_0 D1_1 S1_1
+ G1_1 w_n1081_n1018#
X0 S0_0 G0_0 D0_0 w_n1081_n1018# sg13_hv_pmos ad=1.36p pd=8.68u as=1.36p ps=8.68u w=4u l=4u
X1 D1_0 G1_0 S1_0 w_n1081_n1018# sg13_hv_pmos ad=1.36p pd=8.68u as=1.36p ps=8.68u w=4u l=4u
X2 D1_1 G1_1 S1_1 w_n1081_n1018# sg13_hv_pmos ad=1.36p pd=8.68u as=1.36p ps=8.68u w=4u l=4u
X3 S0_1 G0_1 D0_1 w_n1081_n1018# sg13_hv_pmos ad=1.36p pd=8.68u as=1.36p ps=8.68u w=4u l=4u
.ends

.subckt sg13_hv_pmos_FJG4RK D S G w_n242_n155#
X0 S G D w_n242_n155# sg13_hv_pmos ad=0.17p pd=1.68u as=0.17p ps=1.68u w=0.5u l=0.5u
.ends

.subckt sg13_hv_pmos_MLH6U9 D S G w_n242_n224#
X0 S G D w_n242_n224# sg13_hv_pmos ad=0.34p pd=2.68u as=0.34p ps=2.68u w=1u l=0.5u
.ends

.subckt sg13_hv_nmos_BEHQUZ D0 S0 G0 D1 S1 G1 D2 S2 G2 D3 S3 G3 D4 S4 G4 D5 S5 G5
+ D6 S6 G6 D7 S7 G7 sub
X0 S4 G4 D4 sub sg13_hv_nmos ad=0.34p pd=2.68u as=0.34p ps=2.68u w=1u l=1u
X1 S6 G6 D6 sub sg13_hv_nmos ad=0.34p pd=2.68u as=0.34p ps=2.68u w=1u l=1u
X2 D5 G5 S5 sub sg13_hv_nmos ad=0.34p pd=2.68u as=0.34p ps=2.68u w=1u l=1u
X3 D7 G7 S7 sub sg13_hv_nmos ad=0.34p pd=2.68u as=0.34p ps=2.68u w=1u l=1u
X4 S0 G0 D0 sub sg13_hv_nmos ad=0.34p pd=2.68u as=0.34p ps=2.68u w=1u l=1u
X5 D1 G1 S1 sub sg13_hv_nmos ad=0.34p pd=2.68u as=0.34p ps=2.68u w=1u l=1u
X6 S2 G2 D2 sub sg13_hv_nmos ad=0.34p pd=2.68u as=0.34p ps=2.68u w=1u l=1u
X7 D3 G3 S3 sub sg13_hv_nmos ad=0.34p pd=2.68u as=0.34p ps=2.68u w=1u l=1u
.ends

.subckt sg13_hv_nmos_BEZCVZ D0 S0 G0 D1 S1 G1 D2 S2 G2 D3 S3 G3 sub
X0 S2 G2 D2 sub sg13_hv_nmos ad=0.34p pd=2.68u as=0.34p ps=2.68u w=1u l=1u
X1 D3 G3 S3 sub sg13_hv_nmos ad=0.34p pd=2.68u as=0.34p ps=2.68u w=1u l=1u
X2 S0 G0 D0 sub sg13_hv_nmos ad=0.34p pd=2.68u as=0.34p ps=2.68u w=1u l=1u
X3 D1 G1 S1 sub sg13_hv_nmos ad=0.34p pd=2.68u as=0.34p ps=2.68u w=1u l=1u
.ends

.subckt sg13_hv_pmos_ZK4LW2 D0 S0 G0 D1 S1 G1 D2 S2 G2 D3 S3 G3 D4 S4 G4 D5 S5 G5
+ D6 S6 G6 D7 S7 G7 D8 S8 G8 D9 S9 G9 D10 S10 G10 D11 S11 G11 w_n2371_n224#
X0 D5 G5 S5 w_n2371_n224# sg13_hv_pmos ad=0.34p pd=2.68u as=0.34p ps=2.68u w=1u l=1u
X1 S6 G6 D6 w_n2371_n224# sg13_hv_pmos ad=0.34p pd=2.68u as=0.34p ps=2.68u w=1u l=1u
X2 S0 G0 D0 w_n2371_n224# sg13_hv_pmos ad=0.34p pd=2.68u as=0.34p ps=2.68u w=1u l=1u
X3 D11 G11 S11 w_n2371_n224# sg13_hv_pmos ad=0.34p pd=2.68u as=0.34p ps=2.68u w=1u l=1u
X4 S8 G8 D8 w_n2371_n224# sg13_hv_pmos ad=0.34p pd=2.68u as=0.34p ps=2.68u w=1u l=1u
X5 S10 G10 D10 w_n2371_n224# sg13_hv_pmos ad=0.34p pd=2.68u as=0.34p ps=2.68u w=1u l=1u
X6 D7 G7 S7 w_n2371_n224# sg13_hv_pmos ad=0.34p pd=2.68u as=0.34p ps=2.68u w=1u l=1u
X7 D9 G9 S9 w_n2371_n224# sg13_hv_pmos ad=0.34p pd=2.68u as=0.34p ps=2.68u w=1u l=1u
X8 D1 G1 S1 w_n2371_n224# sg13_hv_pmos ad=0.34p pd=2.68u as=0.34p ps=2.68u w=1u l=1u
X9 S2 G2 D2 w_n2371_n224# sg13_hv_pmos ad=0.34p pd=2.68u as=0.34p ps=2.68u w=1u l=1u
X10 D3 G3 S3 w_n2371_n224# sg13_hv_pmos ad=0.34p pd=2.68u as=0.34p ps=2.68u w=1u l=1u
X11 S4 G4 D4 w_n2371_n224# sg13_hv_pmos ad=0.34p pd=2.68u as=0.34p ps=2.68u w=1u l=1u
.ends

.subckt sg13_hv_pmos_DFT6DG D0_0 S0_0 G0_0 D0_1 S0_1 G0_1 D0_2 S0_2 G0_2 D0_3 S0_3
+ G0_3 D1_0 S1_0 G1_0 D1_1 S1_1 G1_1 D1_2 S1_2 G1_2 D1_3 S1_3 G1_3 D2_0 S2_0 G2_0
+ D2_1 S2_1 G2_1 D2_2 S2_2 G2_2 D2_3 S2_3 G2_3 D3_0 S3_0 G3_0 D3_1 S3_1 G3_1 D3_2
+ S3_2 G3_2 D3_3 S3_3 G3_3 w_n2059_n806#
X0 S0_3 G0_3 D0_3 w_n2059_n806# sg13_hv_pmos ad=0.34p pd=2.68u as=0.34p ps=2.68u w=1u l=4u
X1 S0_0 G0_0 D0_0 w_n2059_n806# sg13_hv_pmos ad=0.34p pd=2.68u as=0.34p ps=2.68u w=1u l=4u
X2 D1_0 G1_0 S1_0 w_n2059_n806# sg13_hv_pmos ad=0.34p pd=2.68u as=0.34p ps=2.68u w=1u l=4u
X3 D3_2 G3_2 S3_2 w_n2059_n806# sg13_hv_pmos ad=0.34p pd=2.68u as=0.34p ps=2.68u w=1u l=4u
X4 S2_1 G2_1 D2_1 w_n2059_n806# sg13_hv_pmos ad=0.34p pd=2.68u as=0.34p ps=2.68u w=1u l=4u
X5 D3_1 G3_1 S3_1 w_n2059_n806# sg13_hv_pmos ad=0.34p pd=2.68u as=0.34p ps=2.68u w=1u l=4u
X6 S0_2 G0_2 D0_2 w_n2059_n806# sg13_hv_pmos ad=0.34p pd=2.68u as=0.34p ps=2.68u w=1u l=4u
X7 S2_2 G2_2 D2_2 w_n2059_n806# sg13_hv_pmos ad=0.34p pd=2.68u as=0.34p ps=2.68u w=1u l=4u
X8 S0_1 G0_1 D0_1 w_n2059_n806# sg13_hv_pmos ad=0.34p pd=2.68u as=0.34p ps=2.68u w=1u l=4u
X9 D3_3 G3_3 S3_3 w_n2059_n806# sg13_hv_pmos ad=0.34p pd=2.68u as=0.34p ps=2.68u w=1u l=4u
X10 D3_0 G3_0 S3_0 w_n2059_n806# sg13_hv_pmos ad=0.34p pd=2.68u as=0.34p ps=2.68u w=1u l=4u
X11 S2_0 G2_0 D2_0 w_n2059_n806# sg13_hv_pmos ad=0.34p pd=2.68u as=0.34p ps=2.68u w=1u l=4u
X12 S2_3 G2_3 D2_3 w_n2059_n806# sg13_hv_pmos ad=0.34p pd=2.68u as=0.34p ps=2.68u w=1u l=4u
X13 D1_2 G1_2 S1_2 w_n2059_n806# sg13_hv_pmos ad=0.34p pd=2.68u as=0.34p ps=2.68u w=1u l=4u
X14 D1_1 G1_1 S1_1 w_n2059_n806# sg13_hv_pmos ad=0.34p pd=2.68u as=0.34p ps=2.68u w=1u l=4u
X15 D1_3 G1_3 S1_3 w_n2059_n806# sg13_hv_pmos ad=0.34p pd=2.68u as=0.34p ps=2.68u w=1u l=4u
.ends

.subckt sg13_hv_nmos_T2KQE3 D0 S0 G0 D1 S1 G1 D2 S2 G2 D3 S3 G3 sub
X0 S0 G0 D0 sub sg13_hv_nmos ad=0.68p pd=4.68u as=0.68p ps=4.68u w=2u l=4u
X1 S2 G2 D2 sub sg13_hv_nmos ad=0.68p pd=4.68u as=0.68p ps=4.68u w=2u l=4u
X2 S3 G3 D3 sub sg13_hv_nmos ad=0.68p pd=4.68u as=0.68p ps=4.68u w=2u l=4u
X3 S1 G1 D1 sub sg13_hv_nmos ad=0.68p pd=4.68u as=0.68p ps=4.68u w=2u l=4u
.ends

.subckt sg13_hv_nmos_TAZSE3 D0_0 S0_0 G0_0 D0_1 S0_1 G0_1 D0_2 S0_2 G0_2 D0_3 S0_3
+ G0_3 D1_0 S1_0 G1_0 D1_1 S1_1 G1_1 D1_2 S1_2 G1_2 D1_3 S1_3 G1_3 D2_0 S2_0 G2_0
+ D2_1 S2_1 G2_1 D2_2 S2_2 G2_2 D2_3 S2_3 G2_3 D3_0 S3_0 G3_0 D3_1 S3_1 G3_1 D3_2
+ S3_2 G3_2 D3_3 S3_3 G3_3 sub
X0 S0_1 G0_1 D0_1 sub sg13_hv_nmos ad=0.68p pd=4.68u as=0.68p ps=4.68u w=2u l=4u
X1 S2_0 G2_0 D2_0 sub sg13_hv_nmos ad=0.68p pd=4.68u as=0.68p ps=4.68u w=2u l=4u
X2 D3_3 G3_3 S3_3 sub sg13_hv_nmos ad=0.68p pd=4.68u as=0.68p ps=4.68u w=2u l=4u
X3 S2_3 G2_3 D2_3 sub sg13_hv_nmos ad=0.68p pd=4.68u as=0.68p ps=4.68u w=2u l=4u
X4 D1_0 G1_0 S1_0 sub sg13_hv_nmos ad=0.68p pd=4.68u as=0.68p ps=4.68u w=2u l=4u
X5 D1_1 G1_1 S1_1 sub sg13_hv_nmos ad=0.68p pd=4.68u as=0.68p ps=4.68u w=2u l=4u
X6 D1_3 G1_3 S1_3 sub sg13_hv_nmos ad=0.68p pd=4.68u as=0.68p ps=4.68u w=2u l=4u
X7 D3_2 G3_2 S3_2 sub sg13_hv_nmos ad=0.68p pd=4.68u as=0.68p ps=4.68u w=2u l=4u
X8 S0_3 G0_3 D0_3 sub sg13_hv_nmos ad=0.68p pd=4.68u as=0.68p ps=4.68u w=2u l=4u
X9 S0_2 G0_2 D0_2 sub sg13_hv_nmos ad=0.68p pd=4.68u as=0.68p ps=4.68u w=2u l=4u
X10 S0_0 G0_0 D0_0 sub sg13_hv_nmos ad=0.68p pd=4.68u as=0.68p ps=4.68u w=2u l=4u
X11 S2_2 G2_2 D2_2 sub sg13_hv_nmos ad=0.68p pd=4.68u as=0.68p ps=4.68u w=2u l=4u
X12 D3_0 G3_0 S3_0 sub sg13_hv_nmos ad=0.68p pd=4.68u as=0.68p ps=4.68u w=2u l=4u
X13 S2_1 G2_1 D2_1 sub sg13_hv_nmos ad=0.68p pd=4.68u as=0.68p ps=4.68u w=2u l=4u
X14 D3_1 G3_1 S3_1 sub sg13_hv_nmos ad=0.68p pd=4.68u as=0.68p ps=4.68u w=2u l=4u
X15 D1_2 G1_2 S1_2 sub sg13_hv_nmos ad=0.68p pd=4.68u as=0.68p ps=4.68u w=2u l=4u
.ends

.subckt sg13_hv_pmos_NQD9LU D0_0 S0_0 G0_0 D0_1 S0_1 G0_1 D1_0 S1_0 G1_0 D1_1 S1_1
+ G1_1 D2_0 S2_0 G2_0 D2_1 S2_1 G2_1 D3_0 S3_0 G3_0 D3_1 S3_1 G3_1 D4_0 S4_0 G4_0
+ D4_1 S4_1 G4_1 D5_0 S5_0 G5_0 D5_1 S5_1 G5_1 D6_0 S6_0 G6_0 D6_1 S6_1 G6_1 D7_0
+ S7_0 G7_0 D7_1 S7_1 G7_1 w_n1615_n418#
X0 S6_0 G6_0 D6_0 w_n1615_n418# sg13_hv_pmos ad=0.34p pd=2.68u as=0.34p ps=2.68u w=1u l=1u
X1 D5_1 G5_1 S5_1 w_n1615_n418# sg13_hv_pmos ad=0.34p pd=2.68u as=0.34p ps=2.68u w=1u l=1u
X2 S2_1 G2_1 D2_1 w_n1615_n418# sg13_hv_pmos ad=0.34p pd=2.68u as=0.34p ps=2.68u w=1u l=1u
X3 D7_0 G7_0 S7_0 w_n1615_n418# sg13_hv_pmos ad=0.34p pd=2.68u as=0.34p ps=2.68u w=1u l=1u
X4 D1_1 G1_1 S1_1 w_n1615_n418# sg13_hv_pmos ad=0.34p pd=2.68u as=0.34p ps=2.68u w=1u l=1u
X5 D7_1 G7_1 S7_1 w_n1615_n418# sg13_hv_pmos ad=0.34p pd=2.68u as=0.34p ps=2.68u w=1u l=1u
X6 D3_1 G3_1 S3_1 w_n1615_n418# sg13_hv_pmos ad=0.34p pd=2.68u as=0.34p ps=2.68u w=1u l=1u
X7 D3_0 G3_0 S3_0 w_n1615_n418# sg13_hv_pmos ad=0.34p pd=2.68u as=0.34p ps=2.68u w=1u l=1u
X8 S4_0 G4_0 D4_0 w_n1615_n418# sg13_hv_pmos ad=0.34p pd=2.68u as=0.34p ps=2.68u w=1u l=1u
X9 S2_0 G2_0 D2_0 w_n1615_n418# sg13_hv_pmos ad=0.34p pd=2.68u as=0.34p ps=2.68u w=1u l=1u
X10 S4_1 G4_1 D4_1 w_n1615_n418# sg13_hv_pmos ad=0.34p pd=2.68u as=0.34p ps=2.68u w=1u l=1u
X11 S6_1 G6_1 D6_1 w_n1615_n418# sg13_hv_pmos ad=0.34p pd=2.68u as=0.34p ps=2.68u w=1u l=1u
X12 D1_0 G1_0 S1_0 w_n1615_n418# sg13_hv_pmos ad=0.34p pd=2.68u as=0.34p ps=2.68u w=1u l=1u
X13 D5_0 G5_0 S5_0 w_n1615_n418# sg13_hv_pmos ad=0.34p pd=2.68u as=0.34p ps=2.68u w=1u l=1u
X14 S0_1 G0_1 D0_1 w_n1615_n418# sg13_hv_pmos ad=0.34p pd=2.68u as=0.34p ps=2.68u w=1u l=1u
X15 S0_0 G0_0 D0_0 w_n1615_n418# sg13_hv_pmos ad=0.34p pd=2.68u as=0.34p ps=2.68u w=1u l=1u
.ends

.subckt sg13_hv_pmos_V3Q6DG D0 S0 G0 D1 S1 G1 D2 S2 G2 D3 S3 G3 w_n592_n806#
X0 S0 G0 D0 w_n592_n806# sg13_hv_pmos ad=0.34p pd=2.68u as=0.34p ps=2.68u w=1u l=4u
X1 S2 G2 D2 w_n592_n806# sg13_hv_pmos ad=0.34p pd=2.68u as=0.34p ps=2.68u w=1u l=4u
X2 S3 G3 D3 w_n592_n806# sg13_hv_pmos ad=0.34p pd=2.68u as=0.34p ps=2.68u w=1u l=4u
X3 S1 G1 D1 w_n592_n806# sg13_hv_pmos ad=0.34p pd=2.68u as=0.34p ps=2.68u w=1u l=4u
.ends

.subckt sg13_hv_pmos_NED9LU D0_0 S0_0 G0_0 D0_1 S0_1 G0_1 D1_0 S1_0 G1_0 D1_1 S1_1
+ G1_1 D2_0 S2_0 G2_0 D2_1 S2_1 G2_1 D3_0 S3_0 G3_0 D3_1 S3_1 G3_1 w_n859_n1018#
X0 D3_0 G3_0 S3_0 w_n859_n1018# sg13_hv_pmos ad=1.36p pd=8.68u as=1.36p ps=8.68u w=4u l=1u
X1 D3_1 G3_1 S3_1 w_n859_n1018# sg13_hv_pmos ad=1.36p pd=8.68u as=1.36p ps=8.68u w=4u l=1u
X2 S0_1 G0_1 D0_1 w_n859_n1018# sg13_hv_pmos ad=1.36p pd=8.68u as=1.36p ps=8.68u w=4u l=1u
X3 D1_1 G1_1 S1_1 w_n859_n1018# sg13_hv_pmos ad=1.36p pd=8.68u as=1.36p ps=8.68u w=4u l=1u
X4 D1_0 G1_0 S1_0 w_n859_n1018# sg13_hv_pmos ad=1.36p pd=8.68u as=1.36p ps=8.68u w=4u l=1u
X5 S2_0 G2_0 D2_0 w_n859_n1018# sg13_hv_pmos ad=1.36p pd=8.68u as=1.36p ps=8.68u w=4u l=1u
X6 S2_1 G2_1 D2_1 w_n859_n1018# sg13_hv_pmos ad=1.36p pd=8.68u as=1.36p ps=8.68u w=4u l=1u
X7 S0_0 G0_0 D0_0 w_n859_n1018# sg13_hv_pmos ad=1.36p pd=8.68u as=1.36p ps=8.68u w=4u l=1u
.ends

.subckt sg13_hv_nmos_BENXUZ D0_0 S0_0 G0_0 D0_1 S0_1 G0_1 D1_0 S1_0 G1_0 D1_1 S1_1
+ G1_1 D2_0 S2_0 G2_0 D2_1 S2_1 G2_1 D3_0 S3_0 G3_0 D3_1 S3_1 G3_1 sub
X0 D3_1 G3_1 S3_1 sub sg13_hv_nmos ad=0.68p pd=4.68u as=0.68p ps=4.68u w=2u l=1u
X1 S0_1 G0_1 D0_1 sub sg13_hv_nmos ad=0.68p pd=4.68u as=0.68p ps=4.68u w=2u l=1u
X2 D3_0 G3_0 S3_0 sub sg13_hv_nmos ad=0.68p pd=4.68u as=0.68p ps=4.68u w=2u l=1u
X3 D1_1 G1_1 S1_1 sub sg13_hv_nmos ad=0.68p pd=4.68u as=0.68p ps=4.68u w=2u l=1u
X4 S2_1 G2_1 D2_1 sub sg13_hv_nmos ad=0.68p pd=4.68u as=0.68p ps=4.68u w=2u l=1u
X5 S2_0 G2_0 D2_0 sub sg13_hv_nmos ad=0.68p pd=4.68u as=0.68p ps=4.68u w=2u l=1u
X6 D1_0 G1_0 S1_0 sub sg13_hv_nmos ad=0.68p pd=4.68u as=0.68p ps=4.68u w=2u l=1u
X7 S0_0 G0_0 D0_0 sub sg13_hv_nmos ad=0.68p pd=4.68u as=0.68p ps=4.68u w=2u l=1u
.ends

.subckt capacitor_W9X9FK sub c1 c2
X0 c1 c2 cap_cmomf mm_ok=1 subblock=1 mmax=4 mmin=1 l=15.5u w=35.317u
.ends

.subckt sg13_hv_nmos_QMKJVU D S G sub
X0 S G D sub sg13_hv_nmos ad=1.36p pd=8.68u as=1.36p ps=8.68u w=4u l=0.45u
.ends

.subckt sg13_hv_nmos_XAS6UC D0_0 S0_0 G0_0 D0_1 S0_1 G0_1 D1_0 S1_0 G1_0 D1_1 S1_1
+ G1_1 D2_0 S2_0 G2_0 D2_1 S2_1 G2_1 D3_0 S3_0 G3_0 D3_1 S3_1 G3_1 D4_0 S4_0 G4_0
+ D4_1 S4_1 G4_1 D5_0 S5_0 G5_0 D5_1 S5_1 G5_1 D6_0 S6_0 G6_0 D6_1 S6_1 G6_1 D7_0
+ S7_0 G7_0 D7_1 S7_1 G7_1 D8_0 S8_0 G8_0 D8_1 S8_1 G8_1 D9_0 S9_0 G9_0 D9_1 S9_1
+ G9_1 D10_0 S10_0 G10_0 D10_1 S10_1 G10_1 D11_0 S11_0 G11_0 D11_1 S11_1 G11_1 sub
X0 S0_1 G0_1 D0_1 sub sg13_hv_nmos ad=0.34p pd=2.68u as=0.34p ps=2.68u w=1u l=1u
X1 D7_1 G7_1 S7_1 sub sg13_hv_nmos ad=0.34p pd=2.68u as=0.34p ps=2.68u w=1u l=1u
X2 S4_1 G4_1 D4_1 sub sg13_hv_nmos ad=0.34p pd=2.68u as=0.34p ps=2.68u w=1u l=1u
X3 D9_0 G9_0 S9_0 sub sg13_hv_nmos ad=0.34p pd=2.68u as=0.34p ps=2.68u w=1u l=1u
X4 D3_1 G3_1 S3_1 sub sg13_hv_nmos ad=0.34p pd=2.68u as=0.34p ps=2.68u w=1u l=1u
X5 D11_1 G11_1 S11_1 sub sg13_hv_nmos ad=0.34p pd=2.68u as=0.34p ps=2.68u w=1u l=1u
X6 S10_0 G10_0 D10_0 sub sg13_hv_nmos ad=0.34p pd=2.68u as=0.34p ps=2.68u w=1u l=1u
X7 D9_1 G9_1 S9_1 sub sg13_hv_nmos ad=0.34p pd=2.68u as=0.34p ps=2.68u w=1u l=1u
X8 S6_0 G6_0 D6_0 sub sg13_hv_nmos ad=0.34p pd=2.68u as=0.34p ps=2.68u w=1u l=1u
X9 D11_0 G11_0 S11_0 sub sg13_hv_nmos ad=0.34p pd=2.68u as=0.34p ps=2.68u w=1u l=1u
X10 D5_1 G5_1 S5_1 sub sg13_hv_nmos ad=0.34p pd=2.68u as=0.34p ps=2.68u w=1u l=1u
X11 D5_0 G5_0 S5_0 sub sg13_hv_nmos ad=0.34p pd=2.68u as=0.34p ps=2.68u w=1u l=1u
X12 S0_0 G0_0 D0_0 sub sg13_hv_nmos ad=0.34p pd=2.68u as=0.34p ps=2.68u w=1u l=1u
X13 S4_0 G4_0 D4_0 sub sg13_hv_nmos ad=0.34p pd=2.68u as=0.34p ps=2.68u w=1u l=1u
X14 D1_1 G1_1 S1_1 sub sg13_hv_nmos ad=0.34p pd=2.68u as=0.34p ps=2.68u w=1u l=1u
X15 S6_1 G6_1 D6_1 sub sg13_hv_nmos ad=0.34p pd=2.68u as=0.34p ps=2.68u w=1u l=1u
X16 S8_1 G8_1 D8_1 sub sg13_hv_nmos ad=0.34p pd=2.68u as=0.34p ps=2.68u w=1u l=1u
X17 D3_0 G3_0 S3_0 sub sg13_hv_nmos ad=0.34p pd=2.68u as=0.34p ps=2.68u w=1u l=1u
X18 D7_0 G7_0 S7_0 sub sg13_hv_nmos ad=0.34p pd=2.68u as=0.34p ps=2.68u w=1u l=1u
X19 S2_0 G2_0 D2_0 sub sg13_hv_nmos ad=0.34p pd=2.68u as=0.34p ps=2.68u w=1u l=1u
X20 S2_1 G2_1 D2_1 sub sg13_hv_nmos ad=0.34p pd=2.68u as=0.34p ps=2.68u w=1u l=1u
X21 S10_1 G10_1 D10_1 sub sg13_hv_nmos ad=0.34p pd=2.68u as=0.34p ps=2.68u w=1u l=1u
X22 D1_0 G1_0 S1_0 sub sg13_hv_nmos ad=0.34p pd=2.68u as=0.34p ps=2.68u w=1u l=1u
X23 S8_0 G8_0 D8_0 sub sg13_hv_nmos ad=0.34p pd=2.68u as=0.34p ps=2.68u w=1u l=1u
.ends

.subckt sg13_hv_nmos_2G82VR D0_0 S0_0 G0_0 D0_1 S0_1 G0_1 D1_0 S1_0 G1_0 D1_1 S1_1
+ G1_1 sub
X0 S0_0 G0_0 D0_0 sub sg13_hv_nmos ad=1.36p pd=8.68u as=1.36p ps=8.68u w=4u l=4u
X1 D1_0 G1_0 S1_0 sub sg13_hv_nmos ad=1.36p pd=8.68u as=1.36p ps=8.68u w=4u l=4u
X2 D1_1 G1_1 S1_1 sub sg13_hv_nmos ad=1.36p pd=8.68u as=1.36p ps=8.68u w=4u l=4u
X3 S0_1 G0_1 D0_1 sub sg13_hv_nmos ad=1.36p pd=8.68u as=1.36p ps=8.68u w=4u l=4u
.ends

.subckt se_folded_cascode_np_ab vdd out inp vss bias ena inn
XXMOP out vdd XM9/S3_2 out vdd XM9/S3_2 vdd out XM9/S3_2 vdd out XM9/S3_2 vdd sg13_hv_pmos_QWE845
Xsg13_hv_pmos_FJG4RK_0 vdd bias ena vdd sg13_hv_pmos_FJG4RK
Xsg13_hv_pmos_MLH6U9_0 XM9/S3_2 vdd ena vdd sg13_hv_pmos_MLH6U9
Xsg13_hv_nmos_BEHQUZ_0 vss vss vss vss vss vss vss vss vss vss vss vss vss vss vss
+ vss vss vss vss vss vss vss vss vss vss sg13_hv_nmos_BEHQUZ
Xsg13_hv_nmos_BEZCVZ_0 vss vss vss vss vss vss vss vss vss vss vss vss vss sg13_hv_nmos_BEZCVZ
XXM4 vdd outa1n outa1n outa1p vdd outa1n vdd outa1n outa1n outa1p vdd outa1n vdd outa1n
+ outa1n outa1p vdd outa1n vdd outa1n outa1n outa1p vdd outa1n vdd outa1n outa1n outa1p
+ vdd outa1n vdd outa1n outa1n outa1p vdd outa1n vdd sg13_hv_pmos_ZK4LW2
XXM5 vdd outa1n outa1n outa1p vdd outa1n vdd outa1n outa1n outa1p vdd outa1n vdd outa1n
+ outa1n outa1p vdd outa1n vdd outa1n outa1n outa1p vdd outa1n vdd outa1n outa1n outa1p
+ vdd outa1n vdd outa1n outa1n outa1p vdd outa1n vdd sg13_hv_pmos_ZK4LW2
XXM6 XM9/S3_2 outa1p XM9/S3_3 outa1n XM9/S3_3 XM9/S3_3 XM9/S3_2 outa1p XM9/S3_3 outa1n
+ XM9/S3_3 XM9/S3_3 XM9/S3_3 outa1n XM9/S3_3 outa1p XM9/S3_2 XM9/S3_3 XM9/S3_3 outa1n
+ XM9/S3_3 outa1p XM9/S3_2 XM9/S3_3 XM9/S3_2 outa1p XM9/S3_3 outa1n XM9/S3_3 XM9/S3_3
+ XM9/S3_2 outa1p XM9/S3_3 outa1n XM9/S3_3 XM9/S3_3 XM9/S3_3 outa1n XM9/S3_3 outa1p
+ XM9/S3_2 XM9/S3_3 XM9/S3_3 outa1n XM9/S3_3 outa1p XM9/S3_2 XM9/S3_3 vdd sg13_hv_pmos_DFT6DG
XXM7 XM9/S3_2 outa1p XM9/S3_3 outa1n XM9/S3_3 XM9/S3_3 XM9/S3_2 outa1p XM9/S3_3 outa1n
+ XM9/S3_3 XM9/S3_3 XM9/S3_3 outa1n XM9/S3_3 outa1p XM9/S3_2 XM9/S3_3 XM9/S3_3 outa1n
+ XM9/S3_3 outa1p XM9/S3_2 XM9/S3_3 XM9/S3_2 outa1p XM9/S3_3 outa1n XM9/S3_3 XM9/S3_3
+ XM9/S3_2 outa1p XM9/S3_3 outa1n XM9/S3_3 XM9/S3_3 XM9/S3_3 outa1n XM9/S3_3 outa1p
+ XM9/S3_2 XM9/S3_3 XM9/S3_3 outa1n XM9/S3_3 outa1p XM9/S3_2 XM9/S3_3 vdd sg13_hv_pmos_DFT6DG
XXMB1 vbn1 vbn2 vbn2 vbn1 vbn2 vbn2 vbn1 vbn2 vbn2 vbn1 vbn2 vbn2 vss sg13_hv_nmos_T2KQE3
XXM8 XM9/S3_3 outb1n vbn2 XM9/S3_2 outb1p vbn2 XM9/S3_3 outb1n vbn2 XM9/S3_2 outb1p
+ vbn2 outb1p XM9/S3_2 vbn2 outb1n XM9/S3_3 vbn2 outb1p XM9/S3_2 vbn2 outb1n XM9/S3_3
+ vbn2 XM9/S3_3 outb1n vbn2 XM9/S3_2 outb1p vbn2 XM9/S3_3 outb1n vbn2 XM9/S3_2 outb1p
+ vbn2 outb1p XM9/S3_2 vbn2 outb1n XM9/S3_3 vbn2 outb1p XM9/S3_2 vbn2 outb1n XM9/S3_3
+ vbn2 vss sg13_hv_nmos_TAZSE3
XXMB2 vss vbn1 vbn1 vbn1 vss vbn1 vss vbn1 vbn1 vbn1 vss vbn1 vss sg13_hv_nmos_BEZCVZ
XXMIP1 vdd diffb vbp1 vdd diffb vbp1 diffb vdd vbp1 diffb vdd vbp1 vdd diffb vbp1
+ vdd diffb vbp1 diffb vdd vbp1 diffb vdd vbp1 vdd diffb vbp1 vdd diffb vbp1 diffb
+ vdd vbp1 diffb vdd vbp1 vdd diffb vbp1 vdd diffb vbp1 diffb vdd vbp1 diffb vdd vbp1
+ vdd sg13_hv_pmos_NQD9LU
XXM9 XM9/S3_3 outb1n vbn2 XM9/S3_2 outb1p vbn2 XM9/S3_3 outb1n vbn2 XM9/S3_2 outb1p
+ vbn2 outb1p XM9/S3_2 vbn2 outb1n XM9/S3_3 vbn2 outb1p XM9/S3_2 vbn2 outb1n XM9/S3_3
+ vbn2 XM9/S3_3 outb1n vbn2 XM9/S3_2 outb1p vbn2 XM9/S3_3 outb1n vbn2 XM9/S3_2 outb1p
+ vbn2 outb1p XM9/S3_2 vbn2 outb1n XM9/S3_3 vbn2 outb1p XM9/S3_2 vbn2 outb1n XM9/S3_3
+ vbn2 vss sg13_hv_nmos_TAZSE3
XXMB3 vdd vdd vdd vdd vdd vdd vdd vdd vdd vdd vdd vdd vdd sg13_hv_pmos_V3Q6DG
XXMIP2 outb1n diffb inn outb1p diffb inp diffb outb1p inp diffb outb1n inn outb1n
+ diffb inn outb1p diffb inp diffb outb1p inp diffb outb1n inn vdd sg13_hv_pmos_NED9LU
XXMB4 vbp1 bias bias vbp1 bias bias vbp1 bias bias vbp1 bias bias vdd sg13_hv_pmos_V3Q6DG
XXMIP3 outb1n diffb inn outb1p diffb inp diffb outb1p inp diffb outb1n inn outb1n
+ diffb inn outb1p diffb inp diffb outb1p inp diffb outb1n inn vdd sg13_hv_pmos_NED9LU
XXMIN1 vss diffa vbn1 diffa vss vbn1 vss diffa vbn1 diffa vss vbn1 vss diffa vbn1
+ diffa vss vbn1 vss diffa vbn1 diffa vss vbn1 vss sg13_hv_nmos_BEHQUZ
XXMB5 vdd vbn2 vbp1 vbp1 vdd vbp1 vdd vbn2 vbp1 vbp1 vdd vbp1 vdd sg13_hv_pmos_NQUDLU
XXMIN2 outa1n diffa inn outa1p diffa inp diffa outa1p inp diffa outa1n inn outa1n
+ diffa inn outa1p diffa inp diffa outa1p inp diffa outa1n inn vss sg13_hv_nmos_BENXUZ
XXMB6 vdd vbn2 vbp1 vbp1 vdd vbp1 vdd vbn2 vbp1 vbp1 vdd vbp1 vdd sg13_hv_pmos_NQUDLU
XXMIN3 outa1n diffa inn outa1p diffa inp diffa outa1p inp diffa outa1n inn outa1n
+ diffa inn outa1p diffa inp diffa outa1p inp diffa outa1n inn vss sg13_hv_nmos_BENXUZ
XC1[1] vss XM9/S3_2 out capacitor_W9X9FK
XC1[0] vss XM9/S3_2 out capacitor_W9X9FK
Xsg13_hv_nmos_QMKJVU_0 vss XMON/S0_1 ena vss sg13_hv_nmos_QMKJVU
Xsg13_hv_nmos_QMKJVU_1 vss XMON/S0_1 ena vss sg13_hv_nmos_QMKJVU
Xsg13_hv_nmos_QMKJVU_2 vss XMON/S0_1 ena vss sg13_hv_nmos_QMKJVU
XXM10 vss outb1p vbn1 vss outb1p vbn1 outb1n vss vbn1 outb1n vss vbn1 vss outb1p vbn1
+ vss outb1p vbn1 outb1n vss vbn1 outb1n vss vbn1 vss outb1p vbn1 vss outb1p vbn1
+ outb1n vss vbn1 outb1n vss vbn1 vss outb1p vbn1 vss outb1p vbn1 outb1n vss vbn1
+ outb1n vss vbn1 vss outb1p vbn1 vss outb1p vbn1 outb1n vss vbn1 outb1n vss vbn1
+ vss outb1p vbn1 vss outb1p vbn1 outb1n vss vbn1 outb1n vss vbn1 vss sg13_hv_nmos_XAS6UC
XXMON out XMON/S0_1 XM9/S3_2 out XMON/S0_1 XM9/S3_2 XMON/S0_1 out XM9/S3_2 XMON/S0_1
+ out XM9/S3_2 vss sg13_hv_nmos_2G82VR
Xsg13_hv_nmos_T2KQE3_0 vss vss vbn2 vss vss vbn2 vss vss vbn2 vss vss vbn2 vss sg13_hv_nmos_T2KQE3
Xsg13_hv_nmos_QMKJVU_3 vss XMON/S0_1 ena vss sg13_hv_nmos_QMKJVU
XXM11 vss outb1p vbn1 vss outb1p vbn1 outb1n vss vbn1 outb1n vss vbn1 vss outb1p vbn1
+ vss outb1p vbn1 outb1n vss vbn1 outb1n vss vbn1 vss outb1p vbn1 vss outb1p vbn1
+ outb1n vss vbn1 outb1n vss vbn1 vss outb1p vbn1 vss outb1p vbn1 outb1n vss vbn1
+ outb1n vss vbn1 vss outb1p vbn1 vss outb1p vbn1 outb1n vss vbn1 outb1n vss vbn1
+ vss outb1p vbn1 vss outb1p vbn1 outb1n vss vbn1 outb1n vss vbn1 vss sg13_hv_nmos_XAS6UC
.ends

.subckt sg13cmos5l_ocd_ip__classab_buffer inp ena bias out vss vdd
Xse_folded_cascode_np_ab_0 vdd out inp vss bias ena out se_folded_cascode_np_ab
.ends

.subckt pnpMPA_9DZCCL C B E
X0 C B E pnpMPA a=1.4p p=5.4u
.ends

.subckt rhigh_SUDY2Y R1 R2 sub
X0 R1 R2 sub rhigh l=20u w=0.69u
.ends

.subckt bg_res b a d c vss e f g h j k XR1[20]/R1 XR1[14]/R2 XR1[8]/R1 XR1[9]/R2 XR1[15]/R1
+ XR1[6]/R2 XR1[12]/R1 XR1[3]/R1 XR1[17]/R2 XR1[19]/R1 XR1[8]/R2 XR1[16]/R1 XR1[5]/R2
+ XR1[9]/R1 XR1[13]/R2 XR1[7]/R1 XR1[4]/R1 XR1[18]/R2
XXR1[0] k j vss rhigh_SUDY2Y
XXR1[1] XR1[3]/R1 a vss rhigh_SUDY2Y
XXR1[2] XR1[4]/R1 b vss rhigh_SUDY2Y
XXR1[3] XR1[3]/R1 XR1[5]/R2 vss rhigh_SUDY2Y
XXR1[4] XR1[4]/R1 XR1[6]/R2 vss rhigh_SUDY2Y
XXR1[5] XR1[7]/R1 XR1[5]/R2 vss rhigh_SUDY2Y
XXR1[6] XR1[8]/R1 XR1[6]/R2 vss rhigh_SUDY2Y
XXR1[7] XR1[7]/R1 XR1[9]/R2 vss rhigh_SUDY2Y
XXR1[8] XR1[8]/R1 XR1[8]/R2 vss rhigh_SUDY2Y
XXR1[9] XR1[9]/R1 XR1[9]/R2 vss rhigh_SUDY2Y
XXR1[10] XR1[12]/R1 XR1[8]/R2 vss rhigh_SUDY2Y
XXR1[11] XR1[9]/R1 XR1[13]/R2 vss rhigh_SUDY2Y
XXR1[12] XR1[12]/R1 XR1[14]/R2 vss rhigh_SUDY2Y
XXR1[13] XR1[15]/R1 XR1[13]/R2 vss rhigh_SUDY2Y
XXR1[14] XR1[16]/R1 XR1[14]/R2 vss rhigh_SUDY2Y
XXR1[15] XR1[15]/R1 XR1[17]/R2 vss rhigh_SUDY2Y
XXR1[16] XR1[16]/R1 XR1[18]/R2 vss rhigh_SUDY2Y
XXR1[17] XR1[19]/R1 XR1[17]/R2 vss rhigh_SUDY2Y
XXR1[18] XR1[20]/R1 XR1[18]/R2 vss rhigh_SUDY2Y
XXR1[19] XR1[19]/R1 c vss rhigh_SUDY2Y
XXR1[20] XR1[20]/R1 d vss rhigh_SUDY2Y
XXR1[21] f e vss rhigh_SUDY2Y
XXR1[22] h g vss rhigh_SUDY2Y
.ends

.subckt sg13_hv_pmos_NWA9LU D0 S0 G0 D1 S1 G1 w_n481_n524#
X0 D1 G1 S1 w_n481_n524# sg13_hv_pmos ad=1.36p pd=8.68u as=1.36p ps=8.68u w=4u l=1u
X1 S0 G0 D0 w_n481_n524# sg13_hv_pmos ad=1.36p pd=8.68u as=1.36p ps=8.68u w=4u l=1u
.ends

.subckt sg13_hv_nmos_BEVMZW D S G sub
X0 S G D sub sg13_hv_nmos ad=0.34p pd=2.68u as=0.34p ps=2.68u w=1u l=1u
.ends

.subckt sg13_hv_pmos_WYN5QB D S G w_n292_n224#
X0 S G D w_n292_n224# sg13_hv_pmos ad=0.34p pd=2.68u as=0.34p ps=2.68u w=1u l=1u
.ends

.subckt capacitor_UEBLR3 c1 c2
X0 c1 c2 cap_cmomf mm_ok=1 subblock=0 mmax=4 mmin=1 l=26.749u w=48u
.ends

.subckt capacitor_77YAAU c1 c2
X0 c1 c2 cap_cmomf mm_ok=1 subblock=0 mmax=4 mmin=1 l=20u w=20u
.ends

.subckt capacitor_C4E5CZ c1 c2
X0 c1 c2 cap_cmomf mm_ok=1 subblock=0 mmax=4 mmin=1 l=7u w=13.7u
.ends

.subckt sg13_hv_nmos_2UD3QN D S G sub
X0 S G D sub sg13_hv_nmos ad=0.68p pd=4.68u as=0.68p ps=4.68u w=2u l=0.5u
.ends

.subckt rppd_Y8MW75 R1 R2 sub
X0 R1 R2 sub rppd l=3.4u w=1.41u
.ends

.subckt bg_trim top bot ctrl[15] ctrl[14] ctrl[13] ctrl[12] ctrl[11] ctrl[10] ctrl[9]
+ ctrl[8] ctrl[7] ctrl[6] ctrl[5] ctrl[4] ctrl[3] ctrl[2] ctrl[1] ctrl[0] m1_13078_n9645#
+ m1_13078_n10923# m1_8992_n8367# m1_8992_n10284# m1_13078_n8793# m1_8992_n9006# m1_13078_n9432#
+ m1_13078_n10710# m1_8992_n11988# m1_8992_n10071# m1_13078_n8580# m1_8992_n12627#
+ m1_8992_n9858# m1_8992_n11775# m1_8992_n12414# m1_8992_n9645# m1_8992_n11562# m1_8992_n8793#
+ m1_8992_n12201# m1_8992_n9432# m1_8992_n8580# m1_8992_n12840# m1_8992_n10923# m1_8992_n10710#
+ m1_13078_n11349# m1_13078_n13053# m1_13078_n10497# m1_13078_n11136# m1_13078_n10284#
+ m1_13078_n11988# m1_13078_n10071# m1_13078_n12627# m1_13078_n11775# m1_13078_n12414#
+ m1_13078_n11562# m1_13078_n9219# m1_13078_n12201# m1_13078_n8367# vss m1_13078_n9006#
+ m1_8992_n11349# m1_13078_n9858# m1_8992_n13053# m1_8992_n10497# m1_13078_n12840#
+ m1_8992_n11136# m1_8992_n9219#
XXM0[0] vss vss vss vss sg13_hv_nmos_2UD3QN
XXM0[1] bot XM0[1]/S ctrl[0] vss sg13_hv_nmos_2UD3QN
XXM0[2] bot XM0[2]/S ctrl[1] vss sg13_hv_nmos_2UD3QN
XXM0[3] bot XM0[3]/S ctrl[2] vss sg13_hv_nmos_2UD3QN
XXM0[4] bot XM0[4]/S ctrl[3] vss sg13_hv_nmos_2UD3QN
XXM0[5] bot XM0[5]/S ctrl[4] vss sg13_hv_nmos_2UD3QN
XXM0[6] bot XM0[6]/S ctrl[5] vss sg13_hv_nmos_2UD3QN
XXM0[7] bot XM0[7]/S ctrl[6] vss sg13_hv_nmos_2UD3QN
XXM0[8] bot XM0[8]/S ctrl[7] vss sg13_hv_nmos_2UD3QN
XXM0[9] bot XM0[9]/S ctrl[8] vss sg13_hv_nmos_2UD3QN
XXM0[10] bot XM0[10]/S ctrl[9] vss sg13_hv_nmos_2UD3QN
XXM0[11] bot XM0[11]/S ctrl[10] vss sg13_hv_nmos_2UD3QN
XXM0[12] bot XM0[12]/S ctrl[11] vss sg13_hv_nmos_2UD3QN
XXM0[13] bot XM0[13]/S ctrl[12] vss sg13_hv_nmos_2UD3QN
XXM0[14] bot XM0[14]/S ctrl[13] vss sg13_hv_nmos_2UD3QN
XXM0[15] bot XM0[15]/S ctrl[14] vss sg13_hv_nmos_2UD3QN
XXM0[16] bot top ctrl[15] vss sg13_hv_nmos_2UD3QN
XXM0[17] vss vss vss vss sg13_hv_nmos_2UD3QN
Xrppd_Y8MW75_0[0] vss vss vss rppd_Y8MW75
Xrppd_Y8MW75_0[1] XM0[1]/S bot vss rppd_Y8MW75
Xrppd_Y8MW75_0[2] XM0[2]/S XM0[1]/S vss rppd_Y8MW75
Xrppd_Y8MW75_0[3] XM0[3]/S XM0[2]/S vss rppd_Y8MW75
Xrppd_Y8MW75_0[4] XM0[4]/S XM0[3]/S vss rppd_Y8MW75
Xrppd_Y8MW75_0[5] XM0[5]/S XM0[4]/S vss rppd_Y8MW75
Xrppd_Y8MW75_0[6] XM0[6]/S XM0[5]/S vss rppd_Y8MW75
Xrppd_Y8MW75_0[7] XM0[7]/S XM0[6]/S vss rppd_Y8MW75
Xrppd_Y8MW75_0[8] XM0[8]/S XM0[7]/S vss rppd_Y8MW75
Xrppd_Y8MW75_0[9] XM0[9]/S XM0[8]/S vss rppd_Y8MW75
Xrppd_Y8MW75_0[10] XM0[10]/S XM0[9]/S vss rppd_Y8MW75
Xrppd_Y8MW75_0[11] XM0[11]/S XM0[10]/S vss rppd_Y8MW75
Xrppd_Y8MW75_0[12] XM0[12]/S XM0[11]/S vss rppd_Y8MW75
Xrppd_Y8MW75_0[13] XM0[13]/S XM0[12]/S vss rppd_Y8MW75
Xrppd_Y8MW75_0[14] XM0[14]/S XM0[13]/S vss rppd_Y8MW75
Xrppd_Y8MW75_0[15] XM0[15]/S XM0[14]/S vss rppd_Y8MW75
Xrppd_Y8MW75_0[16] top XM0[15]/S vss rppd_Y8MW75
Xrppd_Y8MW75_0[17] top top vss rppd_Y8MW75
.ends

.subckt capacitor_P4YBHP c1 c2
X0 c1 c2 cap_cmomf mm_ok=1 subblock=0 mmax=4 mmin=1 l=16.1u w=12.35u
.ends

.subckt capacitor_4HNWC9 c1 c2
X0 c1 c2 cap_cmomf mm_ok=1 subblock=0 mmax=4 mmin=1 l=10.8u w=21.6u
.ends

.subckt bandgap_unbuffered_v2 vbg bias trim[15] trim[14] trim[13] trim[12] trim[11]
+ trim[10] trim[9] trim[8] trim[7] trim[6] trim[5] trim[4] trim[3] trim[2] trim[1]
+ trim[0] ena ena_h XM4/S dvdd dvss vss vdd
Xsg13cmos5l_antennanp_16 ena dvdd dvss sg13cmos5l_antennanp
XXQ2_1 vss vss xtr/bot pnpMPA_9DZCCL
Xx1[0] x1[0]/in_n ena ena_h vss vdd level_shift
Xx1[1] x1[1]/in_n trim[15] x1[1]/out vss vdd level_shift
Xx1[2] x1[2]/in_n trim[13] x1[2]/out vss vdd level_shift
Xx1[3] x1[3]/in_n trim[11] x1[3]/out vss vdd level_shift
Xx1[4] x1[4]/in_n trim[9] x1[4]/out vss vdd level_shift
Xx1[5] x1[5]/in_n trim[7] x1[5]/out vss vdd level_shift
Xx1[6] x1[6]/in_n trim[5] x1[6]/out vss vdd level_shift
Xx1[7] x1[7]/in_n trim[3] x1[7]/out vss vdd level_shift
Xx1[8] x1[8]/in_n trim[1] x1[8]/out vss vdd level_shift
Xxamp XM4/S bias ena_h XQ1/E xres/e vdd vss se_folded_cascode_p
Xsg13cmos5l_inv_2_0 x1[1]/in_n trim[15] dvdd dvss sg13cmos5l_inv_2
XXQ2_2 vss vss xtr/bot pnpMPA_9DZCCL
Xsg13cmos5l_inv_2_1 sg13cmos5l_inv_2_1/Y trim[14] dvdd dvss sg13cmos5l_inv_2
XXQ2_3 vss vss xtr/bot pnpMPA_9DZCCL
Xxres vbg xres/a xres/e XQ1/E vss xres/e xres/f vss vss vss vss xres/XR1[20]/R1 xres/XR1[14]/R2
+ xres/XR1[8]/R1 xres/XR1[9]/R2 xres/XR1[15]/R1 xres/XR1[6]/R2 xres/XR1[12]/R1 xres/XR1[3]/R1
+ xres/XR1[17]/R2 xres/XR1[19]/R1 xres/XR1[8]/R2 xres/XR1[16]/R1 xres/XR1[5]/R2 xres/XR1[9]/R1
+ xres/XR1[13]/R2 xres/XR1[7]/R1 xres/XR1[4]/R1 xres/XR1[18]/R2 bg_res
Xsg13cmos5l_inv_2_2 x1[2]/in_n trim[13] dvdd dvss sg13cmos5l_inv_2
XXQ2_4 vss vss xtr/bot pnpMPA_9DZCCL
Xsg13cmos5l_inv_2_3 sg13cmos5l_inv_2_3/Y trim[12] dvdd dvss sg13cmos5l_inv_2
XXQ2_5 vss vss xtr/bot pnpMPA_9DZCCL
Xsg13cmos5l_inv_2_4 x1[3]/in_n trim[11] dvdd dvss sg13cmos5l_inv_2
XXQ2_6 vss vss xtr/bot pnpMPA_9DZCCL
XXQ2_7 vss vss xtr/bot pnpMPA_9DZCCL
Xsg13cmos5l_inv_2_5 sg13cmos5l_inv_2_5/Y trim[10] dvdd dvss sg13cmos5l_inv_2
Xsg13cmos5l_inv_2_6 x1[4]/in_n trim[9] dvdd dvss sg13cmos5l_inv_2
XXQ1 vss vss XQ1/E pnpMPA_9DZCCL
Xsg13cmos5l_inv_2_7 sg13cmos5l_inv_2_7/Y trim[8] dvdd dvss sg13cmos5l_inv_2
Xsg13cmos5l_inv_2_8 x1[5]/in_n trim[7] dvdd dvss sg13cmos5l_inv_2
Xsg13cmos5l_inv_2_9 sg13cmos5l_inv_2_9/Y trim[6] dvdd dvss sg13cmos5l_inv_2
XXM1 vdd xres/a XM4/S vbg vdd XM4/S vdd sg13_hv_pmos_NWA9LU
Xsg13cmos5l_antennanp_0 trim[15] dvdd dvss sg13cmos5l_antennanp
XXM2 vdd xres/a XM4/S vbg vdd XM4/S vdd sg13_hv_pmos_NWA9LU
Xsg13cmos5l_antennanp_1 trim[14] dvdd dvss sg13cmos5l_antennanp
XXM3 vss vs1 vbg vss sg13_hv_nmos_BEVMZW
Xsg13cmos5l_antennanp_2 trim[13] dvdd dvss sg13cmos5l_antennanp
XXM4 vss XM4/S vs1 vss sg13_hv_nmos_BEVMZW
Xsg13cmos5l_antennanp_3 trim[12] dvdd dvss sg13cmos5l_antennanp
XXM5 vdd vs1 vs2 vdd sg13_hv_pmos_WYN5QB
Xsg13cmos5l_antennanp_4 trim[11] dvdd dvss sg13cmos5l_antennanp
XXM6 vdd vs2 vs2 vdd sg13_hv_pmos_WYN5QB
Xsg13cmos5l_antennanp_5 trim[10] dvdd dvss sg13cmos5l_antennanp
XC1 vss XM4/S capacitor_UEBLR3
XXM7 vs2 vss vdd vs2 sg13_hv_pmos_WYN5QB
Xsg13cmos5l_antennanp_6 trim[9] dvdd dvss sg13cmos5l_antennanp
Xsg13cmos5l_antennanp_7 trim[8] dvdd dvss sg13cmos5l_antennanp
Xcapacitor_77YAAU_0 vss vs2 capacitor_77YAAU
Xsg13cmos5l_antennanp_8 trim[7] dvdd dvss sg13cmos5l_antennanp
Xsg13cmos5l_antennanp_9 trim[6] dvdd dvss sg13cmos5l_antennanp
Xlevel_shift_0[0] sg13cmos5l_inv_2_1/Y trim[14] xtr/ctrl[14] vss vdd level_shift
Xlevel_shift_0[1] sg13cmos5l_inv_2_3/Y trim[12] xtr/ctrl[12] vss vdd level_shift
Xlevel_shift_0[2] sg13cmos5l_inv_2_5/Y trim[10] xtr/ctrl[10] vss vdd level_shift
Xlevel_shift_0[3] sg13cmos5l_inv_2_7/Y trim[8] xtr/ctrl[8] vss vdd level_shift
Xlevel_shift_0[4] sg13cmos5l_inv_2_9/Y trim[6] xtr/ctrl[6] vss vdd level_shift
Xlevel_shift_0[5] sg13cmos5l_inv_2_11/Y trim[4] xtr/ctrl[4] vss vdd level_shift
Xlevel_shift_0[6] sg13cmos5l_inv_2_13/Y trim[2] xtr/ctrl[2] vss vdd level_shift
Xlevel_shift_0[7] sg13cmos5l_inv_2_15/Y trim[0] xtr/ctrl[0] vss vdd level_shift
Xcapacitor_C4E5CZ_0 vss vs2 capacitor_C4E5CZ
Xxtr xres/f xtr/bot x1[1]/out xtr/ctrl[14] x1[2]/out xtr/ctrl[12] x1[3]/out xtr/ctrl[10]
+ x1[4]/out xtr/ctrl[8] x1[5]/out xtr/ctrl[6] x1[6]/out xtr/ctrl[4] x1[7]/out xtr/ctrl[2]
+ x1[8]/out xtr/ctrl[0] xres/XR1[6]/R2 xres/XR1[14]/R2 vss xres/XR1[9]/R1 vbg xres/XR1[3]/R1
+ xres/XR1[5]/R2 xres/XR1[13]/R2 xres/XR1[19]/R1 xres/XR1[8]/R1 xres/a xres/XR1[20]/R1
+ xres/XR1[7]/R1 xres/XR1[16]/R1 xres/XR1[19]/R1 xres/XR1[8]/R1 xres/XR1[15]/R1 xres/XR1[4]/R1
+ xres/XR1[20]/R1 xres/XR1[7]/R1 xres/XR1[3]/R1 xres/f xres/XR1[12]/R1 xres/XR1[9]/R1
+ xres/XR1[14]/R2 vss xres/XR1[8]/R2 xres/XR1[13]/R2 xres/XR1[9]/R2 xres/XR1[17]/R2
+ xres/XR1[8]/R2 xres/e xres/XR1[18]/R2 XQ1/E xres/XR1[17]/R2 xres/XR1[6]/R2 xres/XR1[18]/R2
+ vss vss xres/XR1[5]/R2 xres/XR1[16]/R1 xres/XR1[9]/R2 vss xres/XR1[12]/R1 xres/e
+ xres/XR1[15]/R1 xres/XR1[4]/R1 bg_trim
Xsg13cmos5l_decap_4_0 dvdd dvss sg13cmos5l_decap_4
Xsg13cmos5l_decap_4_3 dvdd dvss sg13cmos5l_decap_4
Xsg13cmos5l_decap_4_5 dvdd dvss sg13cmos5l_decap_4
Xsg13cmos5l_inv_2_10 x1[6]/in_n trim[5] dvdd dvss sg13cmos5l_inv_2
Xsg13cmos5l_antennanp_10 trim[5] dvdd dvss sg13cmos5l_antennanp
Xsg13cmos5l_inv_2_11 sg13cmos5l_inv_2_11/Y trim[4] dvdd dvss sg13cmos5l_inv_2
Xsg13cmos5l_antennanp_11 trim[4] dvdd dvss sg13cmos5l_antennanp
Xsg13cmos5l_decap_4_7 dvdd dvss sg13cmos5l_decap_4
Xsg13cmos5l_inv_2_12 x1[7]/in_n trim[3] dvdd dvss sg13cmos5l_inv_2
Xsg13cmos5l_antennanp_12 trim[3] dvdd dvss sg13cmos5l_antennanp
Xsg13cmos5l_inv_2_13 sg13cmos5l_inv_2_13/Y trim[2] dvdd dvss sg13cmos5l_inv_2
Xsg13cmos5l_decap_4_8 dvdd dvss sg13cmos5l_decap_4
Xsg13cmos5l_antennanp_13 trim[2] dvdd dvss sg13cmos5l_antennanp
Xsg13cmos5l_inv_2_14 x1[8]/in_n trim[1] dvdd dvss sg13cmos5l_inv_2
Xcapacitor_P4YBHP_0 vss vs2 capacitor_P4YBHP
Xsg13cmos5l_antennanp_14 trim[1] dvdd dvss sg13cmos5l_antennanp
Xsg13cmos5l_inv_2_15 sg13cmos5l_inv_2_15/Y trim[0] dvdd dvss sg13cmos5l_inv_2
Xsg13cmos5l_antennanp_15 trim[0] dvdd dvss sg13cmos5l_antennanp
XXQ2_0 vss vss xtr/bot pnpMPA_9DZCCL
Xsg13cmos5l_inv_2_16 x1[0]/in_n ena dvdd dvss sg13cmos5l_inv_2
Xcapacitor_4HNWC9_0 vss vdd capacitor_4HNWC9
.ends

.subckt sg13cmos5l_ocd_ip__bandgap_v3 vbg ibias1_250n trim[15] trim[14] trim[13] trim[12]
+ trim[11] trim[10] trim[9] trim[8] trim[7] trim[6] trim[5] trim[4] trim[3] trim[2]
+ trim[1] trim[0] ena ibias2_1u dvdd vdd vss dvss
Xx1 x2/inp ibias1_250n trim[15] trim[14] trim[13] trim[12] trim[11] trim[10] trim[9]
+ trim[8] trim[7] trim[6] trim[5] trim[4] trim[3] trim[2] trim[1] trim[0] ena x2/ena
+ x1/XM4/S dvdd dvss vss vdd bandgap_unbuffered_v2
Xx2 vdd vbg x2/inp vss ibias2_1u x2/ena vbg se_folded_cascode_np_ab
.ends

* Black-box entry subcircuit for slot12_wrapper abstract view
.subckt slot12_wrapper vss_3v3 s12_an[0] s12_an[1] s12_an_0_esd s12_an_1_esd vbias
+ dig_in[23] dig_in[22] dig_in[21] dig_in[20] dig_in[19] dig_in[18] dig_in[17] dig_in[16]
+ dig_in[15] dig_in[14] dig_in[13] dig_in[12] dig_in[11] dig_in[10] dig_in[9] dig_in[8]
+ dig_in[7] dig_in[6] dig_in[5] dig_in[4] dig_in[3] dig_in[2] dig_in[1] dig_in[0]
+ dig_out[11] dig_out[10] dig_out[9] dig_out[8] dig_out[7] dig_out[6] dig_out[5] dig_out[4]
+ dig_out[3] dig_out[2] dig_out[1] dig_out[0] ibias0 ibias1 analog_bus3 analog_bus2
+ analog_bus1 analog_bus0 vss_1v2 vdd_1v2 vdd_3v3 enable clk reset
.ends

.subckt sg13cmos5l_nor2b_1 Y A B_N VDD VSS
X0 VDD B_N a_46_156# VDD sg13_lv_pmos ad=0.2618p pd=1.63u as=0.2856p ps=2.36u w=0.84u l=0.13u
X1 VSS B_N a_46_156# VSS sg13_lv_nmos ad=0.17255p pd=1.25u as=0.187p ps=1.78u w=0.55u l=0.13u
X2 Y a_46_156# VSS VSS sg13_lv_nmos ad=0.1406p pd=1.12u as=0.17255p ps=1.25u w=0.74u l=0.13u
X3 VSS A Y VSS sg13_lv_nmos ad=0.2516p pd=2.16u as=0.1406p ps=1.12u w=0.74u l=0.13u
X4 a_268_412# a_46_156# VDD VDD sg13_lv_pmos ad=0.1176p pd=1.33u as=0.2618p ps=1.63u w=1.12u l=0.13u
X5 Y A a_268_412# VDD sg13_lv_pmos ad=0.3808p pd=2.92u as=0.1176p ps=1.33u w=1.12u l=0.13u
.ends

.subckt sg13cmos5l_a221oi_1 Y A1 A2 B1 B2 C1 VDD VSS
X0 a_550_140# A1 Y VSS sg13_lv_nmos ad=0.1406p pd=1.12u as=0.2516p ps=2.16u w=0.74u l=0.13u
X1 VSS A2 a_550_140# VSS sg13_lv_nmos ad=0.2516p pd=2.16u as=0.1406p ps=1.12u w=0.74u l=0.13u
X2 a_142_412# C1 Y VDD sg13_lv_pmos ad=0.2128p pd=1.5u as=0.3808p ps=2.92u w=1.12u l=0.13u
X3 a_244_412# B2 a_142_412# VDD sg13_lv_pmos ad=0.2128p pd=1.5u as=0.2128p ps=1.5u w=1.12u l=0.13u
X4 a_142_412# B1 a_244_412# VDD sg13_lv_pmos ad=0.3808p pd=2.92u as=0.2128p ps=1.5u w=1.12u l=0.13u
X5 a_244_412# A1 VDD VDD sg13_lv_pmos ad=0.2128p pd=1.5u as=0.3808p ps=2.92u w=1.12u l=0.13u
X6 VDD A2 a_244_412# VDD sg13_lv_pmos ad=0.3808p pd=2.92u as=0.2128p ps=1.5u w=1.12u l=0.13u
X7 VSS C1 Y VSS sg13_lv_nmos ad=0.1406p pd=1.12u as=0.2516p ps=2.16u w=0.74u l=0.13u
X8 a_244_140# B2 VSS VSS sg13_lv_nmos ad=0.1406p pd=1.12u as=0.1406p ps=1.12u w=0.74u l=0.13u
X9 Y B1 a_244_140# VSS sg13_lv_nmos ad=0.2516p pd=2.16u as=0.1406p ps=1.12u w=0.74u l=0.13u
.ends

.subckt sg13cmos5l_or2_1 X A B VDD VSS
X0 a_142_492# B a_48_492# VDD sg13_lv_pmos ad=0.1596p pd=1.22u as=0.2856p ps=2.36u w=0.84u l=0.13u
X1 VDD A a_142_492# VDD sg13_lv_pmos ad=0.2226p pd=1.535u as=0.1596p ps=1.22u w=0.84u l=0.13u
X2 X a_48_492# VSS VSS sg13_lv_nmos ad=0.2516p pd=2.16u as=0.1469p ps=1.155u w=0.74u l=0.13u
X3 VSS A a_48_492# VSS sg13_lv_nmos ad=0.1469p pd=1.155u as=0.1045p ps=0.93u w=0.55u l=0.13u
X4 a_48_492# B VSS VSS sg13_lv_nmos ad=0.1045p pd=0.93u as=0.187p ps=1.78u w=0.55u l=0.13u
X5 X a_48_492# VDD VDD sg13_lv_pmos ad=0.3976p pd=2.95u as=0.2226p ps=1.535u w=1.12u l=0.13u
.ends

.subckt sg13cmos5l_o21ai_1 Y A1 A2 B1 VDD VSS
X0 VSS A1 a_22_110# VSS sg13_lv_nmos ad=0.1406p pd=1.12u as=0.2516p ps=2.16u w=0.74u l=0.15u
X1 a_120_432# A1 VDD VDD sg13_lv_pmos ad=0.2128p pd=1.5u as=0.3808p ps=2.92u w=1.12u l=0.15u
X2 a_22_110# A2 VSS VSS sg13_lv_nmos ad=0.1406p pd=1.12u as=0.1406p ps=1.12u w=0.74u l=0.15u
X3 Y B1 a_22_110# VSS sg13_lv_nmos ad=0.2516p pd=2.16u as=0.1406p ps=1.12u w=0.74u l=0.15u
X4 Y A2 a_120_432# VDD sg13_lv_pmos ad=0.2128p pd=1.5u as=0.2128p ps=1.5u w=1.12u l=0.15u
X5 VDD B1 Y VDD sg13_lv_pmos ad=0.3808p pd=2.92u as=0.2128p ps=1.5u w=1.12u l=0.15u
.ends

.subckt sg13cmos5l_a21oi_1 Y A1 A2 B1 VDD VSS
X0 Y B1 VSS VSS sg13_lv_nmos ad=0.1406p pd=1.12u as=0.2516p ps=2.16u w=0.74u l=0.13u
X1 a_257_140# A1 Y VSS sg13_lv_nmos ad=0.1406p pd=1.12u as=0.1406p ps=1.12u w=0.74u l=0.13u
X2 VSS A2 a_257_140# VSS sg13_lv_nmos ad=0.2516p pd=2.16u as=0.1406p ps=1.12u w=0.74u l=0.13u
X3 a_155_412# B1 Y VDD sg13_lv_pmos ad=0.2128p pd=1.5u as=0.3808p ps=2.92u w=1.12u l=0.13u
X4 VDD A1 a_155_412# VDD sg13_lv_pmos ad=0.2128p pd=1.5u as=0.2128p ps=1.5u w=1.12u l=0.13u
X5 a_155_412# A2 VDD VDD sg13_lv_pmos ad=0.3808p pd=2.92u as=0.2128p ps=1.5u w=1.12u l=0.13u
.ends

.subckt sg13cmos5l_a21o_1 X A1 A2 B1 VDD VSS
X0 VDD A1 a_358_436# VDD sg13_lv_pmos ad=0.19p pd=1.38u as=0.2125p ps=1.425u w=1u l=0.13u
X1 VSS A2 a_494_160# VSS sg13_lv_nmos ad=0.2176p pd=1.96u as=81.6f ps=0.895u w=0.64u l=0.13u
X2 a_358_436# A2 VDD VDD sg13_lv_pmos ad=0.34p pd=2.68u as=0.19p ps=1.38u w=1u l=0.13u
X3 a_115_308# B1 VSS VSS sg13_lv_nmos ad=0.1216p pd=1.02u as=0.15745p ps=1.175u w=0.64u l=0.13u
X4 a_494_160# A1 a_115_308# VSS sg13_lv_nmos ad=81.6f pd=0.895u as=0.1216p ps=1.02u w=0.64u l=0.13u
X5 a_358_436# B1 a_115_308# VDD sg13_lv_pmos ad=0.2125p pd=1.425u as=0.35p ps=2.7u w=1u l=0.13u
X6 VDD a_115_308# X VDD sg13_lv_pmos ad=0.3808p pd=2.92u as=0.3808p ps=2.92u w=1.12u l=0.13u
X7 VSS a_115_308# X VSS sg13_lv_nmos ad=0.15745p pd=1.175u as=0.2351p ps=2.16u w=0.74u l=0.13u
.ends

.subckt sg13cmos5l_nor4_1 Y A B C D VDD VSS
X0 a_354_412# C a_252_412# VDD sg13_lv_pmos ad=0.2128p pd=1.5u as=0.2128p ps=1.5u w=1.12u l=0.13u
X1 Y D a_354_412# VDD sg13_lv_pmos ad=0.4368p pd=3.02u as=0.2128p ps=1.5u w=1.12u l=0.13u
X2 Y A VSS VSS sg13_lv_nmos ad=0.1406p pd=1.12u as=0.2516p ps=2.16u w=0.74u l=0.13u
X3 a_150_412# A VDD VDD sg13_lv_pmos ad=0.2128p pd=1.5u as=0.3808p ps=2.92u w=1.12u l=0.13u
X4 VSS B Y VSS sg13_lv_nmos ad=0.1406p pd=1.12u as=0.1406p ps=1.12u w=0.74u l=0.13u
X5 a_252_412# B a_150_412# VDD sg13_lv_pmos ad=0.2128p pd=1.5u as=0.2128p ps=1.5u w=1.12u l=0.13u
X6 Y C VSS VSS sg13_lv_nmos ad=0.1406p pd=1.12u as=0.1406p ps=1.12u w=0.74u l=0.13u
X7 VSS D Y VSS sg13_lv_nmos ad=0.23757p pd=2.16u as=0.1406p ps=1.12u w=0.74u l=0.13u
.ends

.subckt sg13cmos5l_a22oi_1 Y A1 A2 B1 B2 VDD VSS
X0 a_398_96# A1 Y VSS sg13_lv_nmos ad=96.2f pd=1u as=0.2664p ps=1.46u w=0.74u l=0.13u
X1 Y B2 a_127_96# VSS sg13_lv_nmos ad=0.2664p pd=1.46u as=0.13875p ps=1.115u w=0.74u l=0.13u
X2 VDD A2 a_127_436# VDD sg13_lv_pmos ad=0.3808p pd=2.92u as=0.2744p ps=1.61u w=1.12u l=0.13u
X3 Y B1 a_127_436# VDD sg13_lv_pmos ad=0.2128p pd=1.5u as=0.2716p ps=1.605u w=1.12u l=0.13u
X4 a_127_436# B2 Y VDD sg13_lv_pmos ad=0.2744p pd=1.61u as=0.2128p ps=1.5u w=1.12u l=0.13u
X5 a_127_96# B1 VSS VSS sg13_lv_nmos ad=0.13875p pd=1.115u as=0.2553p ps=2.17u w=0.74u l=0.13u
X6 a_127_436# A1 VDD VDD sg13_lv_pmos ad=0.2716p pd=1.605u as=0.3808p ps=2.92u w=1.12u l=0.13u
X7 VSS A2 a_398_96# VSS sg13_lv_nmos ad=0.2516p pd=2.16u as=96.2f ps=1u w=0.74u l=0.13u
.ends

.subckt sg13cmos5l_buf_2 X A VDD VSS
X0 a_41_304# A VSS VSS sg13_lv_nmos ad=0.2176p pd=1.96u as=0.1371p ps=1.12u w=0.64u l=0.13u
X1 a_41_304# A VDD VDD sg13_lv_pmos ad=0.34p pd=2.68u as=0.2086p ps=1.5u w=1u l=0.13u
X2 X a_41_304# VSS VSS sg13_lv_nmos ad=0.1406p pd=1.12u as=0.2516p ps=2.16u w=0.74u l=0.13u
X3 X a_41_304# VDD VDD sg13_lv_pmos ad=0.2128p pd=1.5u as=0.7336p ps=3.55u w=1.12u l=0.13u
X4 VSS a_41_304# X VSS sg13_lv_nmos ad=0.1371p pd=1.12u as=0.1406p ps=1.12u w=0.74u l=0.13u
X5 VDD a_41_304# X VDD sg13_lv_pmos ad=0.2086p pd=1.5u as=0.2128p ps=1.5u w=1.12u l=0.13u
.ends

.subckt sg13cmos5l_xnor2_1 Y A B VDD VSS
X0 a_192_429# A VDD VDD sg13_lv_pmos ad=0.1596p pd=1.22u as=0.4536p ps=2.76u w=0.84u l=0.13u
X1 VSS A a_341_118# VSS sg13_lv_nmos ad=0.1898p pd=1.36u as=0.2516p ps=2.16u w=0.74u l=0.13u
X2 VDD B a_192_429# VDD sg13_lv_pmos ad=0.2891p pd=1.695u as=0.1596p ps=1.22u w=0.84u l=0.13u
X3 a_435_412# A VDD VDD sg13_lv_pmos ad=0.1428p pd=1.375u as=0.2891p ps=1.695u w=1.12u l=0.13u
X4 a_155_160# A VSS VSS sg13_lv_nmos ad=78.39999f pd=0.885u as=0.2272p ps=1.99u w=0.64u l=0.13u
X5 a_341_118# B VSS VSS sg13_lv_nmos ad=0.1406p pd=1.12u as=0.1898p ps=1.36u w=0.74u l=0.13u
X6 Y a_192_429# a_341_118# VSS sg13_lv_nmos ad=0.2516p pd=2.16u as=0.1406p ps=1.12u w=0.74u l=0.13u
X7 VDD a_192_429# Y VDD sg13_lv_pmos ad=0.3808p pd=2.92u as=0.2408p ps=1.55u w=1.12u l=0.13u
X8 Y B a_435_412# VDD sg13_lv_pmos ad=0.2408p pd=1.55u as=0.1428p ps=1.375u w=1.12u l=0.13u
X9 a_192_429# B a_155_160# VSS sg13_lv_nmos ad=0.2176p pd=1.96u as=78.39999f ps=0.885u w=0.64u l=0.13u
.ends

.subckt sg13cmos5l_or3_1 X A B C VDD VSS
X0 VSS A a_73_118# VSS sg13_lv_nmos ad=0.13395p pd=1.12u as=0.198p ps=1.27u w=0.55u l=0.13u
X1 X a_73_118# VSS VSS sg13_lv_nmos ad=0.2516p pd=2.16u as=0.13395p ps=1.12u w=0.74u l=0.13u
X2 VDD A a_269_412# VDD sg13_lv_pmos ad=0.3822p pd=1.84u as=0.1575p ps=1.315u w=1u l=0.13u
X3 VSS C a_73_118# VSS sg13_lv_nmos ad=0.1045p pd=0.93u as=0.187p ps=1.78u w=0.55u l=0.13u
X4 a_167_412# C a_73_118# VDD sg13_lv_pmos ad=0.19p pd=1.38u as=0.34p ps=2.68u w=1u l=0.13u
X5 a_73_118# B VSS VSS sg13_lv_nmos ad=0.198p pd=1.27u as=0.1045p ps=0.93u w=0.55u l=0.13u
X6 X a_73_118# VDD VDD sg13_lv_pmos ad=0.3808p pd=2.92u as=0.3822p ps=1.84u w=1.12u l=0.13u
X7 a_269_412# B a_167_412# VDD sg13_lv_pmos ad=0.1575p pd=1.315u as=0.19p ps=1.38u w=1u l=0.13u
.ends

.subckt sg13cmos5l_nand3b_1 Y A_N B C VDD VSS
X0 a_318_122# C VSS VSS sg13_lv_nmos ad=0.1406p pd=1.12u as=0.18575p ps=1.26u w=0.74u l=0.13u
X1 a_420_122# B a_318_122# VSS sg13_lv_nmos ad=0.1406p pd=1.12u as=0.1406p ps=1.12u w=0.74u l=0.13u
X2 Y a_94_160# a_420_122# VSS sg13_lv_nmos ad=0.3404p pd=2.4u as=0.1406p ps=1.12u w=0.74u l=0.13u
X3 VSS A_N a_94_160# VSS sg13_lv_nmos ad=0.18575p pd=1.26u as=0.187p ps=1.78u w=0.55u l=0.13u
X4 VDD A_N a_94_160# VDD sg13_lv_pmos ad=0.2198p pd=1.53u as=0.2856p ps=2.36u w=0.84u l=0.13u
X5 Y C VDD VDD sg13_lv_pmos ad=0.2128p pd=1.5u as=0.2198p ps=1.53u w=1.12u l=0.13u
X6 VDD B Y VDD sg13_lv_pmos ad=0.2128p pd=1.5u as=0.2128p ps=1.5u w=1.12u l=0.13u
X7 Y a_94_160# VDD VDD sg13_lv_pmos ad=0.3808p pd=2.92u as=0.2128p ps=1.5u w=1.12u l=0.13u
.ends

.subckt sg13cmos5l_and4_1 X A B C D VDD VSS
X0 VDD D a_81_118# VDD sg13_lv_pmos ad=0.2044p pd=1.53u as=0.1848p ps=1.28u w=0.84u l=0.13u
X1 a_175_118# A a_81_118# VSS sg13_lv_nmos ad=0.1216p pd=1.02u as=0.2176p ps=1.96u w=0.64u l=0.13u
X2 a_277_118# B a_175_118# VSS sg13_lv_nmos ad=0.1216p pd=1.02u as=0.1216p ps=1.02u w=0.64u l=0.13u
X3 a_379_118# C a_277_118# VSS sg13_lv_nmos ad=0.1408p pd=1.08u as=0.1216p ps=1.02u w=0.64u l=0.13u
X4 VSS D a_379_118# VSS sg13_lv_nmos ad=0.1447p pd=1.15u as=0.1408p ps=1.08u w=0.64u l=0.13u
X5 X a_81_118# VSS VSS sg13_lv_nmos ad=0.3552p pd=2.44u as=0.1447p ps=1.15u w=0.74u l=0.13u
X6 X a_81_118# VDD VDD sg13_lv_pmos ad=0.5376p pd=3.2u as=0.2044p ps=1.53u w=1.12u l=0.13u
X7 a_81_118# A VDD VDD sg13_lv_pmos ad=0.1596p pd=1.22u as=0.2856p ps=2.36u w=0.84u l=0.13u
X8 VDD B a_81_118# VDD sg13_lv_pmos ad=0.1596p pd=1.22u as=0.1596p ps=1.22u w=0.84u l=0.13u
X9 a_81_118# C VDD VDD sg13_lv_pmos ad=0.1848p pd=1.28u as=0.1596p ps=1.22u w=0.84u l=0.13u
.ends

.subckt sg13cmos5l_and3_1 X A B C VDD VSS
X0 a_170_160# A a_76_160# VSS sg13_lv_nmos ad=0.1216p pd=1.02u as=0.2176p ps=1.96u w=0.64u l=0.13u
X1 a_272_160# B a_170_160# VSS sg13_lv_nmos ad=0.1216p pd=1.02u as=0.1216p ps=1.02u w=0.64u l=0.13u
X2 VSS C a_272_160# VSS sg13_lv_nmos ad=0.1371p pd=1.12u as=0.1216p ps=1.02u w=0.64u l=0.13u
X3 VDD A a_76_160# VDD sg13_lv_pmos ad=0.1596p pd=1.22u as=0.2856p ps=2.36u w=0.84u l=0.13u
X4 a_76_160# B VDD VDD sg13_lv_pmos ad=0.1596p pd=1.22u as=0.1596p ps=1.22u w=0.84u l=0.13u
X5 VDD C a_76_160# VDD sg13_lv_pmos ad=0.36195p pd=1.84u as=0.1596p ps=1.22u w=0.84u l=0.13u
X6 X a_76_160# VDD VDD sg13_lv_pmos ad=0.3808p pd=2.92u as=0.36195p ps=1.84u w=1.12u l=0.13u
X7 X a_76_160# VSS VSS sg13_lv_nmos ad=0.2516p pd=2.16u as=0.1371p ps=1.12u w=0.74u l=0.13u
.ends

.subckt housekeeping_top CSB SCK SDI SDO analog_bus_ena[0] analog_bus_ena[1] analog_bus_ena[2]
+ analog_bus_ena[3] bandgap_ena bandgap_sink1[0] bandgap_sink1[1] bandgap_sink1[2]
+ bandgap_sink2[0] bandgap_sink2[1] bandgap_trim[0] bandgap_trim[10] bandgap_trim[11]
+ bandgap_trim[12] bandgap_trim[13] bandgap_trim[14] bandgap_trim[15] bandgap_trim[1]
+ bandgap_trim[2] bandgap_trim[3] bandgap_trim[4] bandgap_trim[5] bandgap_trim[6]
+ bandgap_trim[7] bandgap_trim[8] bandgap_trim[9] biasgen_coarse biasgen_ena biasgen_fine
+ biasgen_ref_vbg clk clk_out dbus_in_left[0] dbus_in_left[10] dbus_in_left[11] dbus_in_left[1]
+ dbus_in_left[2] dbus_in_left[3] dbus_in_left[4] dbus_in_left[5] dbus_in_left[6]
+ dbus_in_left[7] dbus_in_left[8] dbus_in_left[9] dbus_in_right[0] dbus_in_right[10]
+ dbus_in_right[11] dbus_in_right[1] dbus_in_right[2] dbus_in_right[3] dbus_in_right[4]
+ dbus_in_right[5] dbus_in_right[6] dbus_in_right[7] dbus_in_right[8] dbus_in_right[9]
+ dbus_out[0] dbus_out[10] dbus_out[11] dbus_out[12] dbus_out[13] dbus_out[14] dbus_out[15]
+ dbus_out[16] dbus_out[17] dbus_out[18] dbus_out[19] dbus_out[1] dbus_out[20] dbus_out[21]
+ dbus_out[22] dbus_out[23] dbus_out[2] dbus_out[3] dbus_out[4] dbus_out[5] dbus_out[6]
+ dbus_out[7] dbus_out[8] dbus_out[9] idac1_value[0] idac1_value[1] idac1_value[2]
+ idac1_value[3] idac1_value[4] idac2_value[0] idac2_value[1] idac2_value[2] idac2_value[3]
+ idac2_value[4] io_in[0] io_in[10] io_in[11] io_in[1] io_in[2] io_in[3] io_in[4]
+ io_in[5] io_in[6] io_in[7] io_in[8] io_in[9] io_oe[0] io_oe[10] io_oe[11] io_oe[1]
+ io_oe[2] io_oe[3] io_oe[4] io_oe[5] io_oe[6] io_oe[7] io_oe[8] io_oe[9] io_out[0]
+ io_out[10] io_out[11] io_out[1] io_out[2] io_out[3] io_out[4] io_out[5] io_out[6]
+ io_out[7] io_out[8] io_out[9] mask_rev_in[0] mask_rev_in[10] mask_rev_in[11] mask_rev_in[12]
+ mask_rev_in[13] mask_rev_in[14] mask_rev_in[15] mask_rev_in[16] mask_rev_in[17]
+ mask_rev_in[18] mask_rev_in[19] mask_rev_in[1] mask_rev_in[20] mask_rev_in[21] mask_rev_in[22]
+ mask_rev_in[23] mask_rev_in[24] mask_rev_in[25] mask_rev_in[26] mask_rev_in[27]
+ mask_rev_in[28] mask_rev_in[29] mask_rev_in[2] mask_rev_in[30] mask_rev_in[31] mask_rev_in[3]
+ mask_rev_in[4] mask_rev_in[5] mask_rev_in[6] mask_rev_in[7] mask_rev_in[8] mask_rev_in[9]
+ porb proj_1v2_ena proj_3v3_ena proj_dig_ena proj_ena proj_ibias_ena[0] proj_ibias_ena[1]
+ proj_sel[0] proj_sel[1] proj_sel[2] proj_sel[3] proj_sel[4] proj_vbias_ena project_zero
+ reset sdo_ena sram_addr[0] sram_addr[1] sram_addr[2] sram_addr[3] sram_addr[4] sram_addr[5]
+ sram_addr[6] sram_addr[7] sram_addr[8] sram_addr[9] sram_clk sram_idata[0] sram_idata[1]
+ sram_idata[2] sram_idata[3] sram_idata[4] sram_idata[5] sram_idata[6] sram_idata[7]
+ sram_odata[0] sram_odata[1] sram_odata[2] sram_odata[3] sram_odata[4] sram_odata[5]
+ sram_odata[6] sram_odata[7] sram_read sram_write voltgen_ena[0] voltgen_ena[1] voltgen_ena[2]
+ voltgen_high voltgen_sink1[0] voltgen_sink1[1] voltgen_sink1[2] voltgen_sink2[0]
+ voltgen_sink2[1] voltgen_sink2[2] voltgen_source[0] voltgen_source[1] voltgen_source[2]
+ voltgen_source[3] voltgen_source[4] voltgen_value[0] voltgen_value[1] voltgen_value[2]
+ vddd vssd
XFILLER_3_2467 vddd vssd sg13cmos5l_decap_8
Xoutbuffers\[32\] bandgap_sink1[0] _7056_/Q vddd vssd sg13cmos5l_buf_16
X_6914_ _6914_/Y _6943_/A _6943_/B_N vddd vssd sg13cmos5l_nor2b_1
XFILLER_22_122 vddd vssd sg13cmos5l_decap_8
X_6845_ _6845_/Y _6845_/A _6846_/B_N vddd vssd sg13cmos5l_nor2b_1
XFILLER_22_166 vddd vssd sg13cmos5l_decap_8
X_3988_ _3990_/C _7109_/Q _4067_/B1 _3896_/B _3690_/Y _3987_/Y vddd vssd sg13cmos5l_a221oi_1
X_6776_ _6776_/Y _6776_/A _6781_/S vddd vssd sg13cmos5l_nor2_1
XFILLER_32_1908 vddd vssd sg13cmos5l_decap_8
X_5727_ _5727_/X _5727_/A _7203_/Q vddd vssd sg13cmos5l_or2_1
X_5658_ _5658_/Y _5647_/Y _5655_/Y _5657_/Y vddd vssd sg13cmos5l_o21ai_1
XFILLER_11_1020 vddd vssd sg13cmos5l_decap_4
X_5589_ _5589_/X _5727_/A _7183_/Q vddd vssd sg13cmos5l_or2_1
X_4609_ _4610_/C _4609_/A _4609_/B vddd vssd sg13cmos5l_nor2_1
XFILLER_11_1042 vddd vssd sg13cmos5l_decap_8
X_7328_ _7328_/Q _7348_/CLK _7328_/D _6841_/Y vddd vssd sg13cmos5l_dfrbpq_1
XFILLER_7_7 vddd vssd sg13cmos5l_decap_8
X_7259_ _7259_/Q _7259_/CLK _7259_/D fanout390/X vddd vssd sg13cmos5l_dfrbpq_1
XFILLER_28_1550 vddd vssd sg13cmos5l_decap_8
XFILLER_24_2148 vddd vssd sg13cmos5l_decap_4
XFILLER_8_2378 vddd vssd sg13cmos5l_decap_8
XFILLER_4_1508 vddd vssd sg13cmos5l_decap_4
XFILLER_8_1655 vddd vssd sg13cmos5l_decap_4
XFILLER_8_1666 vddd vssd sg13cmos5l_decap_8
XFILLER_18_406 vddd vssd sg13cmos5l_decap_8
Xhold1051 hold486/A hold1513/X vddd vssd sg13cmos5l_dlygate4sd3_1
XFILLER_4_1519 vddd vssd sg13cmos5l_decap_4
Xhold1040 _6410_/A1 _7154_/Q vddd vssd sg13cmos5l_dlygate4sd3_1
Xhold1062 _7113_/D _6331_/Y vddd vssd sg13cmos5l_dlygate4sd3_1
Xhold1084 _6606_/A1 _5085_/B vddd vssd sg13cmos5l_dlygate4sd3_1
Xhold1073 _3591_/A _7226_/Q vddd vssd sg13cmos5l_dlygate4sd3_1
XFILLER_27_951 vddd vssd sg13cmos5l_decap_8
Xhold1095 _3532_/A _7236_/Q vddd vssd sg13cmos5l_dlygate4sd3_1
XFILLER_26_483 vddd vssd sg13cmos5l_decap_8
XFILLER_26_63 vddd vssd sg13cmos5l_decap_8
XFILLER_13_2553 vddd vssd sg13cmos5l_decap_8
XFILLER_10_862 vddd vssd sg13cmos5l_decap_8
XFILLER_5_376 vddd vssd sg13cmos5l_decap_8
XFILLER_3_23 vddd vssd sg13cmos5l_decap_8
XFILLER_27_1060 vddd vssd sg13cmos5l_decap_8
XFILLER_3_89 vddd vssd sg13cmos5l_decap_8
XFILLER_1_582 vddd vssd sg13cmos5l_decap_8
XFILLER_20_2535 vddd vssd sg13cmos5l_decap_8
XFILLER_7_1165 vddd vssd sg13cmos5l_decap_4
XFILLER_7_1187 vddd vssd sg13cmos5l_decap_8
Xwire18 wire18/X wire18/A vddd vssd sg13cmos5l_buf_4
XFILLER_0_1928 vddd vssd sg13cmos5l_decap_4
X_4960_ _4960_/Y _4965_/B _4959_/Y hold884/X vddd vssd sg13cmos5l_o21ai_1
XFILLER_32_420 vddd vssd sg13cmos5l_decap_8
XFILLER_18_2453 vddd vssd sg13cmos5l_decap_8
X_4891_ _4891_/Y _3641_/Y _3652_/A _5285_/D hold851/X _4890_/X vddd vssd sg13cmos5l_a221oi_1
X_3911_ _3911_/Y _3911_/A _3911_/B vddd vssd sg13cmos5l_nor2_1
X_6630_ _6630_/Y _6630_/A _6635_/S vddd vssd sg13cmos5l_nor2_1
X_3842_ _6755_/A _3891_/A _3842_/B vddd vssd sg13cmos5l_nand2_1
XFILLER_32_486 vddd vssd sg13cmos5l_decap_8
X_6561_ _6561_/X _6544_/A hold861/X _6562_/S vddd vssd sg13cmos5l_mux2_1
X_3773_ _3777_/A _7112_/Q _4067_/B1 _4242_/A2 _3519_/Y _3772_/Y vddd vssd sg13cmos5l_a221oi_1
X_5512_ _5512_/Y _5372_/A _5509_/Y _5511_/Y vddd vssd sg13cmos5l_a21oi_1
XFILLER_8_181 vddd vssd sg13cmos5l_decap_8
XFILLER_12_2085 vddd vssd sg13cmos5l_decap_8
X_6492_ _6492_/Y _6520_/A _6495_/S vddd vssd sg13cmos5l_nor2_1
X_5443_ _5443_/Y _5441_/Y _5442_/Y _5454_/C vddd vssd sg13cmos5l_o21ai_1
XFILLER_12_1362 vddd vssd sg13cmos5l_decap_4
X_5374_ _5374_/X _5374_/A _5374_/B vddd vssd sg13cmos5l_and2_1
X_7113_ _7113_/Q _7127_/CLK _7113_/D fanout398/X vddd vssd sg13cmos5l_dfrbpq_1
X_4325_ _4325_/Y _3484_/Y _4324_/Y hold601/X vddd vssd sg13cmos5l_o21ai_1
XFILLER_25_2424 vddd vssd sg13cmos5l_decap_8
XFILLER_25_1701 vddd vssd sg13cmos5l_decap_8
Xfanout127 _6733_/B _6303_/Y vddd vssd sg13cmos5l_buf_1
Xfanout116 _6315_/A _3691_/Y vddd vssd sg13cmos5l_buf_1
XFILLER_5_2518 vddd vssd sg13cmos5l_decap_8
Xfanout138 _4856_/A2 _4827_/Y vddd vssd sg13cmos5l_buf_1
X_7044_ _7044_/Q _7279_/CLK _7044_/D fanout385/X vddd vssd sg13cmos5l_dfrbpq_1
X_4256_ _4256_/Y _6302_/A _3755_/B vddd vssd sg13cmos5l_nor2b_1
Xfanout149 _5241_/A _4978_/Y vddd vssd sg13cmos5l_buf_1
XFILLER_25_1767 vddd vssd sg13cmos5l_decap_4
X_4187_ _4187_/X _4184_/Y _4185_/Y _4186_/Y vddd vssd sg13cmos5l_a21o_1
XFILLER_27_203 vddd vssd sg13cmos5l_decap_8
XFILLER_3_2253 vddd vssd sg13cmos5l_decap_8
XFILLER_24_954 vddd vssd sg13cmos5l_decap_8
XFILLER_19_1527 vddd vssd sg13cmos5l_decap_8
X_6828_ _6828_/Y _6828_/A _6828_/B_N vddd vssd sg13cmos5l_nor2b_1
XFILLER_10_114 vddd vssd sg13cmos5l_decap_8
X_6759_ _6759_/Y _6773_/A _6759_/B _6759_/C vddd vssd sg13cmos5l_nor3_1
XFILLER_12_21 vddd vssd sg13cmos5l_decap_8
XFILLER_3_814 vddd vssd sg13cmos5l_decap_4
XFILLER_24_1211 vddd vssd sg13cmos5l_decap_8
XFILLER_28_1391 vddd vssd sg13cmos5l_decap_8
XFILLER_24_1244 vddd vssd sg13cmos5l_decap_8
XFILLER_19_726 vddd vssd sg13cmos5l_decap_8
XFILLER_18_236 vddd vssd sg13cmos5l_decap_4
XFILLER_18_1037 vddd vssd sg13cmos5l_decap_8
XFILLER_30_935 vddd vssd sg13cmos5l_decap_8
XFILLER_31_1248 vddd vssd sg13cmos5l_decap_4
XFILLER_6_652 vddd vssd sg13cmos5l_decap_4
X_4110_ _6278_/A dbus_in_left[1] dbus_in_right[1] vddd vssd sg13cmos5l_nor2_1
XFILLER_29_1177 vddd vssd sg13cmos5l_decap_8
XFILLER_25_1019 vddd vssd sg13cmos5l_decap_4
XFILLER_2_891 vddd vssd sg13cmos5l_decap_8
X_5090_ _5091_/D _7285_/Q _5090_/B _5090_/C _5090_/D vddd vssd sg13cmos5l_nor4_1
X_4041_ _4041_/Y _5597_/A _6459_/A _6450_/A vddd vssd sg13cmos5l_a21oi_1
XFILLER_4_2551 vddd vssd sg13cmos5l_decap_8
XFILLER_20_1642 vddd vssd sg13cmos5l_decap_8
XFILLER_0_2448 vddd vssd sg13cmos5l_decap_8
XFILLER_24_217 vddd vssd sg13cmos5l_decap_8
X_5992_ _5992_/X hold973/X _3717_/A _5994_/S vddd vssd sg13cmos5l_mux2_1
XFILLER_0_1747 vddd vssd sg13cmos5l_decap_8
X_4943_ _7306_/D _4943_/A vddd vssd sg13cmos5l_inv_1
XFILLER_17_280 vddd vssd sg13cmos5l_decap_8
XFILLER_18_2261 vddd vssd sg13cmos5l_decap_8
X_6613_ _6613_/X _6613_/A0 _6599_/A _6614_/S vddd vssd sg13cmos5l_mux2_1
XFILLER_21_935 vddd vssd sg13cmos5l_decap_8
X_4874_ _4878_/A _4959_/A _7133_/Q _7132_/Q _4962_/A vddd vssd sg13cmos5l_a22oi_1
XFILLER_32_294 vddd vssd sg13cmos5l_decap_8
X_3825_ _3825_/Y _3822_/Y _3823_/Y wire78/X _7060_/Q _4085_/B vddd vssd sg13cmos5l_a221oi_1
XFILLER_31_2461 vddd vssd sg13cmos5l_decap_8
X_6544_ _6544_/Y _6544_/A _6546_/B vddd vssd sg13cmos5l_nor2_1
X_3756_ _3756_/Y wire61/A vddd vssd sg13cmos5l_inv_1
X_6475_ _6475_/Y _6518_/A _6479_/S vddd vssd sg13cmos5l_nor2_1
XFILLER_14_1468 vddd vssd sg13cmos5l_decap_4
X_3687_ _3687_/Y _4002_/C _3749_/B _3929_/B _3869_/B vddd vssd sg13cmos5l_nor4_1
X_5426_ _5427_/B _5428_/C _5423_/Y _5428_/B vddd vssd sg13cmos5l_a21oi_1
X_5357_ _5357_/Y _4771_/A _3557_/Y _5372_/C vddd vssd sg13cmos5l_o21ai_1
X_4308_ _4308_/Y _4308_/A _4308_/B vddd vssd sg13cmos5l_nand2_1
X_5288_ _7393_/D _5288_/A vddd vssd sg13cmos5l_inv_1
X_7027_ _7027_/Q _7233_/CLK _7027_/D fanout375/X vddd vssd sg13cmos5l_dfrbpq_1
X_4239_ wire12/A _4239_/A _4239_/B _4239_/C vddd vssd sg13cmos5l_nor3_1
XFILLER_5_1625 vddd vssd sg13cmos5l_decap_8
XFILLER_5_2348 vddd vssd sg13cmos5l_decap_8
XFILLER_9_1761 vddd vssd sg13cmos5l_decap_8
XFILLER_25_1597 vddd vssd sg13cmos5l_decap_4
XFILLER_28_534 vddd vssd sg13cmos5l_decap_8
XFILLER_11_401 vddd vssd sg13cmos5l_decap_8
XFILLER_12_946 vddd vssd sg13cmos5l_decap_8
XFILLER_32_2236 vddd vssd sg13cmos5l_decap_8
XFILLER_32_1502 vddd vssd sg13cmos5l_decap_8
XFILLER_23_42 vddd vssd sg13cmos5l_decap_8
XFILLER_11_489 vddd vssd sg13cmos5l_decap_4
XFILLER_10_2545 vddd vssd sg13cmos5l_decap_8
XFILLER_2_121 vddd vssd sg13cmos5l_decap_8
XFILLER_10_1877 vddd vssd sg13cmos5l_decap_4
Xtiedowns\[31\] dbus_in_left[11] vddd vssd sg13cmos5l_antennanp
XFILLER_21_1940 vddd vssd sg13cmos5l_decap_8
XFILLER_0_35 vddd vssd sg13cmos5l_decap_8
XFILLER_9_77 vddd vssd sg13cmos5l_decap_8
X_3610_ _3610_/Y _3610_/A vddd vssd sg13cmos5l_inv_1
X_4590_ _4590_/X _4624_/A _4590_/B vddd vssd sg13cmos5l_and2_1
X_3541_ _4360_/B _3541_/A vddd vssd sg13cmos5l_inv_1
Xhold917 _6668_/A _7023_/Q vddd vssd sg13cmos5l_dlygate4sd3_1
Xhold928 _5935_/C _5931_/Y vddd vssd sg13cmos5l_dlygate4sd3_1
Xhold906 _7194_/D _6486_/Y vddd vssd sg13cmos5l_dlygate4sd3_1
X_3472_ _3472_/Y _4559_/A vddd vssd sg13cmos5l_inv_1
Xhold939 _5949_/B _6971_/Q vddd vssd sg13cmos5l_dlygate4sd3_1
X_6260_ _6260_/Y _4473_/A _4979_/A _6041_/B vddd vssd sg13cmos5l_a21oi_1
X_6191_ _6191_/Y _6243_/A _6191_/B vddd vssd sg13cmos5l_nor2_1
X_5211_ _5225_/B _5210_/A _5210_/B _6152_/A vddd vssd sg13cmos5l_o21ai_1
X_5142_ _5215_/B _7279_/Q _7278_/Q vddd vssd sg13cmos5l_nand2b_1
XFILLER_9_1046 vddd vssd sg13cmos5l_decap_8
XFILLER_29_0 vddd vssd sg13cmos5l_decap_8
XFILLER_26_2574 vddd vssd sg13cmos5l_decap_8
XFILLER_22_2427 vddd vssd sg13cmos5l_decap_8
X_5073_ _5259_/B _7257_/Q _7256_/Q vddd vssd sg13cmos5l_nand2b_1
X_4024_ _4024_/Y _4018_/Y _4021_/Y _6012_/A _3791_/A vddd vssd sg13cmos5l_a22oi_1
X_5975_ _5975_/Y _5975_/A _5975_/B _5975_/C vddd vssd sg13cmos5l_nor3_1
X_4926_ _4964_/B _4968_/A _4968_/B vddd vssd sg13cmos5l_and2_1
X_4857_ _4857_/Y hold725/X _4859_/A2 _4856_/Y vddd vssd sg13cmos5l_a21oi_1
XFILLER_21_776 vddd vssd sg13cmos5l_decap_4
X_3808_ _3808_/Y mask_rev_in[29] _4079_/B vddd vssd sg13cmos5l_nor2_1
X_4788_ _4790_/B _4818_/A _4787_/Y _4785_/Y vddd vssd sg13cmos5l_o21ai_1
X_6527_ _7216_/D _6675_/A1 _6532_/S hold948/X vddd vssd sg13cmos5l_o21ai_1
XFILLER_14_1298 vddd vssd sg13cmos5l_decap_8
X_3739_ _3739_/Y _4251_/B _6609_/B vddd vssd sg13cmos5l_nor2_1
X_6458_ _6458_/Y _6458_/A1 _6457_/B _6457_/Y vddd vssd sg13cmos5l_a21oi_1
X_6389_ _6389_/X _6389_/A0 _6404_/A _6389_/S vddd vssd sg13cmos5l_mux2_1
XFILLER_27_2327 vddd vssd sg13cmos5l_decap_8
X_5409_ _5409_/Y _5428_/C _5422_/C vddd vssd sg13cmos5l_nor2_1
XFILLER_7_1709 vddd vssd sg13cmos5l_decap_8
XFILLER_5_2134 vddd vssd sg13cmos5l_decap_8
XFILLER_9_1591 vddd vssd sg13cmos5l_decap_8
XFILLER_29_843 vddd vssd sg13cmos5l_decap_8
XFILLER_28_342 vddd vssd sg13cmos5l_decap_8
XFILLER_25_1394 vddd vssd sg13cmos5l_decap_8
XFILLER_18_42 vddd vssd sg13cmos5l_decap_8
XFILLER_5_1444 vddd vssd sg13cmos5l_decap_8
Xwire100 _6652_/A _3866_/Y vddd vssd sg13cmos5l_buf_2
XFILLER_8_714 vddd vssd sg13cmos5l_decap_8
Xwire144 _3652_/A wire145/X vddd vssd sg13cmos5l_buf_4
XFILLER_32_1387 vddd vssd sg13cmos5l_decap_8
Xtiedowns\[79\] clkload0/A vddd vssd sg13cmos5l_antennanp
XFILLER_4_920 vddd vssd sg13cmos5l_decap_8
XFILLER_22_7 vddd vssd sg13cmos5l_decap_8
XFILLER_21_1781 vddd vssd sg13cmos5l_decap_8
XFILLER_17_2518 vddd vssd sg13cmos5l_decap_8
X_5760_ _5761_/C _5758_/X _5759_/X _5766_/C vddd vssd sg13cmos5l_a21oi_1
X_5691_ _5708_/C _5691_/A _7197_/Q vddd vssd sg13cmos5l_nand2_1
X_4711_ _4712_/B _4740_/A _4736_/B _4726_/A vddd vssd sg13cmos5l_a21oi_1
X_4642_ _4643_/C _4670_/A _4670_/B vddd vssd sg13cmos5l_xnor2_1
XFILLER_15_1552 vddd vssd sg13cmos5l_decap_8
X_7361_ _7361_/Q _7379_/CLK _7361_/D _6874_/Y vddd vssd sg13cmos5l_dfrbpq_1
X_4573_ _4573_/Y _6149_/A1 _4599_/B _4551_/B vddd vssd sg13cmos5l_a21oi_1
Xhold703 _3588_/A _7218_/Q vddd vssd sg13cmos5l_dlygate4sd3_1
X_3524_ _5077_/B _3524_/A vddd vssd sg13cmos5l_inv_1
X_7292_ _7292_/Q _7292_/CLK _7292_/D fanout384/X vddd vssd sg13cmos5l_dfrbpq_1
Xhold714 hold714/X _6337_/Y vddd vssd sg13cmos5l_dlygate4sd3_1
Xhold725 hold725/X _3508_/Y vddd vssd sg13cmos5l_dlygate4sd3_1
Xhold736 hold736/X _3540_/Y vddd vssd sg13cmos5l_dlygate4sd3_1
X_6312_ _7104_/D hold966/X _6311_/B _6311_/Y vddd vssd sg13cmos5l_o21ai_1
X_6243_ _6243_/Y _6243_/A _6243_/B _6243_/C vddd vssd sg13cmos5l_nor3_1
Xhold747 _5940_/C _5939_/Y vddd vssd sg13cmos5l_dlygate4sd3_1
Xhold769 _3599_/A _7100_/Q vddd vssd sg13cmos5l_dlygate4sd3_1
Xhold758 _7313_/D _4913_/Y vddd vssd sg13cmos5l_dlygate4sd3_1
Xoutbuffers\[62\] voltgen_ena[2] _7046_/Q vddd vssd sg13cmos5l_buf_16
XFILLER_28_1935 vddd vssd sg13cmos5l_decap_8
XFILLER_26_2371 vddd vssd sg13cmos5l_decap_8
X_6174_ _6174_/Y _5237_/A _5237_/B _5244_/C _6048_/A vddd vssd sg13cmos5l_a22oi_1
Xhold1425 hold1425/X _7187_/Q vddd vssd sg13cmos5l_dlygate4sd3_1
X_5125_ _6065_/C _6150_/B _6043_/B vddd vssd sg13cmos5l_nand2b_1
Xhold1414 _6539_/A1 _5887_/B vddd vssd sg13cmos5l_dlygate4sd3_1
XFILLER_6_1720 vddd vssd sg13cmos5l_decap_8
Xhold1403 _4817_/B _7327_/Q vddd vssd sg13cmos5l_dlygate4sd3_1
Xhold1447 hold532/A _6979_/Q vddd vssd sg13cmos5l_dlygate4sd3_1
Xhold1458 _7335_/D _4635_/X vddd vssd sg13cmos5l_dlygate4sd3_1
X_5056_ _5062_/C _7236_/Q _5163_/B _7238_/Q _7239_/Q vddd vssd sg13cmos5l_nor4_1
XFILLER_6_1764 vddd vssd sg13cmos5l_decap_8
XFILLER_6_2498 vddd vssd sg13cmos5l_decap_8
Xhold1436 _6494_/A1 _5701_/B vddd vssd sg13cmos5l_dlygate4sd3_1
Xhold1469 _6705_/A1 _7048_/Q vddd vssd sg13cmos5l_dlygate4sd3_1
X_4007_ _4007_/Y _4007_/A _4007_/B _4007_/C _4007_/D vddd vssd sg13cmos5l_nand4_1
XFILLER_0_2020 vddd vssd sg13cmos5l_decap_8
XFILLER_0_2097 vddd vssd sg13cmos5l_decap_8
X_5958_ _5983_/C _7232_/Q _5967_/B vddd vssd sg13cmos5l_nand2_1
Xclkbuf_leaf_28_SCK_regs _7125_/CLK clkload6/A vddd vssd sg13cmos5l_buf_8
X_4909_ _7315_/D hold932/X _4920_/C _4908_/Y vddd vssd sg13cmos5l_o21ai_1
X_5889_ _5889_/Y _5828_/A _5887_/Y _5888_/Y _5886_/Y _5861_/Y vddd vssd sg13cmos5l_a221oi_1
XFILLER_5_728 vddd vssd sg13cmos5l_decap_8
XFILLER_20_21 vddd vssd sg13cmos5l_decap_8
XFILLER_20_98 vddd vssd sg13cmos5l_decap_8
XFILLER_0_422 vddd vssd sg13cmos5l_decap_8
XFILLER_1_978 vddd vssd sg13cmos5l_decap_4
XFILLER_7_1528 vddd vssd sg13cmos5l_decap_8
XFILLER_29_30 vddd vssd sg13cmos5l_decap_8
XFILLER_0_499 vddd vssd sg13cmos5l_decap_4
XFILLER_21_1044 vddd vssd sg13cmos5l_decap_8
XFILLER_17_813 vddd vssd sg13cmos5l_decap_8
XFILLER_28_183 vddd vssd sg13cmos5l_decap_8
XFILLER_21_1099 vddd vssd sg13cmos5l_decap_8
XFILLER_32_838 vddd vssd sg13cmos5l_decap_8
XFILLER_8_511 vddd vssd sg13cmos5l_decap_8
XFILLER_16_2595 vddd vssd sg13cmos5l_decap_8
XFILLER_8_588 vddd vssd sg13cmos5l_decap_8
XFILLER_6_56 vddd vssd sg13cmos5l_decap_8
XANTENNA_5 _3728_/Y vddd vssd sg13cmos5l_antennanp
XFILLER_23_2544 vddd vssd sg13cmos5l_decap_8
XFILLER_23_1843 vddd vssd sg13cmos5l_decap_4
XFILLER_6_1049 vddd vssd sg13cmos5l_decap_8
X_6930_ _6930_/Y _6952_/A _6960_/B_N vddd vssd sg13cmos5l_nor2b_1
X_6861_ _6861_/Y _6863_/A _6863_/B_N vddd vssd sg13cmos5l_nor2b_1
XFILLER_23_816 vddd vssd sg13cmos5l_decap_8
X_6792_ _6792_/X _6792_/A vddd vssd sg13cmos5l_buf_1
X_5812_ _5812_/Y _5812_/A _5815_/B vddd vssd sg13cmos5l_nor2_1
XFILLER_17_1603 vddd vssd sg13cmos5l_decap_8
X_5743_ _5743_/Y _7204_/Q _7205_/Q _5769_/A _5769_/B vddd vssd sg13cmos5l_nor4_1
XFILLER_30_2515 vddd vssd sg13cmos5l_decap_8
Xoutbuffers\[6\] proj_vbias_ena _7029_/Q vddd vssd sg13cmos5l_buf_16
XFILLER_17_1636 vddd vssd sg13cmos5l_decap_8
X_5674_ _5674_/Y _5674_/A _5683_/B _7193_/Q _5674_/D vddd vssd sg13cmos5l_nor4_1
X_4625_ _4625_/Y _4599_/C _4620_/Y _4671_/A vddd vssd sg13cmos5l_o21ai_1
Xhold500 _7016_/D hold500/A vddd vssd sg13cmos5l_dlygate4sd3_1
Xhold511 _6995_/D _3468_/Y vddd vssd sg13cmos5l_dlygate4sd3_1
X_4556_ _4556_/Y _4551_/Y _4552_/Y _4555_/Y _4499_/A vddd vssd sg13cmos5l_a22oi_1
X_7344_ _7344_/Q _7348_/CLK _7344_/D _6857_/Y vddd vssd sg13cmos5l_dfrbpq_1
Xhold522 _6795_/A _6993_/Q vddd vssd sg13cmos5l_dlygate4sd3_1
Xhold533 _6980_/D _3479_/Y vddd vssd sg13cmos5l_dlygate4sd3_1
Xhold544 _4674_/B _6984_/Q vddd vssd sg13cmos5l_dlygate4sd3_1
X_3507_ _3507_/Y _3643_/A vddd vssd sg13cmos5l_inv_1
Xhold577 _4480_/A _6992_/Q vddd vssd sg13cmos5l_dlygate4sd3_1
Xhold555 _7012_/D _3462_/Y vddd vssd sg13cmos5l_dlygate4sd3_1
X_7275_ _7275_/Q _7275_/CLK _7275_/D fanout394/X vddd vssd sg13cmos5l_dfrbpq_1
XFILLER_28_2455 vddd vssd sg13cmos5l_decap_8
X_4487_ _4490_/B _4609_/A _4487_/B vddd vssd sg13cmos5l_nor2_1
Xhold588 _3813_/A _7387_/Q vddd vssd sg13cmos5l_dlygate4sd3_1
Xhold566 hold566/X _7362_/Q vddd vssd sg13cmos5l_dlygate4sd3_1
X_6226_ _6226_/X _6226_/A _6226_/B vddd vssd sg13cmos5l_or2_1
Xhold599 _7386_/D _4001_/Y vddd vssd sg13cmos5l_dlygate4sd3_1
XFILLER_26_2190 vddd vssd sg13cmos5l_decap_4
X_6157_ _6157_/X _6155_/Y _6156_/Y _5217_/Y vddd vssd sg13cmos5l_a21o_1
Xhold1200 _3561_/A _7161_/Q vddd vssd sg13cmos5l_dlygate4sd3_1
Xhold1222 _6680_/A0 _7031_/Q vddd vssd sg13cmos5l_dlygate4sd3_1
XFILLER_22_2054 vddd vssd sg13cmos5l_decap_8
X_5108_ _5275_/B _7260_/Q _7261_/Q vddd vssd sg13cmos5l_nand2b_1
Xhold1211 _6524_/A1 _7215_/Q vddd vssd sg13cmos5l_dlygate4sd3_1
Xhold1233 _7151_/D _6405_/Y vddd vssd sg13cmos5l_dlygate4sd3_1
Xhold1266 _6681_/A0 _7032_/Q vddd vssd sg13cmos5l_dlygate4sd3_1
XFILLER_22_1353 vddd vssd sg13cmos5l_decap_8
X_6088_ _6088_/Y _6151_/A _6087_/B _5170_/C _6087_/Y _5168_/C vddd vssd sg13cmos5l_a221oi_1
Xhold1255 _6588_/A0 _7251_/Q vddd vssd sg13cmos5l_dlygate4sd3_1
Xhold1244 _7249_/D _6586_/X vddd vssd sg13cmos5l_dlygate4sd3_1
Xhold1299 _7064_/D _6730_/X vddd vssd sg13cmos5l_dlygate4sd3_1
X_5039_ _5058_/B _5230_/B _5099_/A vddd vssd sg13cmos5l_and2_1
XFILLER_26_610 vddd vssd sg13cmos5l_decap_4
Xhold1288 _7057_/D _6721_/X vddd vssd sg13cmos5l_dlygate4sd3_1
Xhold1277 _7183_/D _6466_/Y vddd vssd sg13cmos5l_dlygate4sd3_1
XFILLER_6_1594 vddd vssd sg13cmos5l_decap_8
XFILLER_25_142 vddd vssd sg13cmos5l_decap_8
XFILLER_15_21 vddd vssd sg13cmos5l_decap_8
XFILLER_31_86 vddd vssd sg13cmos5l_decap_8
XFILLER_29_2219 vddd vssd sg13cmos5l_decap_8
XFILLER_5_525 vddd vssd sg13cmos5l_decap_4
XFILLER_11_2470 vddd vssd sg13cmos5l_decap_8
XFILLER_5_569 vddd vssd sg13cmos5l_decap_4
XFILLER_17_621 vddd vssd sg13cmos5l_decap_4
XFILLER_5_1082 vddd vssd sg13cmos5l_decap_8
XFILLER_17_665 vddd vssd sg13cmos5l_decap_8
XFILLER_17_676 vddd vssd sg13cmos5l_decap_8
X_6900__470 _7388_/CLK _7364_/CLK vddd vssd sg13cmos5l_inv_1
XFILLER_32_635 vddd vssd sg13cmos5l_decap_8
XFILLER_31_156 vddd vssd sg13cmos5l_decap_8
XFILLER_13_882 vddd vssd sg13cmos5l_decap_8
X_4410_ _4410_/Y _4420_/A _4410_/B vddd vssd sg13cmos5l_nor2_1
X_5390_ _5396_/A _5532_/A _5401_/A _5389_/Y vddd vssd sg13cmos5l_a21oi_1
X_4341_ _4341_/Y _4316_/A _4317_/A _4340_/Y hold621/X vddd vssd sg13cmos5l_a22oi_1
X_7060_ _7060_/Q _7060_/CLK _7060_/D fanout356/X vddd vssd sg13cmos5l_dfrbpq_1
X_4272_ _7375_/D _6693_/A1 _4271_/B _4271_/Y vddd vssd sg13cmos5l_o21ai_1
Xfanout309 _5416_/B hold1387/X vddd vssd sg13cmos5l_buf_1
XFILLER_4_591 vddd vssd sg13cmos5l_decap_4
XFILLER_25_1927 vddd vssd sg13cmos5l_decap_4
X_6011_ _6011_/Y _5227_/B _5136_/B _6010_/Y vddd vssd sg13cmos5l_a21oi_1
XFILLER_7_2582 vddd vssd sg13cmos5l_decap_8
XFILLER_23_2374 vddd vssd sg13cmos5l_decap_8
XFILLER_11_0 vddd vssd sg13cmos5l_decap_8
X_6899__469 _7387_/CLK _7399_/CLK vddd vssd sg13cmos5l_inv_1
Xoutbuffers\[25\] voltgen_sink2[1] _7065_/Q vddd vssd sg13cmos5l_buf_16
X_6913_ _6913_/Y _6943_/A _6943_/B_N vddd vssd sg13cmos5l_nor2b_1
XFILLER_19_1709 vddd vssd sg13cmos5l_decap_8
XFILLER_23_646 vddd vssd sg13cmos5l_decap_8
XFILLER_17_2145 vddd vssd sg13cmos5l_decap_8
X_6844_ _6844_/Y _6857_/A _6844_/B_N vddd vssd sg13cmos5l_nor2b_1
X_6775_ _6775_/Y _6564_/A _6781_/S hold643/X vddd vssd sg13cmos5l_a21oi_1
X_3987_ _3987_/Y _7117_/Q _4242_/A2 wire11/X _3986_/Y _4067_/B1 vddd vssd sg13cmos5l_a221oi_1
X_5726_ _5733_/B _7203_/Q _5736_/A vddd vssd sg13cmos5l_nor2b_1
XFILLER_17_1488 vddd vssd sg13cmos5l_decap_8
XFILLER_30_2389 vddd vssd sg13cmos5l_decap_8
XFILLER_30_1655 vddd vssd sg13cmos5l_decap_8
XFILLER_30_1633 vddd vssd sg13cmos5l_decap_8
X_5657_ _5657_/Y _5683_/A _5657_/B _5657_/C vddd vssd sg13cmos5l_nand3_1
X_5588_ _5595_/B _7183_/Q _5597_/A vddd vssd sg13cmos5l_nor2b_1
X_4608_ _4609_/B _4608_/A1 _3607_/Y _4794_/B1 _4604_/B vddd vssd sg13cmos5l_a22oi_1
X_4539_ _4540_/C _4609_/A _4539_/B vddd vssd sg13cmos5l_nor2_1
X_7327_ _7327_/Q _7338_/CLK _7327_/D _6840_/Y vddd vssd sg13cmos5l_dfrbpq_1
XFILLER_24_2105 vddd vssd sg13cmos5l_decap_4
XFILLER_8_2313 vddd vssd sg13cmos5l_decap_8
XFILLER_8_2335 vddd vssd sg13cmos5l_decap_8
X_7258_ _7258_/Q _7259_/CLK _7258_/D fanout390/X vddd vssd sg13cmos5l_dfrbpq_1
X_6209_ _6209_/Y _3493_/Y _7293_/Q _5247_/B vddd vssd sg13cmos5l_a21oi_1
X_7189_ _7189_/Q _7233_/CLK _7189_/D fanout373/X vddd vssd sg13cmos5l_dfrbpq_1
Xhold1041 _7154_/D _6410_/X vddd vssd sg13cmos5l_dlygate4sd3_1
Xhold1030 _3564_/A _7164_/Q vddd vssd sg13cmos5l_dlygate4sd3_1
Xhold1063 _6692_/A _7039_/Q vddd vssd sg13cmos5l_dlygate4sd3_1
Xhold1085 _7261_/D _6606_/Y vddd vssd sg13cmos5l_dlygate4sd3_1
Xhold1052 _5994_/A0 _4932_/A vddd vssd sg13cmos5l_dlygate4sd3_1
Xhold1074 _6545_/A1 _3591_/Y vddd vssd sg13cmos5l_dlygate4sd3_1
XFILLER_26_42 vddd vssd sg13cmos5l_decap_8
Xhold1096 _6565_/A1 _5117_/A vddd vssd sg13cmos5l_dlygate4sd3_1
XFILLER_13_2532 vddd vssd sg13cmos5l_decap_8
XFILLER_31_1408 vddd vssd sg13cmos5l_decap_8
XFILLER_10_841 vddd vssd sg13cmos5l_decap_8
Xtiedowns\[61\] mask_rev_in[17] vddd vssd sg13cmos5l_antennanp
XFILLER_5_366 vddd vssd sg13cmos5l_decap_4
XFILLER_29_1326 vddd vssd sg13cmos5l_decap_8
XFILLER_1_572 vddd vssd sg13cmos5l_decap_4
XFILLER_20_2514 vddd vssd sg13cmos5l_decap_8
XFILLER_18_985 vddd vssd sg13cmos5l_decap_8
Xoutbuffers\[115\] dbus_out[18] _5830_/X vddd vssd sg13cmos5l_buf_16
X_4890_ _4890_/X _4890_/A _5285_/D vddd vssd sg13cmos5l_and2_1
X_3910_ _3910_/Y _3905_/Y _3907_/Y _3909_/Y vddd vssd sg13cmos5l_o21ai_1
X_3841_ _3841_/Y _3963_/A _6315_/A vddd vssd sg13cmos5l_nor2_1
X_3772_ _3772_/Y _3772_/A _3772_/B _3772_/C vddd vssd sg13cmos5l_nand3_1
X_6560_ _7233_/D _6560_/A1 _6562_/S _6559_/Y vddd vssd sg13cmos5l_a21oi_1
XFILLER_14_1617 vddd vssd sg13cmos5l_decap_8
X_5511_ _5511_/Y _5511_/A _7171_/Q _5511_/C vddd vssd sg13cmos5l_nor3_1
XFILLER_12_2042 vddd vssd sg13cmos5l_decap_8
X_6491_ _7196_/D _6491_/A1 _6495_/S _6490_/Y vddd vssd sg13cmos5l_a21oi_1
XFILLER_12_2064 vddd vssd sg13cmos5l_decap_8
X_5442_ _5442_/Y _5649_/A1 _7163_/Q _5440_/Y vddd vssd sg13cmos5l_o21ai_1
XFILLER_12_1341 vddd vssd sg13cmos5l_decap_8
X_5373_ _5373_/Y _5373_/A _5372_/Y vddd vssd sg13cmos5l_nor2b_1
XFILLER_29_2583 vddd vssd sg13cmos5l_decap_8
XFILLER_25_2403 vddd vssd sg13cmos5l_decap_8
X_7112_ _7112_/Q _7127_/CLK _7112_/D _6955_/B_N vddd vssd sg13cmos5l_dfrbpq_1
X_4324_ _4324_/Y _4320_/Y _4324_/B vddd vssd sg13cmos5l_nand2b_1
X_7043_ _7043_/Q _7066_/CLK _7043_/D _6838_/B_N vddd vssd sg13cmos5l_dfrbpq_1
Xfanout117 _3842_/B _3690_/Y vddd vssd sg13cmos5l_buf_1
X_4255_ wire2/A mask_rev_in[24] _4079_/B _4254_/Y vddd vssd sg13cmos5l_o21ai_1
Xfanout139 _4841_/B _4826_/Y vddd vssd sg13cmos5l_buf_1
XFILLER_23_2171 vddd vssd sg13cmos5l_decap_4
XFILLER_3_2232 vddd vssd sg13cmos5l_decap_8
X_4186_ _4186_/Y _5240_/A _6589_/A _6583_/A vddd vssd sg13cmos5l_o21ai_1
XFILLER_3_1542 vddd vssd sg13cmos5l_decap_8
X_6827_ _6827_/Y _6827_/A _6827_/B_N vddd vssd sg13cmos5l_nor2b_1
XFILLER_30_2131 vddd vssd sg13cmos5l_decap_8
XFILLER_17_1263 vddd vssd sg13cmos5l_decap_8
X_6758_ _6758_/X hold822/X _6788_/A _6758_/S vddd vssd sg13cmos5l_mux2_1
X_6689_ _6689_/X _6689_/A0 _5027_/A _6690_/S vddd vssd sg13cmos5l_mux2_1
X_5709_ _5709_/Y _5737_/A _5707_/Y _5708_/Y vddd vssd sg13cmos5l_a21oi_1
XFILLER_6_119 vddd vssd sg13cmos5l_decap_8
XFILLER_12_77 vddd vssd sg13cmos5l_decap_8
XFILLER_8_2110 vddd vssd sg13cmos5l_decap_8
XFILLER_8_2176 vddd vssd sg13cmos5l_decap_8
XFILLER_19_705 vddd vssd sg13cmos5l_decap_8
XFILLER_4_2029 vddd vssd sg13cmos5l_decap_8
XFILLER_26_281 vddd vssd sg13cmos5l_decap_4
XFILLER_15_944 vddd vssd sg13cmos5l_decap_8
XFILLER_2_1085 vddd vssd sg13cmos5l_decap_8
XFILLER_31_1216 vddd vssd sg13cmos5l_decap_4
XFILLER_10_660 vddd vssd sg13cmos5l_decap_8
X_4040_ _4040_/Y _5621_/B _3934_/Y _3937_/Y vddd vssd sg13cmos5l_o21ai_1
XFILLER_4_2574 vddd vssd sg13cmos5l_decap_4
XFILLER_25_708 vddd vssd sg13cmos5l_decap_4
XFILLER_0_2427 vddd vssd sg13cmos5l_decap_8
XFILLER_4_2596 vddd vssd sg13cmos5l_decap_8
XFILLER_20_1665 vddd vssd sg13cmos5l_decap_4
X_5991_ _5991_/X hold958/X _3919_/A _5994_/S vddd vssd sg13cmos5l_mux2_1
X_4942_ _4942_/Y _4933_/A _4958_/B _4945_/B _4941_/Y vddd vssd sg13cmos5l_a22oi_1
XFILLER_21_914 vddd vssd sg13cmos5l_decap_8
XFILLER_32_273 vddd vssd sg13cmos5l_decap_8
X_6612_ _6612_/X _6612_/A0 _6605_/A _6614_/S vddd vssd sg13cmos5l_mux2_1
X_4873_ _4873_/Y _4930_/A _7134_/Q vddd vssd sg13cmos5l_nor2_1
XFILLER_31_2440 vddd vssd sg13cmos5l_decap_8
X_3824_ wire78/A _3929_/A _3929_/B _3978_/A vddd vssd sg13cmos5l_nor3_1
X_6543_ _6543_/X _6632_/A hold666/X _6546_/B vddd vssd sg13cmos5l_mux2_1
X_3755_ wire61/A _3755_/A _3755_/B vddd vssd sg13cmos5l_nand2_1
X_6474_ _6479_/S _6474_/A _6660_/B vddd vssd sg13cmos5l_nand2_1
X_3686_ _3686_/X _4002_/C _3869_/B vddd vssd sg13cmos5l_or2_1
Xoutbuffers\[92\] io_out[7] _6168_/Y vddd vssd sg13cmos5l_buf_16
X_5425_ _5427_/A _5626_/A _5422_/Y _5424_/Y vddd vssd sg13cmos5l_a21oi_1
XFILLER_27_2509 vddd vssd sg13cmos5l_decap_8
XFILLER_29_2380 vddd vssd sg13cmos5l_decap_8
X_5356_ _5372_/C _7148_/Q _7149_/Q vddd vssd sg13cmos5l_and2_1
XFILLER_0_807 vddd vssd sg13cmos5l_decap_4
XFILLER_0_829 vddd vssd sg13cmos5l_decap_8
X_4307_ _4307_/Y _7369_/Q _4301_/B hold566/X vddd vssd sg13cmos5l_a21oi_1
X_5287_ _5287_/Y _4828_/A _3641_/Y _4890_/X vddd vssd sg13cmos5l_a21oi_1
X_7026_ _7026_/Q _7191_/CLK _7026_/D fanout375/X vddd vssd sg13cmos5l_dfrbpq_1
X_4238_ _4239_/C _7130_/Q _4155_/B _6349_/A vddd vssd sg13cmos5l_o21ai_1
XFILLER_25_1565 vddd vssd sg13cmos5l_decap_8
XFILLER_3_2073 vddd vssd sg13cmos5l_decap_8
X_4169_ _4169_/Y mask_rev_in[25] _4079_/B _3997_/A vddd vssd sg13cmos5l_o21ai_1
XFILLER_19_2004 vddd vssd sg13cmos5l_decap_4
XFILLER_24_763 vddd vssd sg13cmos5l_decap_8
XFILLER_23_21 vddd vssd sg13cmos5l_decap_8
XFILLER_12_925 vddd vssd sg13cmos5l_decap_8
XFILLER_11_435 vddd vssd sg13cmos5l_decap_4
XFILLER_23_98 vddd vssd sg13cmos5l_decap_8
XFILLER_10_2524 vddd vssd sg13cmos5l_decap_8
XFILLER_2_100 vddd vssd sg13cmos5l_decap_8
XFILLER_3_656 vddd vssd sg13cmos5l_decap_8
XFILLER_8_1261 vddd vssd sg13cmos5l_decap_4
Xtiedowns\[24\] dbus_in_left[4] vddd vssd sg13cmos5l_antennanp
XFILLER_0_14 vddd vssd sg13cmos5l_decap_8
XFILLER_15_763 vddd vssd sg13cmos5l_decap_8
XFILLER_9_56 vddd vssd sg13cmos5l_decap_8
XFILLER_7_951 vddd vssd sg13cmos5l_decap_8
X_3540_ _3540_/Y _3540_/A vddd vssd sg13cmos5l_inv_1
Xhold918 hold918/X _6668_/Y vddd vssd sg13cmos5l_dlygate4sd3_1
Xhold907 _6468_/A _7184_/Q vddd vssd sg13cmos5l_dlygate4sd3_1
XFILLER_7_984 vddd vssd sg13cmos5l_decap_8
X_3471_ _3471_/Y _4533_/B vddd vssd sg13cmos5l_inv_1
X_5210_ _5210_/Y _5210_/A _5210_/B vddd vssd sg13cmos5l_nor2_1
Xhold929 hold929/X _5932_/Y vddd vssd sg13cmos5l_dlygate4sd3_1
X_6190_ _6190_/Y _7335_/Q _6189_/B _6189_/Y vddd vssd sg13cmos5l_a21oi_1
XFILLER_26_2553 vddd vssd sg13cmos5l_decap_8
X_5141_ _5141_/Y _5141_/A _5141_/B _5141_/C _5141_/D vddd vssd sg13cmos5l_nand4_1
XFILLER_9_1025 vddd vssd sg13cmos5l_decap_8
XFILLER_26_1841 vddd vssd sg13cmos5l_decap_8
X_5072_ _5089_/B _7250_/Q _7251_/Q _5258_/B vddd vssd sg13cmos5l_nor3_1
XFILLER_22_1727 vddd vssd sg13cmos5l_decap_8
X_4023_ _4023_/X dbus_in_left[2] dbus_in_right[2] vddd vssd sg13cmos5l_or2_1
X_5974_ _5975_/C _5972_/X _5973_/X _5980_/C vddd vssd sg13cmos5l_a21oi_1
X_4925_ _4968_/B _4934_/B _4934_/C vddd vssd sg13cmos5l_nand2_1
X_4856_ _4856_/Y sram_odata[1] _4856_/A2 _4855_/Y _4826_/Y _4859_/A2 vddd vssd sg13cmos5l_a221oi_1
Xtiedowns\[8\] _5683_/A vddd vssd sg13cmos5l_antennanp
XFILLER_20_254 vddd vssd sg13cmos5l_decap_8
X_3807_ _3807_/Y mask_rev_in[21] _4253_/B1 _3805_/Y _3806_/Y _3852_/A vddd vssd sg13cmos5l_a221oi_1
X_4787_ _4787_/Y _4786_/B _3599_/Y _4786_/Y vddd vssd sg13cmos5l_a21oi_1
X_6526_ _6526_/Y _6526_/A _6532_/S vddd vssd sg13cmos5l_nand2_1
X_3738_ _3945_/A _3863_/C _3738_/B vddd vssd sg13cmos5l_nand2b_1
X_3669_ _3750_/D _4315_/C _5024_/A _3669_/S vddd vssd sg13cmos5l_mux2_1
X_6457_ _6457_/Y _6465_/A _6457_/B vddd vssd sg13cmos5l_nor2_1
X_6388_ _7142_/D _6388_/A0 _6715_/A _6389_/S vddd vssd sg13cmos5l_mux2_1
X_5408_ _5422_/C _7158_/Q _5408_/B vddd vssd sg13cmos5l_nand2_1
XFILLER_27_1638 vddd vssd sg13cmos5l_decap_8
X_5339_ _5340_/B _5594_/A _7146_/Q _5339_/C _5339_/D vddd vssd sg13cmos5l_nand4_1
XFILLER_0_615 vddd vssd sg13cmos5l_decap_8
XFILLER_5_2113 vddd vssd sg13cmos5l_decap_8
X_7009_ _7009_/Q _7341_/CLK _7009_/D _6956_/Y vddd vssd sg13cmos5l_dfrbpq_1
XFILLER_18_21 vddd vssd sg13cmos5l_decap_8
XFILLER_1_1309 vddd vssd sg13cmos5l_decap_4
XFILLER_11_232 vddd vssd sg13cmos5l_decap_4
Xwire101 _6636_/A _3863_/Y vddd vssd sg13cmos5l_buf_2
XFILLER_32_2078 vddd vssd sg13cmos5l_decap_4
Xwire145 wire145/X _3651_/Y vddd vssd sg13cmos5l_buf_4
XFILLER_32_1366 vddd vssd sg13cmos5l_decap_8
XFILLER_10_1653 vddd vssd sg13cmos5l_decap_8
XFILLER_15_7 vddd vssd sg13cmos5l_decap_8
XFILLER_21_1771 vddd vssd sg13cmos5l_decap_4
XFILLER_22_508 vddd vssd sg13cmos5l_decap_4
XFILLER_22_519 vddd vssd sg13cmos5l_decap_8
XFILLER_15_560 vddd vssd sg13cmos5l_decap_8
X_5690_ _5703_/A _5701_/B _5690_/B vddd vssd sg13cmos5l_nor2_1
X_4710_ _4716_/A _4710_/A _4710_/B vddd vssd sg13cmos5l_nand2_1
X_4641_ _4643_/B _4641_/A _4641_/B vddd vssd sg13cmos5l_nand2_1
X_7360_ _7360_/Q _7379_/CLK _7360_/D _6873_/Y vddd vssd sg13cmos5l_dfrbpq_1
X_4572_ _4572_/Y _4594_/A1 _4571_/Y _4569_/Y vddd vssd sg13cmos5l_o21ai_1
Xhold715 _6372_/A _7135_/Q vddd vssd sg13cmos5l_dlygate4sd3_1
X_3523_ _5085_/B _3523_/A vddd vssd sg13cmos5l_inv_1
Xhold726 _7319_/D _4857_/Y vddd vssd sg13cmos5l_dlygate4sd3_1
Xhold704 hold704/X _3588_/Y vddd vssd sg13cmos5l_dlygate4sd3_1
XFILLER_6_280 vddd vssd sg13cmos5l_decap_8
Xhold737 _7089_/D _6772_/Y vddd vssd sg13cmos5l_dlygate4sd3_1
X_7291_ _7291_/Q _7292_/CLK _7291_/D _6829_/B_N vddd vssd sg13cmos5l_dfrbpq_1
X_6311_ _6311_/Y _6328_/A _6311_/B vddd vssd sg13cmos5l_nand2_1
X_6242_ _6244_/B _6194_/B _5270_/B _6243_/B _4020_/X vddd vssd sg13cmos5l_a22oi_1
Xhold748 _6967_/D _5940_/Y vddd vssd sg13cmos5l_dlygate4sd3_1
Xhold759 _3529_/A _7127_/Q vddd vssd sg13cmos5l_dlygate4sd3_1
XFILLER_6_2400 vddd vssd sg13cmos5l_decap_4
X_6173_ _6173_/Y _6194_/A _5245_/A _5236_/Y vddd vssd sg13cmos5l_o21ai_1
XFILLER_26_2350 vddd vssd sg13cmos5l_decap_8
XFILLER_6_2422 vddd vssd sg13cmos5l_decap_4
Xoutbuffers\[55\] bandgap_ena _7051_/Q vddd vssd sg13cmos5l_buf_16
X_5124_ _5141_/A _7263_/Q _7262_/Q _5216_/A vddd vssd sg13cmos5l_or3_1
Xhold1404 _4823_/A2 _4821_/Y vddd vssd sg13cmos5l_dlygate4sd3_1
Xhold1415 hold1415/X _7077_/Q vddd vssd sg13cmos5l_dlygate4sd3_1
Xhold1459 _6704_/A1 _7047_/Q vddd vssd sg13cmos5l_dlygate4sd3_1
Xhold1426 _6473_/A1 _5620_/B vddd vssd sg13cmos5l_dlygate4sd3_1
Xhold1448 _4789_/B _4772_/X vddd vssd sg13cmos5l_dlygate4sd3_1
X_5055_ _5126_/B _7238_/Q _7239_/Q vddd vssd sg13cmos5l_nor2_1
Xhold1437 _7198_/D _6494_/X vddd vssd sg13cmos5l_dlygate4sd3_1
X_4006_ _4007_/D _7286_/Q _6642_/A _6636_/A _7282_/Q vddd vssd sg13cmos5l_a22oi_1
XFILLER_22_1546 vddd vssd sg13cmos5l_decap_8
XFILLER_26_825 vddd vssd sg13cmos5l_decap_8
XFILLER_20_1270 vddd vssd sg13cmos5l_decap_8
XFILLER_0_2076 vddd vssd sg13cmos5l_decap_8
X_5957_ _5957_/Y _7232_/Q _7233_/Q _5983_/A _5972_/B vddd vssd sg13cmos5l_nor4_1
XFILLER_16_2029 vddd vssd sg13cmos5l_decap_8
X_4908_ _4908_/Y _4920_/A sram_odata[6] _4918_/C vddd vssd sg13cmos5l_nand3_1
X_5888_ _5888_/Y _5679_/A _5884_/Y _5887_/Y vddd vssd sg13cmos5l_a21oi_1
X_4839_ _4839_/Y _4839_/A _4839_/B vddd vssd sg13cmos5l_nand2_1
XFILLER_14_1030 vddd vssd sg13cmos5l_decap_8
Xclkbuf_3_7_0_clk_regs clkbuf_3_7_0_clk_regs/X clkbuf_0_clk_regs/X vddd vssd sg13cmos5l_buf_8
X_6509_ _6509_/X _6501_/A _6509_/A1 _6509_/S vddd vssd sg13cmos5l_mux2_1
XFILLER_4_217 vddd vssd sg13cmos5l_decap_8
XFILLER_11_1962 vddd vssd sg13cmos5l_decap_8
XFILLER_14_1096 vddd vssd sg13cmos5l_decap_8
XFILLER_20_77 vddd vssd sg13cmos5l_decap_8
XFILLER_0_401 vddd vssd sg13cmos5l_decap_8
XFILLER_0_478 vddd vssd sg13cmos5l_decap_8
XFILLER_21_1023 vddd vssd sg13cmos5l_decap_8
XFILLER_29_696 vddd vssd sg13cmos5l_decap_8
XFILLER_28_162 vddd vssd sg13cmos5l_decap_8
XFILLER_21_1078 vddd vssd sg13cmos5l_decap_8
XFILLER_32_817 vddd vssd sg13cmos5l_decap_8
XFILLER_16_2574 vddd vssd sg13cmos5l_decap_8
XFILLER_12_2449 vddd vssd sg13cmos5l_decap_8
XFILLER_16_1895 vddd vssd sg13cmos5l_decap_4
XFILLER_10_2140 vddd vssd sg13cmos5l_decap_8
XFILLER_12_1737 vddd vssd sg13cmos5l_decap_8
XFILLER_32_1185 vddd vssd sg13cmos5l_decap_4
XFILLER_6_35 vddd vssd sg13cmos5l_decap_8
XANTENNA_6 _3728_/Y vddd vssd sg13cmos5l_antennanp
XFILLER_23_2523 vddd vssd sg13cmos5l_decap_8
X_6860_ _6860_/Y _6863_/A _6860_/B_N vddd vssd sg13cmos5l_nor2b_1
X_5811_ _5818_/A _7212_/Q _5815_/B vddd vssd sg13cmos5l_nor2_1
X_6791_ _6791_/Y hold770/X _6790_/B _6790_/Y vddd vssd sg13cmos5l_o21ai_1
XFILLER_16_891 vddd vssd sg13cmos5l_decap_8
X_5742_ _5742_/Y _5916_/A1 _5717_/X _5741_/Y vddd vssd sg13cmos5l_a21oi_1
XFILLER_15_2040 vddd vssd sg13cmos5l_decap_8
X_5673_ _5673_/Y _5666_/Y _5671_/Y _5672_/Y _5682_/A vddd vssd sg13cmos5l_a22oi_1
XFILLER_15_1350 vddd vssd sg13cmos5l_decap_4
X_4624_ _4624_/Y _4624_/A _4624_/B vddd vssd sg13cmos5l_xnor2_1
Xhold501 _7013_/D hold501/A vddd vssd sg13cmos5l_dlygate4sd3_1
X_4555_ _4555_/Y _4530_/C _4550_/Y _4594_/A1 vddd vssd sg13cmos5l_o21ai_1
X_7343_ _7343_/Q _7350_/CLK _7343_/D _6856_/Y vddd vssd sg13cmos5l_dfrbpq_1
Xhold523 _6994_/D _6795_/X vddd vssd sg13cmos5l_dlygate4sd3_1
Xhold512 _6979_/D hold512/A vddd vssd sg13cmos5l_dlygate4sd3_1
Xhold545 _6985_/D _3476_/Y vddd vssd sg13cmos5l_dlygate4sd3_1
Xhold534 _4627_/A _6986_/Q vddd vssd sg13cmos5l_dlygate4sd3_1
X_3506_ _3506_/Y _3506_/A vddd vssd sg13cmos5l_inv_1
Xhold578 _6993_/D _3469_/Y vddd vssd sg13cmos5l_dlygate4sd3_1
X_7274_ _7274_/Q _7275_/CLK _7274_/D fanout388/X vddd vssd sg13cmos5l_dfrbpq_1
XFILLER_28_2434 vddd vssd sg13cmos5l_decap_8
Xhold556 _6797_/A _6983_/Q vddd vssd sg13cmos5l_dlygate4sd3_1
X_4486_ _4487_/B _4435_/A _4477_/B _4481_/B _4773_/B1 vddd vssd sg13cmos5l_a22oi_1
Xhold567 hold567/X _4307_/Y vddd vssd sg13cmos5l_dlygate4sd3_1
X_6225_ _6225_/Y _6237_/C _6230_/C vddd vssd sg13cmos5l_nor2_1
Xhold589 hold589/X _3813_/Y vddd vssd sg13cmos5l_dlygate4sd3_1
XFILLER_28_1788 vddd vssd sg13cmos5l_decap_8
X_6156_ _6156_/Y _6156_/A _6156_/B vddd vssd sg13cmos5l_nand2_1
XFILLER_8_1849 vddd vssd sg13cmos5l_decap_8
Xhold1234 _6614_/A0 _7267_/Q vddd vssd sg13cmos5l_dlygate4sd3_1
Xhold1223 _7031_/D _6680_/X vddd vssd sg13cmos5l_dlygate4sd3_1
X_5107_ _5120_/B _7259_/Q _7258_/Q _5273_/B vddd vssd sg13cmos5l_nor3_1
Xhold1212 _7215_/D _6524_/X vddd vssd sg13cmos5l_dlygate4sd3_1
Xhold1201 _6424_/A1 _5441_/B vddd vssd sg13cmos5l_dlygate4sd3_1
Xhold1267 _7032_/D _6681_/X vddd vssd sg13cmos5l_dlygate4sd3_1
XFILLER_22_2077 vddd vssd sg13cmos5l_decap_8
X_6087_ _6087_/Y _6243_/A _6087_/B vddd vssd sg13cmos5l_nor2_1
XFILLER_22_1332 vddd vssd sg13cmos5l_decap_8
Xhold1245 _3567_/A _7173_/Q vddd vssd sg13cmos5l_dlygate4sd3_1
Xhold1256 _7251_/D _6588_/X vddd vssd sg13cmos5l_dlygate4sd3_1
X_5038_ _5099_/A _7275_/Q _7274_/Q vddd vssd sg13cmos5l_nor2_1
Xhold1278 _3585_/A _7213_/Q vddd vssd sg13cmos5l_dlygate4sd3_1
Xhold1289 _3518_/A _7308_/Q vddd vssd sg13cmos5l_dlygate4sd3_1
XFILLER_25_121 vddd vssd sg13cmos5l_decap_8
XFILLER_26_699 vddd vssd sg13cmos5l_decap_8
X_6989_ _6989_/Q _7337_/CLK _6989_/D _6936_/Y vddd vssd sg13cmos5l_dfrbpq_1
XFILLER_25_198 vddd vssd sg13cmos5l_decap_8
XFILLER_15_77 vddd vssd sg13cmos5l_decap_8
XFILLER_9_309 vddd vssd sg13cmos5l_decap_8
XFILLER_31_65 vddd vssd sg13cmos5l_decap_8
XFILLER_1_754 vddd vssd sg13cmos5l_decap_8
XFILLER_17_644 vddd vssd sg13cmos5l_decap_8
XFILLER_17_688 vddd vssd sg13cmos5l_decap_8
XFILLER_31_135 vddd vssd sg13cmos5l_decap_8
XFILLER_9_821 vddd vssd sg13cmos5l_decap_4
XFILLER_9_887 vddd vssd sg13cmos5l_decap_8
XFILLER_8_386 vddd vssd sg13cmos5l_decap_4
XFILLER_12_1578 vddd vssd sg13cmos5l_decap_8
XFILLER_10_1280 vddd vssd sg13cmos5l_decap_8
X_4340_ _4340_/Y _4317_/A _4317_/B _4339_/Y vddd vssd sg13cmos5l_o21ai_1
X_4271_ _4271_/Y _6686_/A _4271_/B vddd vssd sg13cmos5l_nand2_1
X_6010_ _6010_/Y _3904_/X _5046_/Y _6009_/Y vddd vssd sg13cmos5l_a21oi_1
XFILLER_7_2561 vddd vssd sg13cmos5l_decap_8
XFILLER_7_2594 vddd vssd sg13cmos5l_decap_8
XFILLER_23_1674 vddd vssd sg13cmos5l_decap_8
XFILLER_3_1746 vddd vssd sg13cmos5l_decap_8
X_6912_ _6912_/Y _6943_/A _6943_/B_N vddd vssd sg13cmos5l_nor2b_1
Xoutbuffers\[18\] clk_out outbuffers\[18\]/A vddd vssd sg13cmos5l_buf_16
X_6843_ _6843_/Y _6857_/A _6846_/B_N vddd vssd sg13cmos5l_nor2b_1
XFILLER_17_2124 vddd vssd sg13cmos5l_decap_8
X_6774_ _6774_/Y _6774_/A _6781_/S vddd vssd sg13cmos5l_nor2_1
X_3986_ _3986_/Y _7125_/Q _4156_/A _3985_/Y vddd vssd sg13cmos5l_a21oi_1
XFILLER_17_1467 vddd vssd sg13cmos5l_decap_8
XFILLER_17_1445 vddd vssd sg13cmos5l_decap_4
X_5725_ _5725_/Y _7202_/Q _5723_/Y _5724_/Y vddd vssd sg13cmos5l_o21ai_1
X_5656_ _5657_/C _7190_/Q _7191_/Q vddd vssd sg13cmos5l_nor2_1
XFILLER_30_2368 vddd vssd sg13cmos5l_decap_8
X_4607_ _4610_/B _4807_/A _4607_/B vddd vssd sg13cmos5l_nor2_1
X_5587_ _5593_/A _5585_/Y _5586_/Y _5599_/C vddd vssd sg13cmos5l_o21ai_1
X_4538_ _4539_/B _4608_/A1 _3610_/Y _4794_/B1 _4534_/B vddd vssd sg13cmos5l_a22oi_1
X_7326_ _7326_/Q _7337_/CLK _7326_/D _6839_/Y vddd vssd sg13cmos5l_dfrbpq_1
XFILLER_11_1099 vddd vssd sg13cmos5l_decap_8
X_4469_ _4599_/B _4624_/A _4469_/B vddd vssd sg13cmos5l_nand2_1
X_7257_ _7257_/Q _7259_/CLK _7257_/D fanout390/X vddd vssd sg13cmos5l_dfrbpq_1
X_6208_ _6208_/Y _6122_/A _6207_/A _6207_/Y vddd vssd sg13cmos5l_a21oi_1
X_7188_ _7188_/Q _7188_/CLK _7188_/D fanout373/X vddd vssd sg13cmos5l_dfrbpq_1
Xhold1020 _6719_/A _7056_/Q vddd vssd sg13cmos5l_dlygate4sd3_1
Xhold1042 _3618_/A _7028_/Q vddd vssd sg13cmos5l_dlygate4sd3_1
X_6139_ _6139_/Y _6139_/A _6139_/B _6139_/C vddd vssd sg13cmos5l_nand3_1
Xhold1031 _6431_/A1 _5463_/A vddd vssd sg13cmos5l_dlygate4sd3_1
Xhold1064 _6693_/B1 _6692_/Y vddd vssd sg13cmos5l_dlygate4sd3_1
Xhold1075 _5936_/B _6966_/Q vddd vssd sg13cmos5l_dlygate4sd3_1
Xhold1053 _7305_/D _4947_/X vddd vssd sg13cmos5l_dlygate4sd3_1
Xhold1097 _6625_/A0 _7273_/Q vddd vssd sg13cmos5l_dlygate4sd3_1
XFILLER_26_21 vddd vssd sg13cmos5l_decap_8
Xhold1086 hold480/A hold1517/X vddd vssd sg13cmos5l_dlygate4sd3_1
XFILLER_2_1289 vddd vssd sg13cmos5l_decap_8
XFILLER_26_98 vddd vssd sg13cmos5l_decap_8
XFILLER_13_124 vddd vssd sg13cmos5l_decap_8
Xclkbuf_leaf_12_SCK_regs _7143_/CLK clkload4/A vddd vssd sg13cmos5l_buf_8
XFILLER_13_2511 vddd vssd sg13cmos5l_decap_8
XFILLER_17_1990 vddd vssd sg13cmos5l_decap_8
XFILLER_13_1821 vddd vssd sg13cmos5l_decap_4
XFILLER_13_2588 vddd vssd sg13cmos5l_decap_8
XFILLER_10_897 vddd vssd sg13cmos5l_decap_8
XFILLER_5_345 vddd vssd sg13cmos5l_decap_8
XFILLER_6_879 vddd vssd sg13cmos5l_decap_8
XFILLER_29_1349 vddd vssd sg13cmos5l_decap_4
Xtiedowns\[54\] mask_rev_in[10] vddd vssd sg13cmos5l_antennanp
XFILLER_1_562 vddd vssd sg13cmos5l_decap_4
XFILLER_24_1961 vddd vssd sg13cmos5l_decap_8
X_3840_ _3840_/Y _7110_/Q _4067_/B1 _3838_/Y _3839_/Y _3803_/B vddd vssd sg13cmos5l_a221oi_1
Xoutbuffers\[108\] dbus_out[11] _5634_/Y vddd vssd sg13cmos5l_buf_16
XFILLER_18_2488 vddd vssd sg13cmos5l_decap_8
X_3771_ _3772_/C _7128_/Q _4156_/A wire60/X vddd vssd sg13cmos5l_a21oi_1
XFILLER_16_2190 vddd vssd sg13cmos5l_decap_8
X_5510_ _5510_/Y _5674_/A _5508_/C _5508_/Y vddd vssd sg13cmos5l_o21ai_1
XFILLER_12_2021 vddd vssd sg13cmos5l_decap_8
X_6490_ _6490_/Y _6518_/A _6495_/S vddd vssd sg13cmos5l_nor2_1
XFILLER_9_673 vddd vssd sg13cmos5l_decap_8
XFILLER_12_1331 vddd vssd sg13cmos5l_decap_4
X_5441_ _5441_/Y _5527_/A _5441_/B _5454_/A vddd vssd sg13cmos5l_nor3_1
X_5372_ _5372_/Y _5372_/A _5374_/A _5372_/C vddd vssd sg13cmos5l_nand3_1
XFILLER_29_2562 vddd vssd sg13cmos5l_decap_8
X_7111_ _7111_/Q _7127_/CLK _7111_/D fanout398/X vddd vssd sg13cmos5l_dfrbpq_1
X_4323_ _4324_/B _4323_/A _4323_/B vddd vssd sg13cmos5l_nor2_1
X_7042_ _7042_/Q _7069_/CLK _7042_/D _6838_/B_N vddd vssd sg13cmos5l_dfrbpq_1
Xfanout118 _6361_/A _3690_/Y vddd vssd sg13cmos5l_buf_1
Xfanout129 _6725_/B _6673_/B vddd vssd sg13cmos5l_buf_1
Xfanout107 _3961_/A _3896_/B vddd vssd sg13cmos5l_buf_1
XFILLER_25_2459 vddd vssd sg13cmos5l_decap_8
X_4254_ _4254_/Y _4252_/Y _4254_/B vddd vssd sg13cmos5l_nand2b_1
XFILLER_9_1955 vddd vssd sg13cmos5l_decap_8
X_4185_ _4185_/Y _7260_/Q _3875_/Y _3879_/Y _7256_/Q _3882_/Y vddd vssd sg13cmos5l_a221oi_1
XFILLER_5_1819 vddd vssd sg13cmos5l_decap_8
XFILLER_9_1999 vddd vssd sg13cmos5l_decap_8
XFILLER_27_238 vddd vssd sg13cmos5l_decap_4
X_6826_ _6826_/Y _6829_/A _6829_/B_N vddd vssd sg13cmos5l_nor2b_1
XFILLER_32_2419 vddd vssd sg13cmos5l_decap_8
X_6757_ _7080_/D _6333_/A _6758_/S hold665/X vddd vssd sg13cmos5l_a21oi_1
XFILLER_11_639 vddd vssd sg13cmos5l_decap_8
X_3969_ _3969_/X _7070_/Q _3817_/Y _6725_/A vddd vssd sg13cmos5l_a21o_1
X_5708_ _5708_/Y _7198_/Q _5708_/B _5708_/C vddd vssd sg13cmos5l_nor3_1
XFILLER_10_138 vddd vssd sg13cmos5l_decap_4
X_6688_ _6688_/X _6688_/A0 _6695_/A _6690_/S vddd vssd sg13cmos5l_mux2_1
XFILLER_30_2187 vddd vssd sg13cmos5l_decap_4
XFILLER_30_2198 vddd vssd sg13cmos5l_decap_4
X_5639_ _5642_/C _5639_/A _5639_/B vddd vssd sg13cmos5l_and2_1
XFILLER_12_56 vddd vssd sg13cmos5l_decap_8
X_7309_ _7309_/Q _7340_/CLK _7309_/D _6822_/Y vddd vssd sg13cmos5l_dfrbpq_1
XFILLER_15_901 vddd vssd sg13cmos5l_decap_8
XFILLER_14_400 vddd vssd sg13cmos5l_decap_8
XFILLER_18_1006 vddd vssd sg13cmos5l_decap_8
XFILLER_6_621 vddd vssd sg13cmos5l_decap_8
XFILLER_13_1695 vddd vssd sg13cmos5l_decap_8
XFILLER_24_2492 vddd vssd sg13cmos5l_decap_8
X_5990_ _5990_/X hold883/X _3750_/A _5994_/S vddd vssd sg13cmos5l_mux2_1
X_4941_ _4941_/Y _4941_/A _4941_/B vddd vssd sg13cmos5l_nor2_1
X_4872_ _4898_/A _4951_/A _7135_/Q _7134_/Q _4930_/A vddd vssd sg13cmos5l_a22oi_1
XFILLER_32_252 vddd vssd sg13cmos5l_decap_8
X_3823_ _3823_/Y _7065_/Q _6725_/A vddd vssd sg13cmos5l_nand2b_1
X_6611_ _7264_/D _6710_/A1 _6614_/S hold950/X vddd vssd sg13cmos5l_a21oi_1
XFILLER_14_2149 vddd vssd sg13cmos5l_decap_8
XFILLER_14_1404 vddd vssd sg13cmos5l_decap_8
X_6542_ _6542_/Y _6675_/A1 _6546_/B hold592/X vddd vssd sg13cmos5l_o21ai_1
X_3754_ _3755_/B _3752_/A _3961_/A _3752_/B vddd vssd sg13cmos5l_o21ai_1
XFILLER_31_2496 vddd vssd sg13cmos5l_decap_8
X_6473_ _6473_/X _6465_/A _6473_/A1 _6473_/S vddd vssd sg13cmos5l_mux2_1
X_3685_ _3896_/A _4002_/C _3869_/B vddd vssd sg13cmos5l_nor2_1
Xoutbuffers\[85\] io_out[0] _6020_/X vddd vssd sg13cmos5l_buf_16
X_5424_ _5424_/Y _5594_/A _5409_/Y _5412_/Y _5421_/Y _5422_/Y vddd vssd sg13cmos5l_a221oi_1
X_5355_ _5371_/C _5355_/A _7149_/Q vddd vssd sg13cmos5l_nand2_1
XFILLER_25_2245 vddd vssd sg13cmos5l_decap_8
XFILLER_25_1511 vddd vssd sg13cmos5l_decap_8
X_4306_ _4306_/Y hold1002/X _4976_/B _4976_/C vddd vssd sg13cmos5l_nand3b_1
X_5286_ _5286_/Y hold762/X _4832_/A _5285_/Y vddd vssd sg13cmos5l_o21ai_1
XFILLER_9_2486 vddd vssd sg13cmos5l_decap_8
X_7025_ _7025_/Q _7278_/CLK _7025_/D fanout382/X vddd vssd sg13cmos5l_dfrbpq_1
XFILLER_21_2109 vddd vssd sg13cmos5l_decap_8
X_4237_ _4239_/B _7138_/Q _6378_/A vddd vssd sg13cmos5l_nor2_1
XFILLER_28_514 vddd vssd sg13cmos5l_decap_8
X_4168_ _4168_/Y _3883_/B _3781_/B _4168_/B1 mask_rev_in[17] _4167_/Y vddd vssd sg13cmos5l_a221oi_1
X_4099_ _4099_/Y _7257_/Q _3879_/Y _3882_/Y vddd vssd sg13cmos5l_a21oi_1
XFILLER_19_1315 vddd vssd sg13cmos5l_decap_8
X_6809_ _6809_/X _7076_/Q vddd vssd sg13cmos5l_buf_1
XFILLER_32_1537 vddd vssd sg13cmos5l_decap_8
XFILLER_23_77 vddd vssd sg13cmos5l_decap_8
XFILLER_17_1083 vddd vssd sg13cmos5l_decap_4
XFILLER_10_2503 vddd vssd sg13cmos5l_decap_8
XFILLER_3_668 vddd vssd sg13cmos5l_decap_8
XFILLER_19_503 vddd vssd sg13cmos5l_decap_8
Xfanout460 _6911_/A _6881_/A vddd vssd sg13cmos5l_buf_1
XFILLER_19_536 vddd vssd sg13cmos5l_decap_8
Xtiedowns\[17\] _6216_/A1 vddd vssd sg13cmos5l_antennanp
XFILLER_19_2583 vddd vssd sg13cmos5l_decap_8
XFILLER_9_35 vddd vssd sg13cmos5l_decap_8
XFILLER_14_263 vddd vssd sg13cmos5l_decap_4
XFILLER_30_745 vddd vssd sg13cmos5l_decap_8
XFILLER_15_2458 vddd vssd sg13cmos5l_decap_8
XFILLER_15_1735 vddd vssd sg13cmos5l_decap_8
XFILLER_11_970 vddd vssd sg13cmos5l_decap_8
XFILLER_13_2160 vddd vssd sg13cmos5l_decap_8
Xhold919 _6623_/A _7272_/Q vddd vssd sg13cmos5l_dlygate4sd3_1
Xhold908 hold908/X _6468_/Y vddd vssd sg13cmos5l_dlygate4sd3_1
X_3470_ _3470_/Y _4509_/B vddd vssd sg13cmos5l_inv_1
XFILLER_13_1492 vddd vssd sg13cmos5l_decap_4
XFILLER_6_495 vddd vssd sg13cmos5l_decap_4
XFILLER_9_1004 vddd vssd sg13cmos5l_decap_8
XFILLER_26_2532 vddd vssd sg13cmos5l_decap_8
X_5140_ _5141_/D _7287_/Q _5278_/A _6079_/B _5140_/D vddd vssd sg13cmos5l_nor4_1
X_5071_ _5258_/B _7249_/Q _7248_/Q vddd vssd sg13cmos5l_nand2b_1
X_4022_ _6276_/A dbus_in_left[2] dbus_in_right[2] vddd vssd sg13cmos5l_nor2_1
XFILLER_4_2383 vddd vssd sg13cmos5l_decap_8
XFILLER_25_506 vddd vssd sg13cmos5l_decap_8
X_5973_ _5973_/X _5973_/A _5983_/A vddd vssd sg13cmos5l_or2_1
XFILLER_20_1496 vddd vssd sg13cmos5l_decap_8
XFILLER_0_1568 vddd vssd sg13cmos5l_decap_4
X_4924_ _4934_/C _4828_/A _4888_/Y _4889_/B vddd vssd sg13cmos5l_o21ai_1
XFILLER_21_756 vddd vssd sg13cmos5l_decap_8
X_4855_ _4855_/Y _4855_/A _4855_/B vddd vssd sg13cmos5l_xnor2_1
X_4786_ _4786_/Y _4786_/A _4786_/B vddd vssd sg13cmos5l_nor2_1
X_3806_ _3806_/Y mask_rev_in[13] _4077_/B vddd vssd sg13cmos5l_nand2b_1
X_6525_ _6532_/S _6525_/A _6667_/B vddd vssd sg13cmos5l_nand2_1
X_3737_ _3981_/B _3863_/C _3737_/B vddd vssd sg13cmos5l_nor2_1
X_3668_ _4342_/A _4315_/C _3669_/S vddd vssd sg13cmos5l_nor2_1
X_6456_ _6456_/Y _6456_/A1 _6457_/B _6455_/Y vddd vssd sg13cmos5l_a21oi_1
X_6387_ _7141_/D _6387_/A1 _6389_/S _6386_/Y vddd vssd sg13cmos5l_o21ai_1
X_5407_ _5428_/C _5416_/B _7156_/Q vddd vssd sg13cmos5l_nand2b_1
X_3599_ _3599_/Y _3599_/A vddd vssd sg13cmos5l_inv_1
XFILLER_27_1617 vddd vssd sg13cmos5l_decap_8
X_5338_ _5338_/Y _7144_/Q _7145_/Q _5338_/C _7147_/Q vddd vssd sg13cmos5l_nor4_1
XFILLER_0_638 vddd vssd sg13cmos5l_decap_8
XFILLER_25_2042 vddd vssd sg13cmos5l_decap_4
X_7008_ _7008_/Q _7340_/CLK _7008_/D _6955_/Y vddd vssd sg13cmos5l_dfrbpq_1
XFILLER_25_2075 vddd vssd sg13cmos5l_decap_4
X_5269_ _5279_/B _5269_/A _5269_/B vddd vssd sg13cmos5l_nor2_1
XFILLER_28_322 vddd vssd sg13cmos5l_decap_8
XFILLER_25_1363 vddd vssd sg13cmos5l_decap_8
XFILLER_21_1205 vddd vssd sg13cmos5l_decap_8
XFILLER_5_1479 vddd vssd sg13cmos5l_decap_8
XFILLER_19_1112 vddd vssd sg13cmos5l_decap_4
XFILLER_3_1192 vddd vssd sg13cmos5l_decap_4
XFILLER_19_1145 vddd vssd sg13cmos5l_decap_4
XFILLER_32_1312 vddd vssd sg13cmos5l_decap_8
Xwire102 _6609_/B _3945_/A vddd vssd sg13cmos5l_buf_8
Xwire113 _3883_/B _3698_/Y vddd vssd sg13cmos5l_buf_4
XFILLER_32_1345 vddd vssd sg13cmos5l_decap_8
XFILLER_8_749 vddd vssd sg13cmos5l_decap_8
XFILLER_4_944 vddd vssd sg13cmos5l_decap_8
XFILLER_10_1632 vddd vssd sg13cmos5l_decap_8
Xclkbuf_3_1_0_SCK_regs clkload2/A clkbuf_0_SCK_regs/X vddd vssd sg13cmos5l_buf_8
XFILLER_1_0 vddd vssd sg13cmos5l_decap_8
Xfanout290 _5786_/B hold1368/X vddd vssd sg13cmos5l_buf_1
XFILLER_8_1092 vddd vssd sg13cmos5l_decap_4
XFILLER_21_2484 vddd vssd sg13cmos5l_decap_8
X_4640_ _4640_/Y _4819_/A _4639_/Y _4637_/X vddd vssd sg13cmos5l_o21ai_1
XFILLER_32_2580 vddd vssd sg13cmos5l_decap_8
X_4571_ _4571_/Y _4592_/B _3608_/Y _4570_/Y vddd vssd sg13cmos5l_a21oi_1
XFILLER_15_1598 vddd vssd sg13cmos5l_decap_8
X_6310_ _7103_/D hold916/X _6311_/B _6309_/Y vddd vssd sg13cmos5l_o21ai_1
Xhold705 _4310_/A _7360_/Q vddd vssd sg13cmos5l_dlygate4sd3_1
Xhold716 hold716/X _6372_/Y vddd vssd sg13cmos5l_dlygate4sd3_1
Xhold727 _6376_/A _7137_/Q vddd vssd sg13cmos5l_dlygate4sd3_1
X_3522_ _4981_/B _3522_/A vddd vssd sg13cmos5l_inv_1
X_7290_ _7290_/Q _7292_/CLK _7290_/D _6829_/B_N vddd vssd sg13cmos5l_dfrbpq_1
Xhold738 hold738/X _7351_/Q vddd vssd sg13cmos5l_dlygate4sd3_1
X_6241_ _6248_/B _6241_/A _6241_/B vddd vssd sg13cmos5l_nor2_1
Xhold749 hold749/X _7095_/Q vddd vssd sg13cmos5l_dlygate4sd3_1
X_6172_ _6172_/Y _6194_/B _5230_/B _6171_/B _4020_/X _6171_/Y vddd vssd sg13cmos5l_a221oi_1
X_5123_ _6065_/B _5215_/A _5110_/C vddd vssd sg13cmos5l_nor2b_1
Xhold1405 _4824_/B1 _4823_/Y vddd vssd sg13cmos5l_dlygate4sd3_1
Xhold1416 _6749_/A _4460_/A vddd vssd sg13cmos5l_dlygate4sd3_1
Xoutbuffers\[48\] bandgap_trim[9] _6294_/Y vddd vssd sg13cmos5l_buf_16
Xhold1427 _7187_/D _6473_/X vddd vssd sg13cmos5l_dlygate4sd3_1
X_5054_ _5058_/D _5228_/A _7277_/Q _7279_/Q _7278_/Q vddd vssd sg13cmos5l_nor4_1
XFILLER_22_1525 vddd vssd sg13cmos5l_decap_8
Xhold1449 _4792_/A2 _4791_/Y vddd vssd sg13cmos5l_dlygate4sd3_1
Xhold1438 _4758_/A _7330_/Q vddd vssd sg13cmos5l_dlygate4sd3_1
X_4005_ _4007_/C _6189_/B _6652_/A wire99/X vddd vssd sg13cmos5l_a21oi_1
XFILLER_2_1619 vddd vssd sg13cmos5l_decap_8
XFILLER_0_2055 vddd vssd sg13cmos5l_decap_8
XFILLER_26_859 vddd vssd sg13cmos5l_decap_8
X_5956_ _5956_/X _6973_/D _5956_/B vddd vssd sg13cmos5l_and2_1
XFILLER_16_2008 vddd vssd sg13cmos5l_decap_8
X_5887_ _5887_/Y _5887_/A _5887_/B _5887_/C vddd vssd sg13cmos5l_nor3_1
X_4907_ _4907_/Y hold813/X _4920_/C _4906_/Y vddd vssd sg13cmos5l_o21ai_1
XFILLER_21_542 vddd vssd sg13cmos5l_decap_8
X_4838_ _4838_/Y sram_odata[6] _4856_/A2 _4837_/X _4841_/B vddd vssd sg13cmos5l_a22oi_1
X_4769_ _4769_/Y _4769_/A1 _4752_/Y _4765_/Y _4768_/Y vddd vssd sg13cmos5l_a22oi_1
X_6508_ _6508_/X _6553_/A hold874/X _6509_/S vddd vssd sg13cmos5l_mux2_1
XFILLER_20_56 vddd vssd sg13cmos5l_decap_8
X_6439_ _7169_/D hold934/X _6441_/B _6438_/Y vddd vssd sg13cmos5l_a21oi_1
Xclkbuf_leaf_37_SCK_regs _7206_/CLK clkload2/A vddd vssd sg13cmos5l_buf_8
XFILLER_0_457 vddd vssd sg13cmos5l_decap_8
XFILLER_29_65 vddd vssd sg13cmos5l_decap_8
XFILLER_28_141 vddd vssd sg13cmos5l_decap_8
XFILLER_29_675 vddd vssd sg13cmos5l_decap_8
XFILLER_5_1287 vddd vssd sg13cmos5l_decap_8
XFILLER_25_881 vddd vssd sg13cmos5l_decap_8
XFILLER_25_892 vddd vssd sg13cmos5l_decap_8
XFILLER_16_2553 vddd vssd sg13cmos5l_decap_8
XFILLER_12_553 vddd vssd sg13cmos5l_decap_8
XFILLER_32_1164 vddd vssd sg13cmos5l_decap_8
XFILLER_6_14 vddd vssd sg13cmos5l_decap_8
XFILLER_12_1716 vddd vssd sg13cmos5l_decap_8
XANTENNA_7 _3728_/Y vddd vssd sg13cmos5l_antennanp
XFILLER_10_1440 vddd vssd sg13cmos5l_decap_8
XFILLER_4_763 vddd vssd sg13cmos5l_decap_8
XFILLER_10_1473 vddd vssd sg13cmos5l_decap_8
XFILLER_23_2502 vddd vssd sg13cmos5l_decap_8
XFILLER_6_1018 vddd vssd sg13cmos5l_decap_8
XFILLER_23_2579 vddd vssd sg13cmos5l_decap_8
XFILLER_3_1939 vddd vssd sg13cmos5l_decap_8
XFILLER_23_1878 vddd vssd sg13cmos5l_decap_8
X_5810_ _5810_/Y _5808_/Y _5809_/Y _3586_/Y vddd vssd sg13cmos5l_o21ai_1
X_6790_ _6790_/Y _6790_/A _6790_/B vddd vssd sg13cmos5l_nand2_1
X_5741_ _5741_/Y _5733_/A _5739_/A _5739_/X _5571_/A _5740_/Y vddd vssd sg13cmos5l_a221oi_1
X_5672_ _5672_/Y _5903_/A _7192_/Q _5674_/D vddd vssd sg13cmos5l_a21oi_1
X_4623_ _4623_/Y _4623_/A _4623_/B vddd vssd sg13cmos5l_nor2_1
Xhold502 _4650_/B _6985_/Q vddd vssd sg13cmos5l_dlygate4sd3_1
X_4554_ _4554_/Y _4526_/B _4543_/Y _4782_/A vddd vssd sg13cmos5l_o21ai_1
X_7342_ _7342_/Q _7351_/CLK _7342_/D _6855_/Y vddd vssd sg13cmos5l_dfrbpq_1
Xhold524 _3633_/B _6995_/Q vddd vssd sg13cmos5l_dlygate4sd3_1
X_7273_ _7273_/Q _7275_/CLK _7273_/D fanout388/X vddd vssd sg13cmos5l_dfrbpq_1
Xhold513 _7008_/D hold513/A vddd vssd sg13cmos5l_dlygate4sd3_1
XFILLER_28_2413 vddd vssd sg13cmos5l_decap_8
Xhold535 _6987_/D _3474_/Y vddd vssd sg13cmos5l_dlygate4sd3_1
X_3505_ _3505_/Y _3505_/A vddd vssd sg13cmos5l_inv_1
Xhold546 _5023_/B _7016_/Q vddd vssd sg13cmos5l_dlygate4sd3_1
Xhold557 _6984_/D _6797_/X vddd vssd sg13cmos5l_dlygate4sd3_1
X_6224_ _6230_/C _6226_/B _7230_/Q vddd vssd sg13cmos5l_nand2b_1
Xhold579 _4173_/A _7384_/Q vddd vssd sg13cmos5l_dlygate4sd3_1
X_4485_ _4485_/Y _4460_/A _4641_/A _4430_/B vddd vssd sg13cmos5l_a21oi_1
XFILLER_8_2529 vddd vssd sg13cmos5l_decap_8
Xhold568 _7362_/D _4309_/Y vddd vssd sg13cmos5l_dlygate4sd3_1
XFILLER_28_1723 vddd vssd sg13cmos5l_decap_8
X_6155_ _6155_/Y _5210_/Y _6153_/Y _6154_/Y vddd vssd sg13cmos5l_o21ai_1
XFILLER_24_1609 vddd vssd sg13cmos5l_decap_8
Xhold1213 _6620_/A0 _7270_/Q vddd vssd sg13cmos5l_dlygate4sd3_1
Xhold1202 _6663_/A1 _7019_/Q vddd vssd sg13cmos5l_dlygate4sd3_1
Xhold1224 _6608_/A0 _7263_/Q vddd vssd sg13cmos5l_dlygate4sd3_1
X_5106_ _5273_/B _7256_/Q _7257_/Q vddd vssd sg13cmos5l_nand2b_1
X_6086_ _6086_/Y _4638_/A _6063_/B _6085_/Y vddd vssd sg13cmos5l_o21ai_1
X_5037_ _5230_/B _7272_/Q _7273_/Q vddd vssd sg13cmos5l_nor2_1
Xhold1235 _7267_/D _6614_/X vddd vssd sg13cmos5l_dlygate4sd3_1
Xhold1246 _6447_/A1 _5527_/B vddd vssd sg13cmos5l_dlygate4sd3_1
Xhold1257 _3659_/C _7365_/Q vddd vssd sg13cmos5l_dlygate4sd3_1
Xhold1268 _6728_/A1 _7062_/Q vddd vssd sg13cmos5l_dlygate4sd3_1
Xhold1279 _6521_/A1 _5815_/B vddd vssd sg13cmos5l_dlygate4sd3_1
XFILLER_25_100 vddd vssd sg13cmos5l_decap_8
X_6988_ _6988_/Q _7340_/CLK _6988_/D _6935_/Y vddd vssd sg13cmos5l_dfrbpq_1
XFILLER_25_177 vddd vssd sg13cmos5l_decap_8
XFILLER_15_56 vddd vssd sg13cmos5l_decap_8
XFILLER_22_862 vddd vssd sg13cmos5l_decap_8
X_5939_ _5939_/Y _5939_/A _5939_/B vddd vssd sg13cmos5l_nor2_1
XFILLER_31_44 vddd vssd sg13cmos5l_decap_8
XFILLER_0_232 vddd vssd sg13cmos5l_decap_8
XFILLER_27_1266 vddd vssd sg13cmos5l_decap_8
XFILLER_0_276 vddd vssd sg13cmos5l_decap_8
XFILLER_31_114 vddd vssd sg13cmos5l_decap_8
XFILLER_12_2225 vddd vssd sg13cmos5l_decap_8
XFILLER_8_354 vddd vssd sg13cmos5l_decap_8
XFILLER_9_855 vddd vssd sg13cmos5l_decap_4
XFILLER_12_1546 vddd vssd sg13cmos5l_decap_8
XFILLER_4_560 vddd vssd sg13cmos5l_decap_8
X_4270_ _7376_/D _6686_/A _6695_/A _4271_/B vddd vssd sg13cmos5l_mux2_1
XFILLER_7_2540 vddd vssd sg13cmos5l_decap_8
XFILLER_23_1620 vddd vssd sg13cmos5l_decap_8
X_6911_ _6911_/Y _6911_/A _6911_/B_N vddd vssd sg13cmos5l_nor2b_1
X_6842_ _6842_/Y _6857_/A _6844_/B_N vddd vssd sg13cmos5l_nor2b_1
X_6773_ _6773_/Y _6773_/A _6773_/B _6773_/C vddd vssd sg13cmos5l_nor3_1
X_3985_ _3985_/Y _7133_/Q _3705_/Y _3701_/Y vddd vssd sg13cmos5l_o21ai_1
X_5724_ _5724_/Y _3546_/Y _3581_/Y _5722_/Y _5736_/A vddd vssd sg13cmos5l_a22oi_1
XFILLER_30_2347 vddd vssd sg13cmos5l_decap_8
X_5655_ _5655_/Y _5655_/A _5655_/B vddd vssd sg13cmos5l_nand2_1
X_4606_ _4607_/B _4805_/B1 _4594_/Y _4602_/Y _4605_/Y vddd vssd sg13cmos5l_a22oi_1
X_5586_ _5586_/Y _5649_/A1 _7183_/Q _5584_/Y vddd vssd sg13cmos5l_o21ai_1
X_7325_ _7325_/Q _7395_/CLK _7325_/D _6838_/Y vddd vssd sg13cmos5l_dfrbpq_1
XFILLER_11_1056 vddd vssd sg13cmos5l_decap_4
XFILLER_28_2221 vddd vssd sg13cmos5l_decap_8
X_4537_ _4540_/B _4609_/A _4537_/B vddd vssd sg13cmos5l_and2_1
XFILLER_11_1078 vddd vssd sg13cmos5l_decap_8
X_7256_ _7256_/Q _7259_/CLK _7256_/D fanout390/X vddd vssd sg13cmos5l_dfrbpq_1
XFILLER_8_2326 vddd vssd sg13cmos5l_decap_4
X_4468_ _4469_/B _4614_/A _4670_/A _4670_/B vddd vssd sg13cmos5l_nor3_1
X_7187_ _7187_/Q _7187_/CLK _7187_/D fanout369/X vddd vssd sg13cmos5l_dfrbpq_1
X_6207_ _6207_/Y _6207_/A _6207_/B vddd vssd sg13cmos5l_nor2_1
X_6138_ _6139_/C _6138_/A _6138_/B vddd vssd sg13cmos5l_nand2_1
X_4399_ _4403_/C _4409_/A _4402_/B vddd vssd sg13cmos5l_and2_1
Xhold1021 _6720_/B1 _6719_/Y vddd vssd sg13cmos5l_dlygate4sd3_1
Xhold1032 _6641_/A0 _7283_/Q vddd vssd sg13cmos5l_dlygate4sd3_1
Xhold1010 _3553_/A _7145_/Q vddd vssd sg13cmos5l_dlygate4sd3_1
XFILLER_6_2072 vddd vssd sg13cmos5l_decap_8
Xhold1043 _6677_/A1 _3618_/Y vddd vssd sg13cmos5l_dlygate4sd3_1
Xhold1065 _3536_/A _7293_/Q vddd vssd sg13cmos5l_dlygate4sd3_1
Xhold1076 _5950_/A2 _5949_/C vddd vssd sg13cmos5l_dlygate4sd3_1
X_6069_ _6069_/Y _6156_/A _5139_/C _5141_/A vddd vssd sg13cmos5l_o21ai_1
Xhold1054 _6575_/A0 _7243_/Q vddd vssd sg13cmos5l_dlygate4sd3_1
Xhold1098 _7273_/D _6625_/X vddd vssd sg13cmos5l_dlygate4sd3_1
Xhold1087 _5997_/A2 _4933_/A vddd vssd sg13cmos5l_dlygate4sd3_1
XFILLER_26_77 vddd vssd sg13cmos5l_decap_8
XFILLER_13_103 vddd vssd sg13cmos5l_decap_4
XFILLER_10_832 vddd vssd sg13cmos5l_decap_4
XFILLER_13_2567 vddd vssd sg13cmos5l_decap_8
XFILLER_6_814 vddd vssd sg13cmos5l_decap_8
XFILLER_13_1877 vddd vssd sg13cmos5l_decap_8
Xtiedowns\[47\] mask_rev_in[3] vddd vssd sg13cmos5l_antennanp
XFILLER_3_59 vddd vssd sg13cmos5l_decap_8
XFILLER_7_1113 vddd vssd sg13cmos5l_decap_8
XFILLER_27_1074 vddd vssd sg13cmos5l_decap_8
XFILLER_20_2549 vddd vssd sg13cmos5l_decap_8
XFILLER_17_453 vddd vssd sg13cmos5l_decap_4
XFILLER_32_434 vddd vssd sg13cmos5l_decap_8
XFILLER_18_2467 vddd vssd sg13cmos5l_decap_8
XFILLER_31_2601 vddd vssd sg13cmos5l_decap_4
X_3770_ wire60/A _7136_/Q _4155_/B vddd vssd sg13cmos5l_nor2_1
XFILLER_13_681 vddd vssd sg13cmos5l_decap_8
XFILLER_16_1490 vddd vssd sg13cmos5l_decap_8
XFILLER_12_1310 vddd vssd sg13cmos5l_decap_8
X_5440_ _5440_/Y _5453_/C _5439_/Y _5454_/A vddd vssd sg13cmos5l_o21ai_1
X_5371_ _5373_/A _7150_/Q _7151_/Q _5371_/C vddd vssd sg13cmos5l_nor3_1
XFILLER_29_2541 vddd vssd sg13cmos5l_decap_8
X_4322_ _4322_/Y _4321_/Y _4323_/A vddd vssd sg13cmos5l_nand2b_1
X_7110_ _7110_/Q _7127_/CLK _7110_/D _6955_/B_N vddd vssd sg13cmos5l_dfrbpq_1
XFILLER_5_891 vddd vssd sg13cmos5l_decap_8
X_7041_ _7041_/Q _7066_/CLK _7041_/D _6871_/B_N vddd vssd sg13cmos5l_dfrbpq_1
XFILLER_25_2438 vddd vssd sg13cmos5l_decap_8
Xfanout119 _6642_/A _3687_/Y vddd vssd sg13cmos5l_buf_1
Xfanout108 _3922_/A _3717_/Y vddd vssd sg13cmos5l_buf_1
X_4253_ _4254_/B mask_rev_in[8] _4252_/A _4253_/B1 mask_rev_in[16] _3745_/Y vddd vssd
+ sg13cmos5l_a221oi_1
XFILLER_4_390 vddd vssd sg13cmos5l_decap_8
XFILLER_25_1715 vddd vssd sg13cmos5l_decap_8
X_4184_ _4184_/Y _4181_/Y _4183_/Y _4175_/Y vddd vssd sg13cmos5l_o21ai_1
XFILLER_5_1809 vddd vssd sg13cmos5l_decap_8
XFILLER_27_217 vddd vssd sg13cmos5l_decap_8
XFILLER_23_1450 vddd vssd sg13cmos5l_decap_8
XFILLER_3_2267 vddd vssd sg13cmos5l_decap_8
Xoutbuffers\[30\] bandgap_sink2[0] _7059_/Q vddd vssd sg13cmos5l_buf_16
XFILLER_3_1599 vddd vssd sg13cmos5l_decap_8
XFILLER_24_924 vddd vssd sg13cmos5l_decap_4
XFILLER_24_968 vddd vssd sg13cmos5l_decap_8
X_6825_ _6825_/Y _6828_/A _6825_/B_N vddd vssd sg13cmos5l_nor2b_1
XFILLER_1_1290 vddd vssd sg13cmos5l_decap_8
X_3968_ _3968_/Y _5339_/C _4053_/B _3966_/Y vddd vssd sg13cmos5l_a21oi_1
X_6756_ _6756_/Y _6756_/A _6758_/S vddd vssd sg13cmos5l_nor2_1
X_5707_ _5707_/Y _7198_/Q _5708_/B _5707_/C vddd vssd sg13cmos5l_nor3_1
XFILLER_10_128 vddd vssd sg13cmos5l_decap_4
X_3899_ _6262_/A dbus_in_left[11] dbus_in_right[11] vddd vssd sg13cmos5l_nor2_1
X_6687_ _7035_/D _6687_/A1 _6690_/S _6686_/Y vddd vssd sg13cmos5l_o21ai_1
XFILLER_12_35 vddd vssd sg13cmos5l_decap_8
X_5638_ _5639_/B _7188_/Q _5651_/A vddd vssd sg13cmos5l_nor2b_1
X_5569_ _5569_/Y _5626_/A _5568_/A _5568_/Y _5564_/Y vddd vssd sg13cmos5l_a22oi_1
XFILLER_3_828 vddd vssd sg13cmos5l_decap_4
XFILLER_5_7 vddd vssd sg13cmos5l_decap_4
X_7308_ _7308_/Q _7393_/CLK _7308_/D _6821_/Y vddd vssd sg13cmos5l_dfrbpq_1
X_7239_ _7239_/Q _7285_/CLK _7239_/D fanout386/X vddd vssd sg13cmos5l_dfrbpq_1
XFILLER_24_1225 vddd vssd sg13cmos5l_decap_8
XFILLER_8_1477 vddd vssd sg13cmos5l_decap_4
XFILLER_8_1499 vddd vssd sg13cmos5l_decap_8
XFILLER_2_1043 vddd vssd sg13cmos5l_decap_8
XFILLER_14_434 vddd vssd sg13cmos5l_decap_8
XFILLER_5_121 vddd vssd sg13cmos5l_decap_4
XFILLER_6_688 vddd vssd sg13cmos5l_decap_8
XFILLER_29_1114 vddd vssd sg13cmos5l_decap_8
XFILLER_5_187 vddd vssd sg13cmos5l_decap_4
XFILLER_24_2471 vddd vssd sg13cmos5l_decap_8
XFILLER_20_2302 vddd vssd sg13cmos5l_decap_8
XFILLER_4_2565 vddd vssd sg13cmos5l_decap_4
XFILLER_20_1623 vddd vssd sg13cmos5l_decap_4
Xoutbuffers\[120\] dbus_out[23] _5986_/Y vddd vssd sg13cmos5l_buf_16
X_4940_ _4941_/B _4933_/A _4945_/A _4946_/A vddd vssd sg13cmos5l_a21oi_1
XFILLER_32_231 vddd vssd sg13cmos5l_decap_8
XFILLER_18_2220 vddd vssd sg13cmos5l_decap_8
X_4871_ _4871_/Y _4885_/B _4871_/B _4871_/C vddd vssd sg13cmos5l_nor3_1
XFILLER_17_294 vddd vssd sg13cmos5l_decap_8
X_3822_ _3822_/Y _3822_/A _3822_/B _3822_/C vddd vssd sg13cmos5l_nand3_1
X_6610_ _6610_/Y _6610_/A _6614_/S vddd vssd sg13cmos5l_nor2_1
XFILLER_14_2106 vddd vssd sg13cmos5l_decap_8
XFILLER_21_949 vddd vssd sg13cmos5l_decap_8
XFILLER_20_437 vddd vssd sg13cmos5l_decap_8
XFILLER_18_1574 vddd vssd sg13cmos5l_decap_8
X_6541_ _6541_/Y _6541_/A _6546_/B vddd vssd sg13cmos5l_nand2_1
X_3753_ _3753_/X _3755_/A _3753_/B vddd vssd sg13cmos5l_and2_1
XFILLER_31_2475 vddd vssd sg13cmos5l_decap_8
X_6472_ _6472_/X _6455_/A _6472_/A1 _6473_/S vddd vssd sg13cmos5l_mux2_1
X_3684_ _3869_/B _3717_/A _3919_/A vddd vssd sg13cmos5l_or2_1
X_5423_ _5423_/Y _5398_/A _5413_/Y _5414_/X _5372_/A vddd vssd sg13cmos5l_a22oi_1
X_5354_ _5354_/Y _3545_/Y _5368_/A _5374_/B _3544_/Y _3557_/Y vddd vssd sg13cmos5l_a221oi_1
X_4305_ _4305_/Y _3483_/Y hold630/X _4293_/B vddd vssd sg13cmos5l_a21oi_1
Xoutbuffers\[78\] io_oe[5] _5189_/Y vddd vssd sg13cmos5l_buf_16
X_5285_ _5285_/Y _5285_/A _5285_/B _5285_/C _5285_/D vddd vssd sg13cmos5l_nand4_1
XFILLER_9_1731 vddd vssd sg13cmos5l_decap_8
XFILLER_9_2465 vddd vssd sg13cmos5l_decap_4
X_7024_ _7024_/Q _7278_/CLK _7024_/D fanout382/X vddd vssd sg13cmos5l_dfrbpq_1
X_4236_ _4239_/A _4233_/X _4234_/Y _4235_/Y vddd vssd sg13cmos5l_a21oi_1
XFILLER_4_91 vddd vssd sg13cmos5l_decap_8
X_4167_ _4167_/Y _3614_/Y _4252_/A _4165_/Y _4166_/Y _4168_/B1 vddd vssd sg13cmos5l_a221oi_1
XFILLER_28_548 vddd vssd sg13cmos5l_decap_8
X_4098_ _4098_/Y _4095_/Y _4096_/X _4097_/Y vddd vssd sg13cmos5l_o21ai_1
XFILLER_32_2206 vddd vssd sg13cmos5l_decap_4
XFILLER_19_1349 vddd vssd sg13cmos5l_decap_8
X_6808_ _6808_/Y _6911_/A _6909_/B_N vddd vssd sg13cmos5l_nor2b_1
XFILLER_32_1516 vddd vssd sg13cmos5l_decap_8
X_6739_ _6739_/X _6739_/A0 _6739_/A1 _6739_/S vddd vssd sg13cmos5l_mux2_1
XFILLER_23_56 vddd vssd sg13cmos5l_decap_8
XFILLER_10_2559 vddd vssd sg13cmos5l_decap_8
Xfanout450 _5728_/A _6227_/A1 vddd vssd sg13cmos5l_buf_1
Xfanout461 _6881_/A _6909_/A vddd vssd sg13cmos5l_buf_1
XFILLER_4_1127 vddd vssd sg13cmos5l_decap_4
XFILLER_21_1954 vddd vssd sg13cmos5l_decap_8
XFILLER_0_49 vddd vssd sg13cmos5l_decap_8
XFILLER_30_702 vddd vssd sg13cmos5l_decap_8
XFILLER_19_2562 vddd vssd sg13cmos5l_decap_8
XFILLER_9_14 vddd vssd sg13cmos5l_decap_8
XFILLER_19_1883 vddd vssd sg13cmos5l_decap_8
XFILLER_15_2437 vddd vssd sg13cmos5l_decap_8
Xfanout90 _4073_/A _3730_/Y vddd vssd sg13cmos5l_buf_1
Xhold909 _3572_/A _7181_/Q vddd vssd sg13cmos5l_dlygate4sd3_1
XFILLER_13_1471 vddd vssd sg13cmos5l_decap_8
XFILLER_10_481 vddd vssd sg13cmos5l_decap_4
XFILLER_26_2511 vddd vssd sg13cmos5l_decap_8
XFILLER_26_2588 vddd vssd sg13cmos5l_decap_8
X_5070_ _5088_/A _5099_/A _6194_/C vddd vssd sg13cmos5l_and2_1
X_4021_ _4021_/Y _3901_/A _6151_/A _3791_/A vddd vssd sg13cmos5l_a21oi_1
X_5972_ _5972_/X _6226_/A _5972_/B vddd vssd sg13cmos5l_or2_1
XFILLER_4_1683 vddd vssd sg13cmos5l_decap_8
X_4923_ _4923_/Y _4828_/A _4894_/B _4894_/A vddd vssd sg13cmos5l_o21ai_1
XFILLER_21_735 vddd vssd sg13cmos5l_decap_8
X_4854_ _4854_/Y hold609/X _4835_/B _4853_/Y vddd vssd sg13cmos5l_a21oi_1
X_4785_ _4785_/Y _4785_/A _4785_/B _4785_/C _4785_/D vddd vssd sg13cmos5l_nand4_1
X_3805_ _3805_/Y _3805_/A _3805_/B _3805_/C _3805_/D vddd vssd sg13cmos5l_nand4_1
XFILLER_20_278 vddd vssd sg13cmos5l_decap_8
X_6524_ _6524_/X _6501_/A _6524_/A1 _6524_/S vddd vssd sg13cmos5l_mux2_1
X_3736_ _3736_/Y _7089_/Q _6773_/A _6759_/B vddd vssd sg13cmos5l_nor3_1
X_3667_ _3667_/Y _5024_/A _3669_/S vddd vssd sg13cmos5l_nand2_1
X_6455_ _6455_/Y _6455_/A _6457_/B vddd vssd sg13cmos5l_nor2_1
X_6386_ _6386_/Y _6393_/A _6389_/S vddd vssd sg13cmos5l_nand2_1
X_3598_ _3598_/Y _3598_/A vddd vssd sg13cmos5l_inv_1
X_5406_ _5429_/A _7156_/Q _5416_/B _5428_/B vddd vssd sg13cmos5l_nor3_1
X_5337_ _5337_/Y _5337_/A _5337_/B vddd vssd sg13cmos5l_nor2_1
X_5268_ _6243_/C _5268_/A _6130_/B vddd vssd sg13cmos5l_nand2_1
X_7007_ _7007_/Q _7337_/CLK _7007_/D _6954_/Y vddd vssd sg13cmos5l_dfrbpq_1
XFILLER_5_2148 vddd vssd sg13cmos5l_decap_8
XFILLER_9_1572 vddd vssd sg13cmos5l_decap_8
X_4219_ _4219_/Y _4216_/Y _4217_/Y _4218_/Y vddd vssd sg13cmos5l_o21ai_1
XFILLER_5_1458 vddd vssd sg13cmos5l_decap_8
X_5199_ _6144_/B _7240_/Q _5199_/B _5208_/B vddd vssd sg13cmos5l_nor3_1
XFILLER_29_857 vddd vssd sg13cmos5l_decap_8
XFILLER_18_56 vddd vssd sg13cmos5l_decap_8
XFILLER_28_378 vddd vssd sg13cmos5l_decap_4
XFILLER_3_1171 vddd vssd sg13cmos5l_decap_8
XFILLER_24_595 vddd vssd sg13cmos5l_decap_8
XFILLER_11_201 vddd vssd sg13cmos5l_decap_4
XFILLER_7_205 vddd vssd sg13cmos5l_decap_8
Xwire114 _3887_/B _3958_/A vddd vssd sg13cmos5l_buf_4
Xwire136 wire136/X _5295_/Y vddd vssd sg13cmos5l_buf_2
XFILLER_14_2492 vddd vssd sg13cmos5l_decap_8
XFILLER_10_1611 vddd vssd sg13cmos5l_decap_8
XFILLER_4_934 vddd vssd sg13cmos5l_decap_4
XFILLER_4_989 vddd vssd sg13cmos5l_decap_8
Xfanout280 _6226_/B _7231_/Q vddd vssd sg13cmos5l_buf_1
Xfanout291 _5769_/B hold1417/X vddd vssd sg13cmos5l_buf_1
XFILLER_21_2463 vddd vssd sg13cmos5l_decap_8
XFILLER_21_1740 vddd vssd sg13cmos5l_decap_8
XFILLER_19_334 vddd vssd sg13cmos5l_decap_8
XFILLER_21_1795 vddd vssd sg13cmos5l_decap_8
XFILLER_19_2381 vddd vssd sg13cmos5l_decap_8
Xclkbuf_leaf_7_SCK_regs _7378_/CLK clkload3/A vddd vssd sg13cmos5l_buf_8
XFILLER_15_2267 vddd vssd sg13cmos5l_decap_4
X_4570_ _4570_/Y _4599_/A _4592_/B vddd vssd sg13cmos5l_nor2_1
XFILLER_15_1577 vddd vssd sg13cmos5l_decap_8
X_3521_ _3521_/Y _3521_/A vddd vssd sg13cmos5l_inv_1
XFILLER_32_1880 vddd vssd sg13cmos5l_decap_8
Xhold706 hold706/X _3484_/Y vddd vssd sg13cmos5l_dlygate4sd3_1
Xhold717 _7135_/D _6373_/Y vddd vssd sg13cmos5l_dlygate4sd3_1
Xhold728 hold728/X _6376_/Y vddd vssd sg13cmos5l_dlygate4sd3_1
X_6240_ _6240_/Y _3552_/Y _6213_/Y _6238_/Y _6239_/Y vddd vssd sg13cmos5l_a22oi_1
Xhold739 _4395_/A _4394_/Y vddd vssd sg13cmos5l_dlygate4sd3_1
X_6171_ _6171_/Y _6243_/A _6171_/B _6171_/C vddd vssd sg13cmos5l_nor3_1
XFILLER_28_1949 vddd vssd sg13cmos5l_decap_4
X_5122_ _6073_/A _5220_/A _5076_/A vddd vssd sg13cmos5l_nor2b_1
XFILLER_29_109 vddd vssd sg13cmos5l_decap_8
XFILLER_26_2385 vddd vssd sg13cmos5l_decap_8
XFILLER_26_1651 vddd vssd sg13cmos5l_decap_8
XFILLER_27_0 vddd vssd sg13cmos5l_decap_8
Xhold1406 _4825_/A2 _4824_/Y vddd vssd sg13cmos5l_dlygate4sd3_1
X_5053_ _5110_/C _7279_/Q _7278_/Q vddd vssd sg13cmos5l_nor2_1
XFILLER_22_2249 vddd vssd sg13cmos5l_decap_8
Xhold1417 hold1417/X _7207_/Q vddd vssd sg13cmos5l_dlygate4sd3_1
Xhold1439 _7330_/D _4749_/Y vddd vssd sg13cmos5l_dlygate4sd3_1
Xhold1428 hold1428/X _7170_/Q vddd vssd sg13cmos5l_dlygate4sd3_1
XFILLER_6_1745 vddd vssd sg13cmos5l_decap_8
X_4004_ _4007_/B _7020_/Q _6660_/A vddd vssd sg13cmos5l_nand2_1
XFILLER_4_2192 vddd vssd sg13cmos5l_decap_4
XFILLER_0_2034 vddd vssd sg13cmos5l_decap_8
XFILLER_1_92 vddd vssd sg13cmos5l_decap_8
XFILLER_20_1261 vddd vssd sg13cmos5l_decap_4
XFILLER_0_1344 vddd vssd sg13cmos5l_decap_8
XFILLER_25_359 vddd vssd sg13cmos5l_decap_8
X_5955_ _5955_/X _6973_/D _5955_/B vddd vssd sg13cmos5l_and2_1
X_5886_ _5886_/Y _5881_/Y _5882_/X _5885_/Y vddd vssd sg13cmos5l_o21ai_1
X_4906_ _4906_/Y _4920_/A sram_odata[7] _4918_/C vddd vssd sg13cmos5l_nand3_1
X_4837_ _4837_/X _4839_/A _4837_/B vddd vssd sg13cmos5l_xor2_1
X_4768_ _4768_/Y _4511_/A _4767_/Y _4769_/A1 vddd vssd sg13cmos5l_a21oi_1
X_3719_ _3719_/Y _3791_/A vddd vssd sg13cmos5l_inv_1
X_6507_ _7205_/D _6507_/A1 _6509_/S _6506_/Y vddd vssd sg13cmos5l_a21oi_1
X_4699_ _4699_/X _4699_/A _4699_/B vddd vssd sg13cmos5l_or2_1
XFILLER_20_35 vddd vssd sg13cmos5l_decap_8
X_6438_ _6438_/Y _6470_/A _6441_/B vddd vssd sg13cmos5l_nor2_1
XFILLER_11_1975 vddd vssd sg13cmos5l_decap_8
XFILLER_0_436 vddd vssd sg13cmos5l_decap_8
X_6369_ _6369_/Y _6404_/A _6370_/B _6369_/B1 vddd vssd sg13cmos5l_o21ai_1
XFILLER_29_44 vddd vssd sg13cmos5l_decap_8
XFILLER_5_1233 vddd vssd sg13cmos5l_decap_8
XFILLER_28_120 vddd vssd sg13cmos5l_decap_8
XFILLER_21_1058 vddd vssd sg13cmos5l_decap_8
XFILLER_28_197 vddd vssd sg13cmos5l_decap_8
XFILLER_16_2532 vddd vssd sg13cmos5l_decap_8
XFILLER_8_525 vddd vssd sg13cmos5l_decap_4
XFILLER_32_1143 vddd vssd sg13cmos5l_decap_8
XANTENNA_8 _3728_/Y vddd vssd sg13cmos5l_antennanp
Xtiedowns\[77\] _5024_/A vddd vssd sg13cmos5l_antennanp
XFILLER_4_742 vddd vssd sg13cmos5l_decap_8
XFILLER_10_2175 vddd vssd sg13cmos5l_decap_8
XFILLER_23_2558 vddd vssd sg13cmos5l_decap_8
XFILLER_20_7 vddd vssd sg13cmos5l_decap_8
XFILLER_0_970 vddd vssd sg13cmos5l_decap_8
XFILLER_1_2332 vddd vssd sg13cmos5l_decap_4
XFILLER_17_2329 vddd vssd sg13cmos5l_decap_8
XFILLER_17_1617 vddd vssd sg13cmos5l_decap_8
X_5740_ _5740_/Y _5679_/A _5738_/A _5738_/Y _5735_/Y _5739_/X vddd vssd sg13cmos5l_a221oi_1
XFILLER_15_392 vddd vssd sg13cmos5l_decap_8
XFILLER_30_2529 vddd vssd sg13cmos5l_decap_8
X_5671_ _5671_/Y _7194_/Q _5671_/B _5671_/C vddd vssd sg13cmos5l_nand3_1
X_4622_ _4623_/B _4734_/A _4641_/B vddd vssd sg13cmos5l_nand2_1
X_7341_ _7341_/Q _7341_/CLK _7341_/D _6854_/Y vddd vssd sg13cmos5l_dfrbpq_1
X_4553_ _4553_/Y _6189_/A _4553_/B vddd vssd sg13cmos5l_nor2_1
Xhold514 _4559_/A _6989_/Q vddd vssd sg13cmos5l_dlygate4sd3_1
X_7272_ _7272_/Q _7275_/CLK _7272_/D fanout388/X vddd vssd sg13cmos5l_dfrbpq_1
Xhold525 _6976_/D _3633_/Y vddd vssd sg13cmos5l_dlygate4sd3_1
Xhold503 _6986_/D _3475_/Y vddd vssd sg13cmos5l_dlygate4sd3_1
Xhold536 _4751_/A _7000_/Q vddd vssd sg13cmos5l_dlygate4sd3_1
X_4484_ _4490_/A _4484_/A _4484_/B _4484_/C vddd vssd sg13cmos5l_nor3_1
X_3504_ _3504_/Y _5329_/A vddd vssd sg13cmos5l_inv_1
Xhold547 _6996_/D _5023_/Y vddd vssd sg13cmos5l_dlygate4sd3_1
Xhold558 _5955_/B _6973_/Q vddd vssd sg13cmos5l_dlygate4sd3_1
X_6223_ _6229_/A _6234_/B _6223_/B vddd vssd sg13cmos5l_nor2_1
Xhold569 _3786_/A _7388_/Q vddd vssd sg13cmos5l_dlygate4sd3_1
XFILLER_8_2508 vddd vssd sg13cmos5l_decap_8
Xoutbuffers\[60\] voltgen_ena[0] _7044_/Q vddd vssd sg13cmos5l_buf_16
XFILLER_28_2469 vddd vssd sg13cmos5l_decap_8
X_6154_ _6154_/Y _6048_/A _5210_/Y _6156_/B vddd vssd sg13cmos5l_a21oi_1
Xhold1214 _7270_/D _6620_/X vddd vssd sg13cmos5l_dlygate4sd3_1
Xhold1203 _7019_/D _6663_/X vddd vssd sg13cmos5l_dlygate4sd3_1
XFILLER_22_2024 vddd vssd sg13cmos5l_decap_8
Xhold1225 _7263_/D _6608_/X vddd vssd sg13cmos5l_dlygate4sd3_1
X_6085_ _6085_/Y _4464_/A _6063_/B _4978_/Y vddd vssd sg13cmos5l_a21oi_1
XFILLER_6_2265 vddd vssd sg13cmos5l_decap_4
X_5105_ _5120_/A _7250_/Q _7251_/Q _5263_/B vddd vssd sg13cmos5l_nor3_1
X_5036_ _5058_/A _7268_/Q _7269_/Q _7271_/Q _7270_/Q vddd vssd sg13cmos5l_nor4_1
XFILLER_26_1492 vddd vssd sg13cmos5l_decap_8
Xhold1236 _6714_/A0 _7053_/Q vddd vssd sg13cmos5l_dlygate4sd3_1
Xhold1247 _3554_/A _7146_/Q vddd vssd sg13cmos5l_dlygate4sd3_1
Xhold1258 _7365_/D _4301_/Y vddd vssd sg13cmos5l_dlygate4sd3_1
Xhold1269 _7062_/D _6728_/X vddd vssd sg13cmos5l_dlygate4sd3_1
X_6987_ _6987_/Q _7341_/CLK _6987_/D _6934_/Y vddd vssd sg13cmos5l_dfrbpq_1
XFILLER_25_156 vddd vssd sg13cmos5l_decap_8
XFILLER_0_1163 vddd vssd sg13cmos5l_decap_8
X_5938_ _5942_/B _5939_/A _5939_/B vddd vssd sg13cmos5l_and2_1
XFILLER_15_35 vddd vssd sg13cmos5l_decap_8
XFILLER_22_896 vddd vssd sg13cmos5l_decap_8
X_5869_ _5869_/Y _7313_/Q _5887_/B vddd vssd sg13cmos5l_nor2b_1
XFILLER_31_23 vddd vssd sg13cmos5l_decap_8
XFILLER_11_2484 vddd vssd sg13cmos5l_decap_8
XFILLER_29_440 vddd vssd sg13cmos5l_decap_4
XFILLER_5_1030 vddd vssd sg13cmos5l_decap_4
XFILLER_2_1984 vddd vssd sg13cmos5l_decap_4
XFILLER_32_649 vddd vssd sg13cmos5l_decap_8
XFILLER_18_1959 vddd vssd sg13cmos5l_decap_8
XFILLER_9_801 vddd vssd sg13cmos5l_decap_8
XFILLER_16_2384 vddd vssd sg13cmos5l_decap_8
XFILLER_8_311 vddd vssd sg13cmos5l_decap_8
XFILLER_13_896 vddd vssd sg13cmos5l_decap_8
XFILLER_12_395 vddd vssd sg13cmos5l_decap_4
XFILLER_12_1525 vddd vssd sg13cmos5l_decap_8
XFILLER_23_2333 vddd vssd sg13cmos5l_decap_8
X_6910_ _6910_/Y _6910_/A _6910_/B_N vddd vssd sg13cmos5l_nor2b_1
X_6841_ _6841_/Y _6857_/A _6844_/B_N vddd vssd sg13cmos5l_nor2b_1
XFILLER_22_115 vddd vssd sg13cmos5l_decap_8
X_3984_ wire11/A _4155_/B _3984_/B _6378_/A _3984_/D vddd vssd sg13cmos5l_nand4_1
X_6772_ _6772_/Y hold736/X _6771_/B _6771_/Y vddd vssd sg13cmos5l_o21ai_1
Xoutbuffers\[4\] analog_bus_ena[2] _7032_/Q vddd vssd sg13cmos5l_buf_16
XFILLER_22_159 vddd vssd sg13cmos5l_decap_8
X_5723_ _5723_/Y _5899_/A _7201_/Q vddd vssd sg13cmos5l_nand2b_1
XFILLER_31_682 vddd vssd sg13cmos5l_decap_8
X_5654_ _5655_/B _5882_/A _5654_/B _5654_/C vddd vssd sg13cmos5l_nand3_1
XFILLER_30_192 vddd vssd sg13cmos5l_decap_8
X_4605_ _4605_/Y _4652_/A _4605_/B vddd vssd sg13cmos5l_nor2_1
XFILLER_11_1013 vddd vssd sg13cmos5l_decap_8
X_5585_ _5585_/Y _5753_/A _5585_/B _5597_/A vddd vssd sg13cmos5l_nor3_1
X_7324_ _7324_/Q _7395_/CLK _7324_/D _6837_/Y vddd vssd sg13cmos5l_dfrbpq_1
XFILLER_11_1035 vddd vssd sg13cmos5l_decap_8
X_4536_ _4537_/B _4534_/Y _4535_/Y _4525_/Y vddd vssd sg13cmos5l_o21ai_1
X_7255_ _7255_/Q _7255_/CLK _7255_/D fanout389/X vddd vssd sg13cmos5l_dfrbpq_1
X_4467_ _4670_/B _6063_/A _4687_/A vddd vssd sg13cmos5l_nand2_1
XFILLER_28_1543 vddd vssd sg13cmos5l_decap_8
X_7186_ _7186_/Q _7187_/CLK _7186_/D fanout369/X vddd vssd sg13cmos5l_dfrbpq_1
X_6206_ _6207_/B _6120_/A _6205_/Y _6206_/S vddd vssd sg13cmos5l_mux2_1
X_4398_ _4402_/B _4398_/A _4398_/B _4416_/A _4401_/C vddd vssd sg13cmos5l_and4_1
XFILLER_8_2349 vddd vssd sg13cmos5l_decap_4
XFILLER_24_1407 vddd vssd sg13cmos5l_decap_4
X_6137_ _6139_/B _5197_/Y _6135_/Y _6136_/Y vddd vssd sg13cmos5l_o21ai_1
Xhold1000 _6414_/B1 _6413_/Y vddd vssd sg13cmos5l_dlygate4sd3_1
XFILLER_6_2051 vddd vssd sg13cmos5l_decap_8
XFILLER_8_1637 vddd vssd sg13cmos5l_decap_4
XFILLER_24_1429 vddd vssd sg13cmos5l_decap_4
Xhold1033 _7283_/D _6641_/X vddd vssd sg13cmos5l_dlygate4sd3_1
Xhold1011 _6394_/A1 _5332_/B vddd vssd sg13cmos5l_dlygate4sd3_1
Xhold1022 _3584_/A _7212_/Q vddd vssd sg13cmos5l_dlygate4sd3_1
Xhold1066 _6656_/A1 _3536_/Y vddd vssd sg13cmos5l_dlygate4sd3_1
Xhold1044 _7028_/D _6677_/Y vddd vssd sg13cmos5l_dlygate4sd3_1
X_6068_ _6068_/X _6048_/A _5129_/B _6067_/Y vddd vssd sg13cmos5l_a21o_1
Xhold1055 _7243_/D _6575_/X vddd vssd sg13cmos5l_dlygate4sd3_1
XFILLER_27_944 vddd vssd sg13cmos5l_decap_8
XFILLER_27_922 vddd vssd sg13cmos5l_decap_4
Xhold1077 _5951_/B _5950_/Y vddd vssd sg13cmos5l_dlygate4sd3_1
Xhold1088 _4943_/A _4942_/Y vddd vssd sg13cmos5l_dlygate4sd3_1
X_5019_ _5269_/A _7238_/Q _7239_/Q vddd vssd sg13cmos5l_nand2b_1
Xhold1099 _6402_/A1 _7149_/Q vddd vssd sg13cmos5l_dlygate4sd3_1
XFILLER_26_56 vddd vssd sg13cmos5l_decap_8
XFILLER_22_693 vddd vssd sg13cmos5l_decap_8
XFILLER_13_2546 vddd vssd sg13cmos5l_decap_8
XFILLER_5_303 vddd vssd sg13cmos5l_decap_8
XFILLER_10_855 vddd vssd sg13cmos5l_decap_8
Xclkbuf_leaf_21_SCK_regs _7108_/CLK clkload8/A vddd vssd sg13cmos5l_buf_8
XFILLER_11_1580 vddd vssd sg13cmos5l_decap_8
XFILLER_3_16 vddd vssd sg13cmos5l_decap_8
XFILLER_27_1053 vddd vssd sg13cmos5l_decap_8
XFILLER_7_1158 vddd vssd sg13cmos5l_decap_8
XFILLER_20_2528 vddd vssd sg13cmos5l_decap_8
XFILLER_32_413 vddd vssd sg13cmos5l_decap_8
XFILLER_18_999 vddd vssd sg13cmos5l_decap_8
XFILLER_2_1781 vddd vssd sg13cmos5l_decap_8
XFILLER_18_2446 vddd vssd sg13cmos5l_decap_8
XFILLER_18_1712 vddd vssd sg13cmos5l_decap_8
XFILLER_32_479 vddd vssd sg13cmos5l_decap_8
XFILLER_9_697 vddd vssd sg13cmos5l_decap_8
XFILLER_12_1355 vddd vssd sg13cmos5l_decap_8
XFILLER_12_2078 vddd vssd sg13cmos5l_decap_8
XFILLER_29_2520 vddd vssd sg13cmos5l_decap_8
X_5370_ _5370_/Y _5674_/A _5369_/C _5369_/Y vddd vssd sg13cmos5l_o21ai_1
X_4321_ _4321_/Y _5996_/B _4320_/Y _4344_/B vddd vssd sg13cmos5l_o21ai_1
XFILLER_29_2597 vddd vssd sg13cmos5l_decap_8
XFILLER_25_2417 vddd vssd sg13cmos5l_decap_8
X_7040_ _7040_/Q _7060_/CLK _7040_/D _6820_/B_N vddd vssd sg13cmos5l_dfrbpq_1
Xfanout109 _3911_/B _3717_/Y vddd vssd sg13cmos5l_buf_1
X_4252_ _4252_/Y _4252_/A _4252_/B _4252_/C vddd vssd sg13cmos5l_nor3_1
XFILLER_29_1885 vddd vssd sg13cmos5l_decap_8
X_4183_ _4183_/Y _4183_/A vddd vssd sg13cmos5l_inv_1
XFILLER_23_2141 vddd vssd sg13cmos5l_decap_8
XFILLER_7_2382 vddd vssd sg13cmos5l_decap_8
XFILLER_3_2246 vddd vssd sg13cmos5l_decap_8
XFILLER_7_1681 vddd vssd sg13cmos5l_decap_8
Xoutbuffers\[23\] voltgen_source[4] _7071_/Q vddd vssd sg13cmos5l_buf_16
XFILLER_23_1495 vddd vssd sg13cmos5l_decap_8
XFILLER_24_947 vddd vssd sg13cmos5l_decap_8
X_6824_ _6824_/Y _6827_/A _6827_/B_N vddd vssd sg13cmos5l_nor2b_1
X_3967_ _6383_/A _3967_/A _3967_/B vddd vssd sg13cmos5l_nand2_1
X_6755_ _6758_/S _6755_/A _6759_/C vddd vssd sg13cmos5l_nor2_1
XFILLER_10_107 vddd vssd sg13cmos5l_decap_8
X_5706_ _5706_/X _5882_/A _5706_/B vddd vssd sg13cmos5l_and2_1
X_6686_ _6686_/Y _6686_/A _6690_/S vddd vssd sg13cmos5l_nand2_1
X_3898_ _3898_/Y _3898_/A _3898_/B _3898_/C _3898_/D vddd vssd sg13cmos5l_nand4_1
XFILLER_12_14 vddd vssd sg13cmos5l_decap_8
X_5637_ _5642_/B _5637_/A _5654_/B _5651_/A vddd vssd sg13cmos5l_nor3_1
XFILLER_30_1477 vddd vssd sg13cmos5l_decap_4
X_5568_ _5568_/Y _5568_/A _5568_/B vddd vssd sg13cmos5l_nor2_1
XFILLER_28_2030 vddd vssd sg13cmos5l_decap_4
X_4519_ _4519_/X _4388_/A _4811_/B _4518_/Y vddd vssd sg13cmos5l_a21o_1
X_7307_ _7307_/Q _7307_/CLK _7307_/D _6820_/Y vddd vssd sg13cmos5l_dfrbpq_1
X_7238_ _7238_/Q _7287_/CLK _7238_/D fanout386/X vddd vssd sg13cmos5l_dfrbpq_1
X_5499_ _5505_/A _5497_/Y _5498_/Y _5511_/C vddd vssd sg13cmos5l_o21ai_1
XFILLER_8_2124 vddd vssd sg13cmos5l_decap_8
XFILLER_24_1204 vddd vssd sg13cmos5l_decap_8
X_7169_ _7169_/Q _7171_/CLK _7169_/D fanout365/X vddd vssd sg13cmos5l_dfrbpq_1
XFILLER_19_719 vddd vssd sg13cmos5l_decap_8
XFILLER_6_1180 vddd vssd sg13cmos5l_decap_8
XFILLER_2_1099 vddd vssd sg13cmos5l_decap_8
XFILLER_30_928 vddd vssd sg13cmos5l_decap_8
XFILLER_17_2490 vddd vssd sg13cmos5l_decap_8
XFILLER_13_1631 vddd vssd sg13cmos5l_decap_8
XFILLER_5_100 vddd vssd sg13cmos5l_decap_8
XFILLER_6_645 vddd vssd sg13cmos5l_decap_8
XFILLER_2_884 vddd vssd sg13cmos5l_decap_8
XFILLER_24_2450 vddd vssd sg13cmos5l_decap_8
XFILLER_20_1679 vddd vssd sg13cmos5l_decap_4
XFILLER_32_210 vddd vssd sg13cmos5l_decap_8
X_4870_ _4871_/C _4949_/A _7136_/Q vddd vssd sg13cmos5l_xnor2_1
Xoutbuffers\[113\] dbus_out[16] _5772_/Y vddd vssd sg13cmos5l_buf_16
X_3821_ _3822_/C _7071_/Q _3817_/Y _3820_/X _3791_/A _6725_/A vddd vssd sg13cmos5l_a221oi_1
XFILLER_21_928 vddd vssd sg13cmos5l_decap_8
XFILLER_21_906 vddd vssd sg13cmos5l_decap_4
XFILLER_18_2254 vddd vssd sg13cmos5l_decap_8
XFILLER_32_287 vddd vssd sg13cmos5l_decap_8
X_6540_ _6546_/B _6540_/A _6667_/B vddd vssd sg13cmos5l_nand2_1
XFILLER_31_2454 vddd vssd sg13cmos5l_decap_8
X_3752_ _3753_/B _3752_/A _3752_/B vddd vssd sg13cmos5l_nand2_1
X_6471_ _7185_/D _6471_/A1 _6473_/S _6470_/Y vddd vssd sg13cmos5l_a21oi_1
X_3683_ _3931_/A _3749_/B _3929_/B vddd vssd sg13cmos5l_nor2_1
X_5422_ _5422_/Y _7156_/Q _7157_/Q _5422_/C vddd vssd sg13cmos5l_nor3_1
X_5353_ _5374_/B _5355_/A _7149_/Q vddd vssd sg13cmos5l_nor2_1
X_4304_ _4304_/Y _4970_/A _4970_/B _4304_/C vddd vssd sg13cmos5l_nand3_1
XFILLER_29_2394 vddd vssd sg13cmos5l_decap_8
XFILLER_4_70 vddd vssd sg13cmos5l_decap_8
X_5284_ _7395_/D _5284_/A vddd vssd sg13cmos5l_inv_1
X_7023_ _7023_/Q _7191_/CLK _7023_/D fanout375/X vddd vssd sg13cmos5l_dfrbpq_1
X_4235_ _4235_/Y _7052_/Q _6711_/A _6378_/A vddd vssd sg13cmos5l_o21ai_1
XFILLER_3_2032 vddd vssd sg13cmos5l_decap_4
XFILLER_5_1618 vddd vssd sg13cmos5l_decap_8
X_4166_ _4166_/Y _3459_/Y _3730_/Y _3739_/Y mask_rev_in[1] _4252_/A vddd vssd sg13cmos5l_a221oi_1
XFILLER_25_1579 vddd vssd sg13cmos5l_decap_8
X_4097_ _4097_/Y _5085_/B _3875_/Y _3879_/Y vddd vssd sg13cmos5l_a21oi_1
XFILLER_3_2087 vddd vssd sg13cmos5l_decap_8
XFILLER_24_711 vddd vssd sg13cmos5l_decap_8
XFILLER_23_221 vddd vssd sg13cmos5l_decap_8
X_6807_ _6807_/Y CSB _6908_/B_N vddd vssd sg13cmos5l_nor2b_1
XFILLER_32_2229 vddd vssd sg13cmos5l_decap_8
X_4999_ _5237_/A _7266_/Q _7267_/Q vddd vssd sg13cmos5l_nor2b_1
XFILLER_23_35 vddd vssd sg13cmos5l_decap_8
XFILLER_17_1041 vddd vssd sg13cmos5l_decap_8
XFILLER_12_939 vddd vssd sg13cmos5l_decap_8
X_6738_ _6738_/X _6738_/A0 _5027_/A _6739_/S vddd vssd sg13cmos5l_mux2_1
X_6669_ _7023_/D _6675_/A1 _6681_/S hold918/X vddd vssd sg13cmos5l_a21oi_1
XFILLER_20_972 vddd vssd sg13cmos5l_decap_8
XFILLER_10_2538 vddd vssd sg13cmos5l_decap_8
XFILLER_10_1815 vddd vssd sg13cmos5l_decap_8
XFILLER_3_604 vddd vssd sg13cmos5l_decap_4
XFILLER_2_114 vddd vssd sg13cmos5l_decap_8
Xfanout440 _5398_/A io_in[2] vddd vssd sg13cmos5l_buf_1
XFILLER_8_1220 vddd vssd sg13cmos5l_decap_8
XFILLER_24_1023 vddd vssd sg13cmos5l_decap_4
Xfanout451 _5973_/A _6227_/A1 vddd vssd sg13cmos5l_buf_1
Xfanout462 _6909_/A _6806_/A vddd vssd sg13cmos5l_buf_1
XFILLER_24_1056 vddd vssd sg13cmos5l_decap_8
XFILLER_21_1933 vddd vssd sg13cmos5l_decap_8
XFILLER_0_28 vddd vssd sg13cmos5l_decap_8
XFILLER_19_2541 vddd vssd sg13cmos5l_decap_8
XFILLER_15_777 vddd vssd sg13cmos5l_decap_8
XFILLER_19_1862 vddd vssd sg13cmos5l_decap_8
Xfanout80 _4231_/C1 _6699_/A vddd vssd sg13cmos5l_buf_1
Xfanout91 _3791_/A _3718_/Y vddd vssd sg13cmos5l_buf_1
XFILLER_6_442 vddd vssd sg13cmos5l_decap_4
XFILLER_7_998 vddd vssd sg13cmos5l_decap_8
XFILLER_26_2567 vddd vssd sg13cmos5l_decap_8
XFILLER_2_670 vddd vssd sg13cmos5l_decap_8
XFILLER_9_1039 vddd vssd sg13cmos5l_decap_8
X_4020_ _4020_/X dbus_in_left[10] dbus_in_right[10] vddd vssd sg13cmos5l_or2_1
XFILLER_20_2166 vddd vssd sg13cmos5l_decap_8
XFILLER_4_1651 vddd vssd sg13cmos5l_decap_8
X_5971_ _5975_/B _5983_/C _5976_/C vddd vssd sg13cmos5l_nor2_1
XFILLER_0_1548 vddd vssd sg13cmos5l_decap_8
X_4922_ _4922_/Y _4922_/A1 _4903_/C wire26/A vddd vssd sg13cmos5l_o21ai_1
XFILLER_18_2084 vddd vssd sg13cmos5l_decap_4
X_4853_ _4853_/Y sram_odata[2] _4856_/A2 _4852_/Y _4841_/B _4835_/B vddd vssd sg13cmos5l_a221oi_1
X_4784_ _4785_/D _4459_/Y _4779_/Y _4798_/B _4805_/B1 vddd vssd sg13cmos5l_a22oi_1
X_3804_ _3805_/D mask_rev_in[5] _4250_/A _4252_/A vddd vssd sg13cmos5l_a21oi_1
XFILLER_18_1394 vddd vssd sg13cmos5l_decap_8
X_3735_ _3735_/Y _3735_/A _3734_/Y vddd vssd sg13cmos5l_nor2b_1
X_6523_ _6523_/Y _6523_/A1 _6524_/S _6522_/Y vddd vssd sg13cmos5l_a21oi_1
X_6454_ _7177_/D _6454_/A1 _6457_/B _6453_/Y vddd vssd sg13cmos5l_a21oi_1
Xoutbuffers\[90\] io_out[5] _6126_/X vddd vssd sg13cmos5l_buf_16
XFILLER_31_1594 vddd vssd sg13cmos5l_decap_4
X_5405_ _5428_/B _5405_/A vddd vssd sg13cmos5l_inv_1
X_3666_ _3750_/C _4343_/A _4315_/C _3669_/S vddd vssd sg13cmos5l_mux2_1
X_6385_ _7140_/D _6482_/A1 _6389_/S _6385_/B1 vddd vssd sg13cmos5l_a21oi_1
X_3597_ _3597_/Y _7098_/Q vddd vssd sg13cmos5l_inv_1
X_5336_ _5337_/B _5330_/Y _5333_/Y _5335_/Y vddd vssd sg13cmos5l_a21oi_1
X_5267_ _5280_/A _6243_/B vddd vssd sg13cmos5l_inv_1
XFILLER_5_2127 vddd vssd sg13cmos5l_decap_8
XFILLER_9_1551 vddd vssd sg13cmos5l_decap_8
X_7006_ _7006_/Q _7340_/CLK _7006_/D _6953_/Y vddd vssd sg13cmos5l_dfrbpq_1
XFILLER_25_2088 vddd vssd sg13cmos5l_decap_4
X_4218_ _4218_/Y _7168_/Q _6435_/A _6429_/A vddd vssd sg13cmos5l_a21oi_1
XFILLER_29_836 vddd vssd sg13cmos5l_decap_8
X_5198_ _5207_/B _6130_/B _6130_/C _5197_/Y vddd vssd sg13cmos5l_a21oi_1
XFILLER_18_35 vddd vssd sg13cmos5l_decap_8
XFILLER_5_1437 vddd vssd sg13cmos5l_decap_8
X_4149_ _4149_/Y _7045_/Q _3766_/Y _6691_/A vddd vssd sg13cmos5l_o21ai_1
XFILLER_3_1150 vddd vssd sg13cmos5l_decap_8
XFILLER_32_2037 vddd vssd sg13cmos5l_decap_4
XFILLER_8_707 vddd vssd sg13cmos5l_decap_8
XFILLER_14_2471 vddd vssd sg13cmos5l_decap_8
Xclkload0 clkload0/Y clkload0/A vddd vssd sg13cmos5l_inv_4
XFILLER_4_902 vddd vssd sg13cmos5l_decap_8
XFILLER_10_1667 vddd vssd sg13cmos5l_decap_4
Xtiedowns\[22\] dbus_in_left[2] vddd vssd sg13cmos5l_antennanp
Xfanout281 _6233_/B _7228_/Q vddd vssd sg13cmos5l_buf_1
XFILLER_21_2442 vddd vssd sg13cmos5l_decap_8
Xfanout292 _5769_/A _7206_/Q vddd vssd sg13cmos5l_buf_1
Xfanout270 _6063_/B _6258_/C1 vddd vssd sg13cmos5l_buf_1
XFILLER_19_1681 vddd vssd sg13cmos5l_decap_8
XFILLER_15_1545 vddd vssd sg13cmos5l_decap_8
X_3520_ _3520_/Y _7119_/Q vddd vssd sg13cmos5l_inv_1
XFILLER_11_791 vddd vssd sg13cmos5l_decap_8
Xhold707 _7360_/D _4326_/Y vddd vssd sg13cmos5l_dlygate4sd3_1
Xhold718 _6776_/A _7091_/Q vddd vssd sg13cmos5l_dlygate4sd3_1
Xhold729 _7137_/D _6377_/Y vddd vssd sg13cmos5l_dlygate4sd3_1
XFILLER_28_1917 vddd vssd sg13cmos5l_decap_8
X_6170_ _6188_/A _4373_/A _6189_/B _6169_/Y vddd vssd sg13cmos5l_a21oi_1
X_5121_ _5121_/Y _5121_/A _5121_/B vddd vssd sg13cmos5l_nand2_1
XFILLER_26_2364 vddd vssd sg13cmos5l_decap_8
XFILLER_26_1630 vddd vssd sg13cmos5l_decap_8
XFILLER_22_2228 vddd vssd sg13cmos5l_decap_4
Xhold1407 _7326_/D _4825_/Y vddd vssd sg13cmos5l_dlygate4sd3_1
XFILLER_6_2436 vddd vssd sg13cmos5l_decap_4
Xhold1429 _6440_/A1 _5511_/A vddd vssd sg13cmos5l_dlygate4sd3_1
Xhold1418 _6509_/A1 _5769_/B vddd vssd sg13cmos5l_dlygate4sd3_1
X_5052_ _6012_/B _5227_/B _5136_/B vddd vssd sg13cmos5l_nand2_1
XFILLER_6_1757 vddd vssd sg13cmos5l_decap_8
X_4003_ _4007_/A _7026_/Q _4176_/A2 _6673_/A _7029_/Q vddd vssd sg13cmos5l_a22oi_1
XFILLER_0_2013 vddd vssd sg13cmos5l_decap_8
XFILLER_4_2160 vddd vssd sg13cmos5l_decap_4
XFILLER_4_1470 vddd vssd sg13cmos5l_decap_4
XFILLER_25_327 vddd vssd sg13cmos5l_decap_8
XFILLER_20_1284 vddd vssd sg13cmos5l_decap_8
X_5954_ _6972_/D _5954_/A _5954_/B vddd vssd sg13cmos5l_nor2_1
XFILLER_0_1378 vddd vssd sg13cmos5l_decap_4
XFILLER_21_500 vddd vssd sg13cmos5l_decap_8
X_5885_ _5885_/Y _6233_/A _5883_/Y _5884_/Y vddd vssd sg13cmos5l_a21oi_1
X_4905_ _4905_/Y _5285_/A _3539_/Y _5285_/D vddd vssd sg13cmos5l_o21ai_1
X_4836_ _4836_/Y _4835_/B _4834_/Y hold624/X vddd vssd sg13cmos5l_o21ai_1
Xtiedowns\[6\] sram_odata[6] vddd vssd sg13cmos5l_antennanp
XFILLER_21_577 vddd vssd sg13cmos5l_decap_8
X_4767_ _4767_/Y _4767_/A1 _4762_/Y _4766_/Y vddd vssd sg13cmos5l_o21ai_1
X_6506_ _6506_/Y _6520_/A _6509_/S vddd vssd sg13cmos5l_nor2_1
XFILLER_20_14 vddd vssd sg13cmos5l_decap_8
X_3718_ _3718_/Y _6615_/B _3922_/A vddd vssd sg13cmos5l_nor2_1
X_4698_ _4699_/B _4628_/A _4684_/X _4511_/Y vddd vssd sg13cmos5l_o21ai_1
X_3649_ _3649_/Y _5936_/A _6966_/Q vddd vssd sg13cmos5l_nor2_1
X_6437_ _7168_/D _6482_/A1 _6441_/B hold827/X vddd vssd sg13cmos5l_o21ai_1
X_6368_ _6368_/Y _6368_/A _6370_/B vddd vssd sg13cmos5l_nand2_1
X_5319_ _5319_/Y _5314_/Y _5315_/X _5318_/Y vddd vssd sg13cmos5l_o21ai_1
XFILLER_0_415 vddd vssd sg13cmos5l_decap_8
X_6299_ _6299_/Y _6287_/A _3628_/Y _6297_/A vddd vssd sg13cmos5l_a21oi_1
XFILLER_29_23 vddd vssd sg13cmos5l_decap_8
XFILLER_21_1037 vddd vssd sg13cmos5l_decap_8
XFILLER_17_806 vddd vssd sg13cmos5l_decap_8
XFILLER_28_176 vddd vssd sg13cmos5l_decap_8
XFILLER_0_2591 vddd vssd sg13cmos5l_decap_8
XFILLER_16_2511 vddd vssd sg13cmos5l_decap_8
XFILLER_8_504 vddd vssd sg13cmos5l_decap_8
XFILLER_32_1122 vddd vssd sg13cmos5l_decap_8
XFILLER_16_2588 vddd vssd sg13cmos5l_decap_8
XANTENNA_9 _3728_/Y vddd vssd sg13cmos5l_antennanp
XFILLER_6_49 vddd vssd sg13cmos5l_decap_8
XFILLER_3_231 vddd vssd sg13cmos5l_decap_4
XFILLER_27_1983 vddd vssd sg13cmos5l_decap_8
XFILLER_23_2537 vddd vssd sg13cmos5l_decap_8
XFILLER_21_2250 vddd vssd sg13cmos5l_decap_4
XFILLER_13_7 vddd vssd sg13cmos5l_decap_8
XFILLER_17_2308 vddd vssd sg13cmos5l_decap_8
X_5670_ _5671_/C _5727_/A _7195_/Q _5679_/B vddd vssd sg13cmos5l_o21ai_1
XFILLER_17_1629 vddd vssd sg13cmos5l_decap_8
XFILLER_30_2508 vddd vssd sg13cmos5l_decap_8
XFILLER_15_2054 vddd vssd sg13cmos5l_decap_4
X_4621_ _4641_/B _4469_/B _4621_/B vddd vssd sg13cmos5l_nand2b_1
X_7340_ _7340_/Q _7340_/CLK _7340_/D _6853_/Y vddd vssd sg13cmos5l_dfrbpq_1
XFILLER_15_1386 vddd vssd sg13cmos5l_decap_4
X_4552_ _4552_/Y _4552_/A _4552_/B vddd vssd sg13cmos5l_nor2_1
Xhold515 _6990_/D _3472_/Y vddd vssd sg13cmos5l_dlygate4sd3_1
Xhold526 _3467_/A _6996_/Q vddd vssd sg13cmos5l_dlygate4sd3_1
X_7271_ _7271_/Q _7275_/CLK _7271_/D fanout392/X vddd vssd sg13cmos5l_dfrbpq_1
Xhold504 _7004_/D hold504/A vddd vssd sg13cmos5l_dlygate4sd3_1
X_4483_ _4484_/C _4609_/A _4512_/B vddd vssd sg13cmos5l_nand2_1
X_3503_ _4464_/A _4740_/A vddd vssd sg13cmos5l_inv_1
Xhold548 _5023_/A _7014_/Q vddd vssd sg13cmos5l_dlygate4sd3_1
XFILLER_28_2448 vddd vssd sg13cmos5l_decap_8
Xhold537 _7001_/D _3466_/Y vddd vssd sg13cmos5l_dlygate4sd3_1
Xhold559 _6974_/D _5955_/X vddd vssd sg13cmos5l_dlygate4sd3_1
X_6222_ _6223_/B _3546_/Y _3624_/Y _6220_/Y _7230_/Q _6221_/Y vddd vssd sg13cmos5l_a221oi_1
X_6153_ _6153_/Y _6194_/A _6152_/A _6152_/Y vddd vssd sg13cmos5l_o21ai_1
Xoutbuffers\[53\] bandgap_trim[14] _6301_/Y vddd vssd sg13cmos5l_buf_16
XFILLER_26_1460 vddd vssd sg13cmos5l_decap_8
Xhold1204 _6607_/A0 _7262_/Q vddd vssd sg13cmos5l_dlygate4sd3_1
X_6084_ _6084_/Y _4978_/Y _6064_/Y _6083_/Y vddd vssd sg13cmos5l_o21ai_1
Xhold1215 _4287_/B _7369_/Q vddd vssd sg13cmos5l_dlygate4sd3_1
X_5104_ _5263_/B _7248_/Q _7249_/Q vddd vssd sg13cmos5l_nand2b_1
Xhold1237 _7053_/D _6714_/X vddd vssd sg13cmos5l_dlygate4sd3_1
X_5035_ _6043_/B _7283_/Q _7282_/Q vddd vssd sg13cmos5l_nor2_1
Xhold1248 _6396_/A1 _5338_/C vddd vssd sg13cmos5l_dlygate4sd3_1
Xhold1226 hold1226/X _7399_/Q vddd vssd sg13cmos5l_dlygate4sd3_1
XFILLER_26_603 vddd vssd sg13cmos5l_decap_8
XFILLER_22_1346 vddd vssd sg13cmos5l_decap_8
Xhold1259 _6651_/A0 _7291_/Q vddd vssd sg13cmos5l_dlygate4sd3_1
XFILLER_6_1587 vddd vssd sg13cmos5l_decap_8
X_6986_ _6986_/Q _7337_/CLK _6986_/D _6933_/Y vddd vssd sg13cmos5l_dfrbpq_1
XFILLER_25_135 vddd vssd sg13cmos5l_decap_8
XFILLER_15_14 vddd vssd sg13cmos5l_decap_8
X_5937_ _5937_/Y _5937_/A _5954_/A _5939_/B vddd vssd sg13cmos5l_nor3_1
XFILLER_0_1175 vddd vssd sg13cmos5l_decap_8
X_5868_ _5883_/C _7220_/Q _7221_/Q vddd vssd sg13cmos5l_nand2_1
X_4819_ _4819_/Y _4819_/A _4819_/B vddd vssd sg13cmos5l_nand2_1
X_5799_ _5800_/C _5828_/A _5799_/B _5799_/C vddd vssd sg13cmos5l_nor3_1
XFILLER_11_2463 vddd vssd sg13cmos5l_decap_8
XFILLER_31_79 vddd vssd sg13cmos5l_decap_8
XFILLER_22_2581 vddd vssd sg13cmos5l_decap_8
XFILLER_5_1075 vddd vssd sg13cmos5l_decap_8
XFILLER_29_474 vddd vssd sg13cmos5l_decap_8
XFILLER_22_1880 vddd vssd sg13cmos5l_decap_8
XFILLER_2_1941 vddd vssd sg13cmos5l_decap_8
XFILLER_17_658 vddd vssd sg13cmos5l_decap_8
XFILLER_32_628 vddd vssd sg13cmos5l_decap_8
XFILLER_31_149 vddd vssd sg13cmos5l_decap_8
XFILLER_18_1927 vddd vssd sg13cmos5l_decap_8
XFILLER_16_2374 vddd vssd sg13cmos5l_decap_4
XFILLER_16_1651 vddd vssd sg13cmos5l_decap_8
XFILLER_10_1250 vddd vssd sg13cmos5l_decap_8
XFILLER_10_1294 vddd vssd sg13cmos5l_decap_8
XFILLER_27_2481 vddd vssd sg13cmos5l_decap_8
XFILLER_23_2312 vddd vssd sg13cmos5l_decap_8
XFILLER_7_2575 vddd vssd sg13cmos5l_decap_8
XFILLER_7_1852 vddd vssd sg13cmos5l_decap_4
XFILLER_23_1688 vddd vssd sg13cmos5l_decap_4
Xclkbuf_3_6_0_clk_regs clkbuf_3_6_0_clk_regs/X clkbuf_0_clk_regs/X vddd vssd sg13cmos5l_buf_8
X_6840_ _6840_/Y _6956_/A _6959_/B_N vddd vssd sg13cmos5l_nor2b_1
XFILLER_23_639 vddd vssd sg13cmos5l_decap_8
X_6771_ _6771_/Y _6784_/A _6771_/B vddd vssd sg13cmos5l_nand2_1
X_3983_ _3984_/D _7055_/Q _3983_/B vddd vssd sg13cmos5l_nand2b_1
XFILLER_17_2138 vddd vssd sg13cmos5l_decap_8
X_5722_ _5722_/Y _4473_/A _3581_/Y _5721_/X vddd vssd sg13cmos5l_o21ai_1
XFILLER_31_650 vddd vssd sg13cmos5l_decap_8
XFILLER_30_171 vddd vssd sg13cmos5l_decap_8
X_5653_ _5655_/A _7190_/Q _5653_/B _5653_/C _5653_/D vddd vssd sg13cmos5l_nand4_1
XFILLER_30_1626 vddd vssd sg13cmos5l_decap_8
X_4604_ _4605_/B _4789_/A _4604_/B vddd vssd sg13cmos5l_nor2_1
X_5584_ _5584_/Y _5597_/C _5583_/Y _5597_/A vddd vssd sg13cmos5l_o21ai_1
X_4535_ _4535_/Y _4524_/Y _4532_/Y _4511_/Y vddd vssd sg13cmos5l_o21ai_1
XFILLER_7_70 vddd vssd sg13cmos5l_decap_8
X_7323_ _7323_/Q _7396_/CLK _7323_/D _6836_/Y vddd vssd sg13cmos5l_dfrbpq_1
XFILLER_8_890 vddd vssd sg13cmos5l_decap_8
Xclkbuf_0_SCK_regs clkbuf_0_SCK_regs/X clkbuf_regs_1_SCK/X vddd vssd sg13cmos5l_buf_8
X_4466_ _4687_/A _6041_/A _4714_/B vddd vssd sg13cmos5l_and2_1
XFILLER_8_2306 vddd vssd sg13cmos5l_decap_8
X_7254_ _7254_/Q _7259_/CLK _7254_/D fanout390/X vddd vssd sg13cmos5l_dfrbpq_1
X_7185_ _7185_/Q _7188_/CLK _7185_/D fanout369/X vddd vssd sg13cmos5l_dfrbpq_1
X_6205_ _6205_/Y _6012_/A _6204_/A _6204_/Y vddd vssd sg13cmos5l_o21ai_1
X_4397_ _4401_/C _4397_/A _4421_/A vddd vssd sg13cmos5l_and2_1
XFILLER_28_1588 vddd vssd sg13cmos5l_decap_8
X_6136_ _6136_/Y _3768_/X _5197_/Y _6138_/B vddd vssd sg13cmos5l_a21oi_1
Xhold1012 _6645_/A0 _7285_/Q vddd vssd sg13cmos5l_dlygate4sd3_1
Xhold1023 _6519_/A1 _5812_/A vddd vssd sg13cmos5l_dlygate4sd3_1
Xhold1001 hold1001/X _7363_/Q vddd vssd sg13cmos5l_dlygate4sd3_1
Xhold1034 _6634_/A0 _7278_/Q vddd vssd sg13cmos5l_dlygate4sd3_1
XFILLER_22_1143 vddd vssd sg13cmos5l_decap_4
X_6067_ _6067_/Y _4107_/Y _5129_/A _6065_/X _6066_/Y _5129_/B vddd vssd sg13cmos5l_a221oi_1
Xhold1067 _7293_/D _6656_/Y vddd vssd sg13cmos5l_dlygate4sd3_1
Xhold1056 _4397_/A _7344_/Q vddd vssd sg13cmos5l_dlygate4sd3_1
XFILLER_6_1362 vddd vssd sg13cmos5l_decap_8
Xhold1045 _6646_/A0 _7286_/Q vddd vssd sg13cmos5l_dlygate4sd3_1
Xhold1078 _6712_/A _7052_/Q vddd vssd sg13cmos5l_dlygate4sd3_1
Xhold1089 _4403_/B _7349_/Q vddd vssd sg13cmos5l_dlygate4sd3_1
XFILLER_6_1395 vddd vssd sg13cmos5l_decap_8
X_5018_ _5214_/A _7236_/Q _5163_/B vddd vssd sg13cmos5l_nand2_1
XFILLER_26_35 vddd vssd sg13cmos5l_decap_8
X_6969_ _6969_/Q _7001_/CLK _6969_/D _6916_/Y vddd vssd sg13cmos5l_dfrbpq_1
XFILLER_22_650 vddd vssd sg13cmos5l_decap_8
XFILLER_22_672 vddd vssd sg13cmos5l_decap_8
XFILLER_13_2525 vddd vssd sg13cmos5l_decap_8
XFILLER_5_359 vddd vssd sg13cmos5l_decap_8
Xhold890 hold890/X _7125_/Q vddd vssd sg13cmos5l_dlygate4sd3_1
XFILLER_20_2507 vddd vssd sg13cmos5l_decap_8
XFILLER_29_260 vddd vssd sg13cmos5l_decap_8
XFILLER_2_2461 vddd vssd sg13cmos5l_decap_4
XFILLER_18_978 vddd vssd sg13cmos5l_decap_8
XFILLER_18_1757 vddd vssd sg13cmos5l_decap_4
XFILLER_9_632 vddd vssd sg13cmos5l_decap_8
XFILLER_12_2035 vddd vssd sg13cmos5l_decap_8
XFILLER_12_2057 vddd vssd sg13cmos5l_decap_8
X_4320_ _4320_/Y _4327_/A _4330_/A _4320_/C vddd vssd sg13cmos5l_nand3_1
XFILLER_29_2576 vddd vssd sg13cmos5l_decap_8
X_4251_ _4252_/C mask_rev_in[0] _4251_/B _6609_/B vddd vssd sg13cmos5l_nor3_1
XFILLER_10_1080 vddd vssd sg13cmos5l_decap_8
X_4182_ _4183_/A _7268_/Q _3862_/Y _3868_/Y _7272_/Q _4175_/B vddd vssd sg13cmos5l_a221oi_1
XFILLER_3_2225 vddd vssd sg13cmos5l_decap_8
XFILLER_3_1535 vddd vssd sg13cmos5l_decap_8
XFILLER_3_1579 vddd vssd sg13cmos5l_decap_4
Xoutbuffers\[16\] proj_sel[3] _7021_/Q vddd vssd sg13cmos5l_buf_16
X_6823_ _6823_/Y _6827_/A _6827_/B_N vddd vssd sg13cmos5l_nor2b_1
X_3966_ _3966_/Y _4071_/C _3966_/B vddd vssd sg13cmos5l_nor2_1
X_6754_ _7079_/D _6790_/A _6753_/B _6753_/Y vddd vssd sg13cmos5l_o21ai_1
X_6685_ _7034_/D _6693_/A1 _6690_/S _6685_/B1 vddd vssd sg13cmos5l_a21oi_1
X_5705_ _5705_/Y _3548_/A _5703_/B _5703_/Y _5697_/Y _5706_/B vddd vssd sg13cmos5l_a221oi_1
XFILLER_17_1256 vddd vssd sg13cmos5l_decap_8
XFILLER_17_1245 vddd vssd sg13cmos5l_decap_4
XFILLER_30_2124 vddd vssd sg13cmos5l_decap_8
X_5636_ _5642_/A _5899_/A _5645_/B _5651_/B vddd vssd sg13cmos5l_o21ai_1
X_3897_ _3898_/D _7247_/Q _3895_/X _3901_/A vddd vssd sg13cmos5l_a21oi_1
X_5567_ _5568_/B _5903_/A _5571_/C _5567_/C vddd vssd sg13cmos5l_nor3_1
X_4518_ _4518_/Y _4633_/A _4518_/B _4518_/C vddd vssd sg13cmos5l_nor3_1
X_7306_ _7306_/Q _7307_/CLK _7306_/D _6819_/Y vddd vssd sg13cmos5l_dfrbpq_1
X_5498_ _5498_/Y _5649_/A1 _7171_/Q _5496_/Y vddd vssd sg13cmos5l_o21ai_1
XFILLER_8_2103 vddd vssd sg13cmos5l_decap_8
XFILLER_12_1890 vddd vssd sg13cmos5l_decap_4
X_7237_ _7237_/Q _7285_/CLK _7237_/D fanout386/X vddd vssd sg13cmos5l_dfrbpq_1
X_4449_ _4612_/B _4670_/A _4450_/C vddd vssd sg13cmos5l_nand2_1
XFILLER_28_1330 vddd vssd sg13cmos5l_decap_8
X_7168_ _7168_/Q _7206_/CLK _7168_/D fanout364/X vddd vssd sg13cmos5l_dfrbpq_1
X_6119_ _6119_/Y _6012_/A _5189_/A _6120_/B vddd vssd sg13cmos5l_o21ai_1
X_7099_ _7099_/Q _7120_/CLK _7099_/D _6959_/B_N vddd vssd sg13cmos5l_dfrbpq_1
XFILLER_2_1023 vddd vssd sg13cmos5l_decap_8
XFILLER_15_1919 vddd vssd sg13cmos5l_decap_4
XFILLER_13_1610 vddd vssd sg13cmos5l_decap_8
XFILLER_10_653 vddd vssd sg13cmos5l_decap_8
XFILLER_13_2399 vddd vssd sg13cmos5l_decap_4
Xtiedowns\[52\] mask_rev_in[8] vddd vssd sg13cmos5l_antennanp
XFILLER_4_2512 vddd vssd sg13cmos5l_decap_8
XFILLER_24_1761 vddd vssd sg13cmos5l_decap_8
XFILLER_4_1822 vddd vssd sg13cmos5l_decap_4
XFILLER_4_2589 vddd vssd sg13cmos5l_decap_8
XFILLER_20_1658 vddd vssd sg13cmos5l_decap_8
XFILLER_32_266 vddd vssd sg13cmos5l_decap_8
X_3820_ _3820_/X dbus_in_left[4] dbus_in_right[4] vddd vssd sg13cmos5l_or2_1
Xoutbuffers\[106\] dbus_out[9] _5574_/Y vddd vssd sg13cmos5l_buf_16
XFILLER_18_1554 vddd vssd sg13cmos5l_decap_8
X_3751_ _3755_/A _3752_/B _3967_/A _4257_/B vddd vssd sg13cmos5l_a21oi_1
XFILLER_31_2433 vddd vssd sg13cmos5l_decap_8
XFILLER_18_1587 vddd vssd sg13cmos5l_decap_4
XFILLER_14_1429 vddd vssd sg13cmos5l_decap_8
X_6470_ _6470_/Y _6470_/A _6473_/S vddd vssd sg13cmos5l_nor2_1
X_3682_ _3929_/B _3750_/A _3750_/B vddd vssd sg13cmos5l_nand2_1
X_5421_ _5421_/Y _5413_/Y _5420_/Y _5418_/Y vddd vssd sg13cmos5l_a21oi_1
X_5352_ _5352_/X _5368_/A _5374_/A vddd vssd sg13cmos5l_and2_1
XFILLER_29_2373 vddd vssd sg13cmos5l_decap_8
X_4303_ _4304_/C _4303_/A _4303_/B _4303_/C vddd vssd sg13cmos5l_and3_1
X_7022_ _7022_/Q _7191_/CLK _7022_/D fanout373/X vddd vssd sg13cmos5l_dfrbpq_1
X_5283_ _5283_/Y _4828_/B _3641_/Y _5285_/D _4828_/A vddd vssd sg13cmos5l_a22oi_1
XFILLER_9_2445 vddd vssd sg13cmos5l_decap_8
X_4234_ _4234_/Y _7034_/Q _3828_/Y _3831_/X _7039_/Q _3983_/B vddd vssd sg13cmos5l_a221oi_1
XFILLER_25_1558 vddd vssd sg13cmos5l_decap_8
X_4165_ _4165_/Y _3733_/Y _4163_/Y _4164_/Y vddd vssd sg13cmos5l_o21ai_1
X_4096_ _4096_/X _7265_/Q _4175_/B _3875_/Y vddd vssd sg13cmos5l_a21o_1
XFILLER_3_1354 vddd vssd sg13cmos5l_decap_4
XFILLER_23_200 vddd vssd sg13cmos5l_decap_8
X_6806_ _6806_/Y _6806_/A _6908_/B_N vddd vssd sg13cmos5l_nor2b_1
X_4998_ _5219_/A _7264_/Q _7265_/Q vddd vssd sg13cmos5l_nand2_1
XFILLER_23_14 vddd vssd sg13cmos5l_decap_8
XFILLER_17_1020 vddd vssd sg13cmos5l_decap_8
XFILLER_11_428 vddd vssd sg13cmos5l_decap_8
X_6737_ _6737_/X _6737_/A0 _6695_/A _6739_/S vddd vssd sg13cmos5l_mux2_1
X_3949_ _3949_/Y _6361_/B _3967_/B vddd vssd sg13cmos5l_nand2_1
X_6668_ _6668_/Y _6668_/A _6681_/S vddd vssd sg13cmos5l_nor2_1
XFILLER_10_2517 vddd vssd sg13cmos5l_decap_8
XFILLER_30_1253 vddd vssd sg13cmos5l_decap_4
X_5619_ _5623_/B _5631_/C _5624_/C vddd vssd sg13cmos5l_nor2_1
XFILLER_14_1996 vddd vssd sg13cmos5l_decap_4
X_6599_ _6599_/Y _6599_/A _6601_/S vddd vssd sg13cmos5l_nand2_1
Xfanout441 _5428_/A _5571_/A vddd vssd sg13cmos5l_buf_1
Xfanout430 _5902_/A _6226_/A vddd vssd sg13cmos5l_buf_1
XFILLER_8_1243 vddd vssd sg13cmos5l_decap_4
Xfanout452 _6227_/A1 io_in[10] vddd vssd sg13cmos5l_buf_1
XFILLER_28_1193 vddd vssd sg13cmos5l_decap_8
Xfanout463 _6806_/A CSB vddd vssd sg13cmos5l_buf_1
XFILLER_8_1254 vddd vssd sg13cmos5l_decap_8
XFILLER_19_2520 vddd vssd sg13cmos5l_decap_8
X_6895__465 _7383_/CLK _7364_/CLK vddd vssd sg13cmos5l_inv_1
XFILLER_14_200 vddd vssd sg13cmos5l_decap_4
XFILLER_19_2597 vddd vssd sg13cmos5l_decap_8
XFILLER_9_49 vddd vssd sg13cmos5l_decap_8
Xfanout92 _4155_/B _3705_/Y vddd vssd sg13cmos5l_buf_1
Xfanout70 _6376_/B _6374_/B vddd vssd sg13cmos5l_buf_1
XFILLER_15_1749 vddd vssd sg13cmos5l_decap_4
XFILLER_7_944 vddd vssd sg13cmos5l_decap_8
XFILLER_11_995 vddd vssd sg13cmos5l_decap_4
XFILLER_13_91 vddd vssd sg13cmos5l_decap_8
XFILLER_26_2546 vddd vssd sg13cmos5l_decap_8
XFILLER_9_1018 vddd vssd sg13cmos5l_decap_8
XFILLER_24_1580 vddd vssd sg13cmos5l_decap_4
XFILLER_20_1400 vddd vssd sg13cmos5l_decap_8
X_5970_ _5976_/C _5972_/B _5983_/A vddd vssd sg13cmos5l_nand2b_1
X_4921_ _7309_/D _4921_/A1 _4920_/C _4920_/Y vddd vssd sg13cmos5l_o21ai_1
X_4852_ _4852_/Y _4848_/B _4852_/B vddd vssd sg13cmos5l_nand2b_1
X_3803_ _3805_/C _7103_/Q _3803_/B vddd vssd sg13cmos5l_nand2_1
X_4783_ _4798_/B _4757_/B _4781_/B _4671_/A vddd vssd sg13cmos5l_o21ai_1
X_6522_ _6522_/Y _6553_/A _6524_/S vddd vssd sg13cmos5l_nor2_1
X_3734_ _3734_/Y _7105_/Q _3803_/B _3990_/A _7097_/Q _4073_/A vddd vssd sg13cmos5l_a221oi_1
X_3665_ _4002_/A _3750_/A _3750_/B vddd vssd sg13cmos5l_or2_1
X_6453_ _6453_/Y _6470_/A _6457_/B vddd vssd sg13cmos5l_nor2_1
Xoutbuffers\[83\] io_oe[10] _5280_/Y vddd vssd sg13cmos5l_buf_16
X_5404_ _5405_/A _7158_/Q _7159_/Q vddd vssd sg13cmos5l_nor2_1
X_6384_ _6384_/Y _6384_/A _6389_/S vddd vssd sg13cmos5l_nor2_1
X_3596_ _3596_/Y _7093_/Q vddd vssd sg13cmos5l_inv_1
X_5335_ _5335_/Y _3547_/Y _5339_/C _5334_/Y vddd vssd sg13cmos5l_a21oi_1
XFILLER_0_608 vddd vssd sg13cmos5l_decap_8
XFILLER_25_2023 vddd vssd sg13cmos5l_decap_8
X_5266_ _6243_/B _7276_/Q _5266_/B _5266_/C vddd vssd sg13cmos5l_nor3_1
X_7005_ _7005_/Q _7012_/CLK _7005_/D _6952_/Y vddd vssd sg13cmos5l_dfrbpq_1
X_4217_ _4217_/Y _7172_/Q _3943_/Y _3946_/Y vddd vssd sg13cmos5l_o21ai_1
XFILLER_28_303 vddd vssd sg13cmos5l_decap_8
XFILLER_25_1377 vddd vssd sg13cmos5l_decap_4
X_5197_ _5197_/Y _5275_/B _5216_/B vddd vssd sg13cmos5l_nor2_1
XFILLER_18_14 vddd vssd sg13cmos5l_decap_8
XFILLER_5_1427 vddd vssd sg13cmos5l_decap_4
X_4148_ _4148_/Y _4085_/Y _4147_/Y _4231_/C1 vddd vssd sg13cmos5l_a21oi_1
X_4079_ _4079_/Y mask_rev_in[26] _4079_/B vddd vssd sg13cmos5l_nor2_1
XFILLER_19_1159 vddd vssd sg13cmos5l_decap_4
Xwire105 _3781_/B _3752_/B vddd vssd sg13cmos5l_buf_4
XFILLER_11_225 vddd vssd sg13cmos5l_decap_8
XFILLER_32_1326 vddd vssd sg13cmos5l_decap_4
Xclkload1 clkload1/Y clkload1/A vddd vssd sg13cmos5l_inv_1
XFILLER_14_2450 vddd vssd sg13cmos5l_decap_8
XFILLER_32_1359 vddd vssd sg13cmos5l_decap_8
XFILLER_20_792 vddd vssd sg13cmos5l_decap_4
XFILLER_20_781 vddd vssd sg13cmos5l_decap_4
XFILLER_14_1760 vddd vssd sg13cmos5l_decap_8
XFILLER_10_2325 vddd vssd sg13cmos5l_decap_4
XFILLER_3_446 vddd vssd sg13cmos5l_decap_8
XFILLER_8_1051 vddd vssd sg13cmos5l_decap_8
XFILLER_21_2421 vddd vssd sg13cmos5l_decap_8
Xfanout271 _6258_/C1 hold1348/X vddd vssd sg13cmos5l_buf_1
Xfanout260 _4592_/B _7297_/Q vddd vssd sg13cmos5l_buf_1
Xfanout282 _5908_/A _7227_/Q vddd vssd sg13cmos5l_buf_1
Xfanout293 _5736_/A hold1372/X vddd vssd sg13cmos5l_buf_1
XFILLER_21_2498 vddd vssd sg13cmos5l_decap_8
XFILLER_21_1764 vddd vssd sg13cmos5l_decap_8
Xtiedowns\[15\] io_in[7] vddd vssd sg13cmos5l_antennanp
XFILLER_32_2594 vddd vssd sg13cmos5l_decap_8
XFILLER_7_741 vddd vssd sg13cmos5l_decap_8
Xhold708 _3521_/A _7114_/Q vddd vssd sg13cmos5l_dlygate4sd3_1
Xhold719 hold719/X _6776_/Y vddd vssd sg13cmos5l_dlygate4sd3_1
XFILLER_7_796 vddd vssd sg13cmos5l_decap_8
XFILLER_26_2343 vddd vssd sg13cmos5l_decap_8
X_5120_ _5121_/B _5120_/A _5120_/B _5120_/C _5120_/D vddd vssd sg13cmos5l_nor4_1
X_5051_ _5136_/B _7246_/Q _7247_/Q vddd vssd sg13cmos5l_nor2_1
X_4002_ _6673_/A _4002_/A _4002_/B _4002_/C _4002_/D vddd vssd sg13cmos5l_nor4_1
Xhold1408 hold1408/X _7153_/Q vddd vssd sg13cmos5l_dlygate4sd3_1
Xhold1419 _7207_/D _6509_/X vddd vssd sg13cmos5l_dlygate4sd3_1
XFILLER_22_1539 vddd vssd sg13cmos5l_decap_8
XFILLER_26_818 vddd vssd sg13cmos5l_decap_8
XFILLER_20_1230 vddd vssd sg13cmos5l_decap_4
XFILLER_19_870 vddd vssd sg13cmos5l_decap_8
XFILLER_0_2069 vddd vssd sg13cmos5l_decap_8
X_5953_ _5953_/Y _5953_/A _5953_/B vddd vssd sg13cmos5l_xnor2_1
X_4904_ _4904_/Y _4860_/Y wire25/X hold649/X vddd vssd sg13cmos5l_o21ai_1
X_5884_ _5884_/Y _7222_/Q _7223_/Q _5884_/C vddd vssd sg13cmos5l_nor3_1
XFILLER_21_556 vddd vssd sg13cmos5l_decap_4
X_4835_ _4835_/Y _4835_/A _4835_/B vddd vssd sg13cmos5l_nand2_1
X_4766_ _4766_/Y _4736_/B _4758_/B _4696_/A vddd vssd sg13cmos5l_o21ai_1
XFILLER_14_1023 vddd vssd sg13cmos5l_decap_8
X_3717_ _3717_/Y _3717_/A _3919_/A _3728_/B vddd vssd sg13cmos5l_nand3_1
X_6505_ _7204_/D _6505_/A1 _6509_/S hold946/X vddd vssd sg13cmos5l_o21ai_1
X_4697_ _4699_/A _4691_/Y _4693_/Y _4696_/Y vddd vssd sg13cmos5l_a21oi_1
X_3648_ _3651_/B _5945_/A _6972_/Q _6971_/Q vddd vssd sg13cmos5l_nor3_1
X_6436_ _6436_/Y _6436_/A _6441_/B vddd vssd sg13cmos5l_nand2_1
X_3579_ _5691_/A _3579_/A vddd vssd sg13cmos5l_inv_1
X_6367_ _7132_/D _6715_/A _6370_/B _6367_/B1 vddd vssd sg13cmos5l_o21ai_1
X_5318_ _5318_/Y _5372_/A _5316_/Y _5317_/Y vddd vssd sg13cmos5l_a21oi_1
X_6298_ _6298_/Y _6294_/A _6290_/B _6297_/A vddd vssd sg13cmos5l_o21ai_1
X_5249_ _5252_/B _6194_/B _6194_/C _6195_/A vddd vssd sg13cmos5l_a21oi_1
XFILLER_29_79 vddd vssd sg13cmos5l_decap_4
XFILLER_21_1016 vddd vssd sg13cmos5l_decap_8
XFILLER_29_689 vddd vssd sg13cmos5l_decap_8
XFILLER_28_155 vddd vssd sg13cmos5l_decap_8
XFILLER_0_2570 vddd vssd sg13cmos5l_decap_8
XFILLER_25_862 vddd vssd sg13cmos5l_decap_8
XFILLER_31_309 vddd vssd sg13cmos5l_decap_4
XFILLER_16_2567 vddd vssd sg13cmos5l_decap_8
XFILLER_32_1101 vddd vssd sg13cmos5l_decap_8
Xclkbuf_leaf_15_SCK_regs _7188_/CLK clkload4/A vddd vssd sg13cmos5l_buf_8
XFILLER_12_567 vddd vssd sg13cmos5l_decap_4
XFILLER_16_1888 vddd vssd sg13cmos5l_decap_8
XFILLER_10_2122 vddd vssd sg13cmos5l_decap_8
XFILLER_32_1178 vddd vssd sg13cmos5l_decap_8
XFILLER_6_28 vddd vssd sg13cmos5l_decap_8
XFILLER_10_2199 vddd vssd sg13cmos5l_decap_8
XFILLER_23_2516 vddd vssd sg13cmos5l_decap_8
XFILLER_27_1962 vddd vssd sg13cmos5l_decap_8
XFILLER_19_166 vddd vssd sg13cmos5l_decap_4
XFILLER_16_884 vddd vssd sg13cmos5l_decap_8
XFILLER_30_331 vddd vssd sg13cmos5l_decap_8
XFILLER_15_2033 vddd vssd sg13cmos5l_decap_8
X_4620_ _4620_/Y _4621_/B vddd vssd sg13cmos5l_inv_1
XFILLER_15_1343 vddd vssd sg13cmos5l_decap_8
XFILLER_32_2391 vddd vssd sg13cmos5l_decap_8
X_4551_ _4551_/Y _4471_/B _4551_/B vddd vssd sg13cmos5l_nand2b_1
Xhold516 _4509_/B _6991_/Q vddd vssd sg13cmos5l_dlygate4sd3_1
X_7270_ _7270_/Q _7275_/CLK _7270_/D fanout392/X vddd vssd sg13cmos5l_dfrbpq_1
Xhold527 _6997_/D _3467_/Y vddd vssd sg13cmos5l_dlygate4sd3_1
Xhold505 _7007_/D hold505/A vddd vssd sg13cmos5l_dlygate4sd3_1
X_4482_ _4512_/B _4755_/A _4482_/B vddd vssd sg13cmos5l_nand2_1
X_3502_ _4737_/A _7331_/Q vddd vssd sg13cmos5l_inv_1
Xhold549 _7015_/D _3460_/Y vddd vssd sg13cmos5l_dlygate4sd3_1
Xhold538 _4812_/B _6977_/Q vddd vssd sg13cmos5l_dlygate4sd3_1
XFILLER_28_2427 vddd vssd sg13cmos5l_decap_8
X_6221_ _6221_/Y _6221_/A _6221_/B _7230_/Q vddd vssd sg13cmos5l_nor3_1
X_6152_ _6152_/Y _6152_/A _6152_/B _6152_/C vddd vssd sg13cmos5l_nand3_1
XFILLER_32_0 vddd vssd sg13cmos5l_decap_8
X_5103_ _5121_/A _7286_/Q _5247_/B _6049_/A _5103_/D vddd vssd sg13cmos5l_nor4_1
Xhold1205 _7262_/D _6607_/X vddd vssd sg13cmos5l_dlygate4sd3_1
X_6083_ _6083_/Y _7287_/Q _6081_/Y _6082_/Y vddd vssd sg13cmos5l_o21ai_1
Xhold1216 _4303_/A _4287_/Y vddd vssd sg13cmos5l_dlygate4sd3_1
XFILLER_6_1511 vddd vssd sg13cmos5l_decap_4
Xhold1249 _6736_/A0 _7068_/Q vddd vssd sg13cmos5l_dlygate4sd3_1
Xoutbuffers\[46\] bandgap_trim[7] _6285_/B vddd vssd sg13cmos5l_buf_16
XFILLER_26_1483 vddd vssd sg13cmos5l_decap_4
Xhold1238 _6724_/A1 _7060_/Q vddd vssd sg13cmos5l_dlygate4sd3_1
X_5034_ _6000_/B _7280_/Q _7281_/Q vddd vssd sg13cmos5l_nor2_1
XFILLER_6_2289 vddd vssd sg13cmos5l_decap_4
Xhold1227 hold1227/X hold1227/A vddd vssd sg13cmos5l_dlygate4sd3_1
XFILLER_6_1577 vddd vssd sg13cmos5l_decap_4
XFILLER_25_114 vddd vssd sg13cmos5l_decap_8
X_6985_ _6985_/Q _7012_/CLK _6985_/D _6932_/Y vddd vssd sg13cmos5l_dfrbpq_1
X_5936_ _5939_/B _5936_/A _5936_/B vddd vssd sg13cmos5l_and2_1
Xclkbuf_3_0_0_SCK_regs clkbuf_3_0_0_SCK_regs/X clkbuf_0_SCK_regs/X vddd vssd sg13cmos5l_buf_8
XFILLER_22_876 vddd vssd sg13cmos5l_decap_8
X_5867_ _5884_/C _5867_/A _7221_/Q vddd vssd sg13cmos5l_nand2_1
X_4818_ _4818_/Y _4818_/A _4818_/B vddd vssd sg13cmos5l_nor2_1
X_5798_ _5800_/B _5798_/A _5798_/B vddd vssd sg13cmos5l_nor2_1
XFILLER_31_58 vddd vssd sg13cmos5l_decap_8
X_4749_ _4749_/Y _4681_/A _4748_/Y _4728_/Y vddd vssd sg13cmos5l_o21ai_1
XFILLER_11_2442 vddd vssd sg13cmos5l_decap_8
XFILLER_11_1730 vddd vssd sg13cmos5l_decap_8
X_6419_ _6419_/Y _6419_/A1 _6418_/B _6418_/Y vddd vssd sg13cmos5l_a21oi_1
XFILLER_11_1774 vddd vssd sg13cmos5l_decap_8
X_7399_ _7399_/Q _7399_/CLK _7399_/D _6911_/Y vddd vssd sg13cmos5l_dfrbpq_1
XFILLER_29_420 vddd vssd sg13cmos5l_decap_4
XFILLER_22_2560 vddd vssd sg13cmos5l_decap_8
XFILLER_17_637 vddd vssd sg13cmos5l_decap_8
XFILLER_32_607 vddd vssd sg13cmos5l_decap_8
XFILLER_31_128 vddd vssd sg13cmos5l_decap_8
XFILLER_16_1685 vddd vssd sg13cmos5l_decap_8
XFILLER_21_91 vddd vssd sg13cmos5l_decap_8
XFILLER_27_2460 vddd vssd sg13cmos5l_decap_8
XFILLER_7_1831 vddd vssd sg13cmos5l_decap_8
XFILLER_7_2554 vddd vssd sg13cmos5l_decap_8
XFILLER_23_1634 vddd vssd sg13cmos5l_decap_4
XFILLER_23_1667 vddd vssd sg13cmos5l_decap_8
XFILLER_3_1739 vddd vssd sg13cmos5l_decap_8
X_3982_ _3982_/Y _4155_/B _6378_/A vddd vssd sg13cmos5l_nand2_1
XFILLER_17_2117 vddd vssd sg13cmos5l_decap_8
X_6770_ _6770_/X hold820/X _6328_/A _6771_/B vddd vssd sg13cmos5l_mux2_1
X_5721_ _5721_/X _7200_/Q _7201_/Q vddd vssd sg13cmos5l_and2_1
XFILLER_17_1438 vddd vssd sg13cmos5l_decap_8
XFILLER_30_150 vddd vssd sg13cmos5l_decap_8
X_5652_ _5653_/D _5732_/A _5654_/B _5654_/C vddd vssd sg13cmos5l_o21ai_1
X_4603_ _4604_/B _4603_/A _7008_/D vddd vssd sg13cmos5l_xnor2_1
X_5583_ _5583_/Y _7336_/Q _5583_/B vddd vssd sg13cmos5l_nor2_1
X_4534_ _4534_/Y _4789_/A _4534_/B vddd vssd sg13cmos5l_nor2_1
X_7322_ _7322_/Q _7395_/CLK _7322_/D _6835_/Y vddd vssd sg13cmos5l_dfrbpq_1
XFILLER_28_2235 vddd vssd sg13cmos5l_decap_4
X_4465_ _4714_/B _4737_/A _4707_/B vddd vssd sg13cmos5l_and2_1
X_7253_ _7253_/Q _7292_/CLK _7253_/D fanout389/X vddd vssd sg13cmos5l_dfrbpq_1
X_7184_ _7184_/Q _7187_/CLK _7184_/D fanout369/X vddd vssd sg13cmos5l_dfrbpq_1
X_6204_ _6204_/Y _6204_/A _6204_/B _6204_/C vddd vssd sg13cmos5l_nand3_1
X_4396_ _4420_/A _4489_/A _4396_/B vddd vssd sg13cmos5l_nor2_1
XFILLER_28_1578 vddd vssd sg13cmos5l_decap_8
X_6135_ _6135_/Y _6241_/A _5193_/A _6134_/Y vddd vssd sg13cmos5l_a21oi_1
X_6066_ _6066_/Y _6151_/A _6065_/B _5129_/A vddd vssd sg13cmos5l_a21oi_1
Xhold1024 hold482/A hold1515/X vddd vssd sg13cmos5l_dlygate4sd3_1
Xhold1013 _7285_/D _6645_/X vddd vssd sg13cmos5l_dlygate4sd3_1
Xhold1002 hold1002/X _5031_/B vddd vssd sg13cmos5l_dlygate4sd3_1
Xhold1035 _7278_/D _6634_/X vddd vssd sg13cmos5l_dlygate4sd3_1
X_5017_ _5021_/C _5216_/A _5275_/A vddd vssd sg13cmos5l_nor2_1
Xhold1057 _4419_/B _4418_/X vddd vssd sg13cmos5l_dlygate4sd3_1
XFILLER_6_2086 vddd vssd sg13cmos5l_decap_8
Xhold1046 _7286_/D _6646_/X vddd vssd sg13cmos5l_dlygate4sd3_1
XFILLER_26_401 vddd vssd sg13cmos5l_decap_4
XFILLER_26_14 vddd vssd sg13cmos5l_decap_8
XFILLER_22_1177 vddd vssd sg13cmos5l_decap_4
Xhold1079 _6713_/B1 _6712_/Y vddd vssd sg13cmos5l_dlygate4sd3_1
XFILLER_2_1227 vddd vssd sg13cmos5l_decap_8
Xhold1068 _3570_/A _7179_/Q vddd vssd sg13cmos5l_dlygate4sd3_1
X_6968_ _6968_/Q _7003_/CLK _6968_/D _6915_/Y vddd vssd sg13cmos5l_dfrbpq_1
X_5919_ _5919_/Y _7090_/Q _5936_/A _5918_/X vddd vssd sg13cmos5l_o21ai_1
XFILLER_13_2504 vddd vssd sg13cmos5l_decap_8
XFILLER_13_1814 vddd vssd sg13cmos5l_decap_8
Xhold880 _4275_/S _4276_/B vddd vssd sg13cmos5l_dlygate4sd3_1
Xhold891 _7125_/D _6355_/X vddd vssd sg13cmos5l_dlygate4sd3_1
XFILLER_7_1127 vddd vssd sg13cmos5l_decap_8
XFILLER_18_902 vddd vssd sg13cmos5l_decap_8
Xclkbuf_leaf_30_SCK_regs _7252_/CLK clkload6/A vddd vssd sg13cmos5l_buf_8
XFILLER_32_448 vddd vssd sg13cmos5l_decap_4
XFILLER_16_91 vddd vssd sg13cmos5l_decap_4
XFILLER_16_2183 vddd vssd sg13cmos5l_decap_8
XFILLER_12_2014 vddd vssd sg13cmos5l_decap_8
XFILLER_16_1460 vddd vssd sg13cmos5l_decap_8
XFILLER_12_1324 vddd vssd sg13cmos5l_decap_8
XFILLER_29_2555 vddd vssd sg13cmos5l_decap_8
X_4250_ _4252_/B _4250_/A _4250_/B _4250_/C _4250_/D vddd vssd sg13cmos5l_nor4_1
XFILLER_23_2110 vddd vssd sg13cmos5l_decap_4
X_4181_ _4181_/Y _5202_/B wire99/X _4179_/Y _4180_/Y _3868_/Y vddd vssd sg13cmos5l_a221oi_1
XFILLER_9_1948 vddd vssd sg13cmos5l_decap_8
XFILLER_23_1464 vddd vssd sg13cmos5l_decap_4
X_6822_ _6822_/Y _6828_/A _6822_/B_N vddd vssd sg13cmos5l_nor2b_1
XFILLER_23_437 vddd vssd sg13cmos5l_decap_4
X_6753_ _6753_/Y _6753_/A _6753_/B vddd vssd sg13cmos5l_nand2_1
X_3965_ _3965_/Y _3959_/Y _3962_/Y _3964_/Y vddd vssd sg13cmos5l_o21ai_1
X_6684_ _6684_/Y _6684_/A _6690_/S vddd vssd sg13cmos5l_nor2_1
X_5704_ _5706_/B _7196_/Q _7197_/Q _5704_/C vddd vssd sg13cmos5l_nor3_1
X_3896_ _6576_/A _3896_/A _3896_/B vddd vssd sg13cmos5l_nand2_1
X_5635_ _5645_/B _7188_/Q _5651_/A vddd vssd sg13cmos5l_nand2_1
XFILLER_30_1435 vddd vssd sg13cmos5l_decap_4
XFILLER_12_49 vddd vssd sg13cmos5l_decap_8
X_5566_ _5566_/Y _5398_/A _5553_/Y _5554_/X _5737_/A vddd vssd sg13cmos5l_a22oi_1
X_4517_ _4518_/C _4609_/A _4517_/B vddd vssd sg13cmos5l_nor2_1
X_5497_ _5497_/Y _5527_/A _5497_/B _5511_/A vddd vssd sg13cmos5l_nor3_1
X_7305_ _7305_/Q _7307_/CLK _7305_/D _6818_/Y vddd vssd sg13cmos5l_dfrbpq_1
X_7236_ _7236_/Q _7287_/CLK _7236_/D fanout386/X vddd vssd sg13cmos5l_dfrbpq_1
X_4448_ _4450_/C _6063_/A _4448_/B vddd vssd sg13cmos5l_nor2_1
X_7167_ _7167_/Q _7206_/CLK _7167_/D fanout368/X vddd vssd sg13cmos5l_dfrbpq_1
X_4379_ _4392_/B _4379_/A _4379_/B _4379_/C _4379_/D vddd vssd sg13cmos5l_nand4_1
XFILLER_8_1447 vddd vssd sg13cmos5l_decap_8
X_7098_ _7098_/Q _7259_/CLK _7098_/D fanout396/X vddd vssd sg13cmos5l_dfrbpq_1
X_6118_ _6118_/Y _5186_/B _6116_/Y _6117_/Y vddd vssd sg13cmos5l_a21oi_1
X_6049_ _6049_/Y _6049_/A _6049_/B _6049_/C vddd vssd sg13cmos5l_nor3_1
XFILLER_6_1171 vddd vssd sg13cmos5l_decap_4
XFILLER_27_732 vddd vssd sg13cmos5l_decap_8
XFILLER_10_610 vddd vssd sg13cmos5l_decap_4
XFILLER_13_2334 vddd vssd sg13cmos5l_decap_4
XFILLER_13_2389 vddd vssd sg13cmos5l_decap_8
XFILLER_6_669 vddd vssd sg13cmos5l_decap_8
XFILLER_2_853 vddd vssd sg13cmos5l_decap_4
Xtiedowns\[45\] mask_rev_in[1] vddd vssd sg13cmos5l_antennanp
XFILLER_24_2485 vddd vssd sg13cmos5l_decap_8
XFILLER_18_710 vddd vssd sg13cmos5l_decap_8
XFILLER_4_1889 vddd vssd sg13cmos5l_decap_4
XFILLER_32_245 vddd vssd sg13cmos5l_decap_8
XFILLER_31_2412 vddd vssd sg13cmos5l_decap_8
X_3750_ _4071_/C _3750_/A _3750_/B _3750_/C _3750_/D vddd vssd sg13cmos5l_or4_1
XFILLER_31_2489 vddd vssd sg13cmos5l_decap_8
X_3681_ _3749_/B _3750_/C _3750_/D vddd vssd sg13cmos5l_or2_1
XFILLER_12_1121 vddd vssd sg13cmos5l_decap_4
X_5420_ _5420_/Y _5533_/A _7158_/Q _5419_/X vddd vssd sg13cmos5l_o21ai_1
X_5351_ _5374_/A _5363_/B _7151_/Q vddd vssd sg13cmos5l_nor2_1
XFILLER_29_2352 vddd vssd sg13cmos5l_decap_8
X_4302_ _4303_/C _4302_/A _4302_/B vddd vssd sg13cmos5l_nor2_1
X_5282_ _5282_/Y _5282_/A vddd vssd sg13cmos5l_inv_1
XFILLER_12_1198 vddd vssd sg13cmos5l_decap_8
XFILLER_29_1662 vddd vssd sg13cmos5l_decap_4
X_7021_ _7021_/Q _7188_/CLK _7021_/D fanout375/X vddd vssd sg13cmos5l_dfrbpq_1
X_4233_ _4233_/X _4230_/Y _4231_/Y _4232_/Y vddd vssd sg13cmos5l_a21o_1
XFILLER_25_1504 vddd vssd sg13cmos5l_decap_8
XFILLER_9_2479 vddd vssd sg13cmos5l_decap_8
XFILLER_7_2181 vddd vssd sg13cmos5l_decap_8
X_4164_ _4164_/Y _7091_/Q _3990_/A _4073_/A vddd vssd sg13cmos5l_a21oi_1
X_4095_ _4095_/Y _5077_/B _3862_/Y _4093_/Y _4094_/Y _4175_/B vddd vssd sg13cmos5l_a221oi_1
XFILLER_19_1308 vddd vssd sg13cmos5l_decap_8
X_6805_ _6805_/Y _6806_/A _6908_/B_N vddd vssd sg13cmos5l_nor2b_1
X_6736_ _6736_/X _6736_/A0 _6686_/A _6739_/S vddd vssd sg13cmos5l_mux2_1
X_4997_ _5022_/A _5278_/A _4997_/B _4997_/C vddd vssd sg13cmos5l_nor3_1
X_3948_ _6429_/A _3948_/A _3966_/B vddd vssd sg13cmos5l_nor2_1
X_6667_ _6682_/S _6667_/A _6667_/B vddd vssd sg13cmos5l_and2_1
Xclkbuf_0_SCK clkbuf_0_SCK/X SCK vddd vssd sg13cmos5l_buf_8
XFILLER_14_1931 vddd vssd sg13cmos5l_decap_4
X_3879_ _3879_/Y _6622_/A _3908_/A vddd vssd sg13cmos5l_nor2_1
X_5618_ _5624_/C _5620_/B _5621_/B vddd vssd sg13cmos5l_nand2b_1
X_6598_ _6598_/X _6598_/A0 _6605_/A _6601_/S vddd vssd sg13cmos5l_mux2_1
X_5549_ _5571_/B _5550_/C vddd vssd sg13cmos5l_inv_1
XFILLER_3_7 vddd vssd sg13cmos5l_decap_4
Xfanout431 _6226_/A io_in[6] vddd vssd sg13cmos5l_buf_1
X_7219_ _7219_/Q _7287_/CLK _7219_/D _6828_/B_N vddd vssd sg13cmos5l_dfrbpq_1
Xfanout420 _5637_/A _6216_/A1 vddd vssd sg13cmos5l_buf_1
XFILLER_21_2603 vddd vssd sg13cmos5l_decap_4
Xfanout453 _5683_/A io_in[0] vddd vssd sg13cmos5l_buf_1
Xfanout442 _5571_/A _6239_/A1 vddd vssd sg13cmos5l_buf_1
XFILLER_19_529 vddd vssd sg13cmos5l_decap_8
XFILLER_8_1277 vddd vssd sg13cmos5l_decap_8
XFILLER_19_2576 vddd vssd sg13cmos5l_decap_8
XFILLER_30_716 vddd vssd sg13cmos5l_decap_4
XFILLER_9_28 vddd vssd sg13cmos5l_decap_8
Xfanout71 _6324_/B _6330_/B vddd vssd sg13cmos5l_buf_1
XFILLER_15_1728 vddd vssd sg13cmos5l_decap_8
XFILLER_13_2153 vddd vssd sg13cmos5l_decap_8
Xfanout93 _4242_/A2 _6332_/A vddd vssd sg13cmos5l_buf_1
XFILLER_13_2197 vddd vssd sg13cmos5l_decap_8
XFILLER_13_70 vddd vssd sg13cmos5l_decap_8
XFILLER_13_1485 vddd vssd sg13cmos5l_decap_8
XFILLER_26_2525 vddd vssd sg13cmos5l_decap_8
XFILLER_4_2332 vddd vssd sg13cmos5l_decap_8
XFILLER_20_2135 vddd vssd sg13cmos5l_decap_4
XFILLER_0_2218 vddd vssd sg13cmos5l_decap_8
XFILLER_4_2376 vddd vssd sg13cmos5l_decap_8
XFILLER_20_1489 vddd vssd sg13cmos5l_decap_8
X_4920_ _4920_/Y _4920_/A sram_odata[0] _4920_/C vddd vssd sg13cmos5l_nand3_1
X_4851_ _4852_/B _4855_/A _4855_/B _3643_/A vddd vssd sg13cmos5l_o21ai_1
X_3802_ _3805_/B _7087_/Q _4073_/A _3990_/A _7095_/Q vddd vssd sg13cmos5l_a22oi_1
XFILLER_21_749 vddd vssd sg13cmos5l_decap_8
XFILLER_18_2097 vddd vssd sg13cmos5l_decap_8
X_4782_ _4785_/C _4782_/A _4782_/B vddd vssd sg13cmos5l_nand2_1
XFILLER_14_790 vddd vssd sg13cmos5l_decap_4
X_6521_ _7213_/D _6521_/A1 _6524_/S _6520_/Y vddd vssd sg13cmos5l_a21oi_1
X_3733_ _3733_/Y _6773_/A _6773_/B vddd vssd sg13cmos5l_nor2_1
X_3664_ _3673_/A _3750_/A _3750_/B vddd vssd sg13cmos5l_nor2_1
X_6452_ _7176_/D _6482_/A1 _6457_/B hold887/X vddd vssd sg13cmos5l_o21ai_1
X_5403_ _5403_/Y _5604_/A1 _5401_/X _5402_/Y _5400_/Y vddd vssd sg13cmos5l_a22oi_1
X_6383_ _6389_/S _6383_/A _6733_/B vddd vssd sg13cmos5l_nor2_1
X_3595_ _5925_/B _7094_/Q vddd vssd sg13cmos5l_inv_1
X_5334_ _5334_/Y _5533_/A _7146_/Q _5332_/Y vddd vssd sg13cmos5l_o21ai_1
Xoutbuffers\[76\] io_oe[3] _5141_/Y vddd vssd sg13cmos5l_buf_16
XFILLER_9_2221 vddd vssd sg13cmos5l_decap_8
XFILLER_29_2193 vddd vssd sg13cmos5l_decap_8
X_5265_ _5277_/A _5265_/A _5265_/B vddd vssd sg13cmos5l_nand2_1
X_5196_ _5206_/B _5270_/B _5209_/B vddd vssd sg13cmos5l_and2_1
X_7004_ _7004_/Q _7012_/CLK _7004_/D _6951_/Y vddd vssd sg13cmos5l_dfrbpq_1
XFILLER_25_2057 vddd vssd sg13cmos5l_decap_4
X_4216_ _4216_/Y _7176_/Q _6450_/A _4214_/Y _4215_/Y _6443_/A vddd vssd sg13cmos5l_a221oi_1
XFILLER_25_1356 vddd vssd sg13cmos5l_decap_8
X_4147_ _4147_/Y _4144_/Y _4145_/Y _4146_/Y vddd vssd sg13cmos5l_o21ai_1
XFILLER_23_1080 vddd vssd sg13cmos5l_decap_8
X_4078_ _4078_/Y mask_rev_in[18] _4168_/B1 _4076_/Y _4077_/Y _3852_/A vddd vssd sg13cmos5l_a221oi_1
XFILLER_3_1185 vddd vssd sg13cmos5l_decap_8
XFILLER_19_1105 vddd vssd sg13cmos5l_decap_8
XFILLER_32_1305 vddd vssd sg13cmos5l_decap_8
XFILLER_32_1338 vddd vssd sg13cmos5l_decap_8
X_6719_ _6719_/Y _6719_/A _6724_/S vddd vssd sg13cmos5l_nand2_1
Xwire128 _6773_/C _6303_/Y vddd vssd sg13cmos5l_buf_8
XFILLER_7_219 vddd vssd sg13cmos5l_decap_4
Xwire106 _3752_/B _3727_/Y vddd vssd sg13cmos5l_buf_4
Xclkload2 clkload2/X clkload2/A vddd vssd sg13cmos5l_buf_8
XFILLER_10_1625 vddd vssd sg13cmos5l_decap_8
Xfanout250 _5393_/A hold1471/X vddd vssd sg13cmos5l_buf_1
Xfanout272 _5228_/A hold1375/X vddd vssd sg13cmos5l_buf_1
Xfanout261 _5996_/A _4914_/A vddd vssd sg13cmos5l_buf_1
XFILLER_8_1085 vddd vssd sg13cmos5l_decap_8
Xfanout283 _5910_/C _7225_/Q vddd vssd sg13cmos5l_buf_1
Xfanout294 _5708_/B hold1484/X vddd vssd sg13cmos5l_buf_1
XFILLER_21_2477 vddd vssd sg13cmos5l_decap_8
XFILLER_21_1754 vddd vssd sg13cmos5l_decap_4
XFILLER_5_1973 vddd vssd sg13cmos5l_decap_8
XFILLER_15_587 vddd vssd sg13cmos5l_decap_4
XFILLER_15_2226 vddd vssd sg13cmos5l_decap_8
XFILLER_24_91 vddd vssd sg13cmos5l_decap_8
XFILLER_32_2573 vddd vssd sg13cmos5l_decap_8
XFILLER_32_1894 vddd vssd sg13cmos5l_decap_8
Xhold709 hold709/X _3521_/Y vddd vssd sg13cmos5l_dlygate4sd3_1
X_5050_ _5227_/B _7244_/Q _7245_/Q vddd vssd sg13cmos5l_nor2_1
XFILLER_26_2399 vddd vssd sg13cmos5l_decap_8
XFILLER_26_1665 vddd vssd sg13cmos5l_decap_4
X_4001_ _4001_/Y _3998_/Y _3999_/Y hold598/X vddd vssd sg13cmos5l_o21ai_1
Xhold1409 _6409_/A1 _5393_/B vddd vssd sg13cmos5l_dlygate4sd3_1
XFILLER_26_1687 vddd vssd sg13cmos5l_decap_4
XFILLER_22_1518 vddd vssd sg13cmos5l_decap_8
XFILLER_0_2048 vddd vssd sg13cmos5l_decap_8
XFILLER_1_62 vddd vssd sg13cmos5l_decap_8
X_5952_ _6971_/D _5953_/B _5952_/B vddd vssd sg13cmos5l_and2_1
X_4903_ wire26/A _4920_/A _4903_/B _4903_/C _4934_/B vddd vssd sg13cmos5l_nand4_1
X_5883_ _5883_/Y _7222_/Q _7223_/Q _5883_/C vddd vssd sg13cmos5l_nor3_1
X_4834_ _4834_/Y sram_odata[7] _4856_/A2 _4833_/X _4841_/B vddd vssd sg13cmos5l_a22oi_1
X_4765_ _4765_/Y _4764_/Y _4765_/B vddd vssd sg13cmos5l_nand2b_1
X_3716_ _3859_/A _3919_/B _3919_/A vddd vssd sg13cmos5l_nor2b_1
X_6504_ _6504_/Y _6504_/A _6509_/S vddd vssd sg13cmos5l_nand2_1
XFILLER_11_1901 vddd vssd sg13cmos5l_decap_8
X_4696_ _4696_/Y _4696_/A _4696_/B vddd vssd sg13cmos5l_nor2_1
XFILLER_11_1923 vddd vssd sg13cmos5l_decap_8
XFILLER_20_49 vddd vssd sg13cmos5l_decap_8
X_6435_ _6441_/B _6435_/A _6459_/B vddd vssd sg13cmos5l_nand2_1
X_3647_ _4833_/B _4839_/A _3647_/B _4841_/A vddd vssd sg13cmos5l_nor3_1
XFILLER_11_1945 vddd vssd sg13cmos5l_decap_8
X_3578_ _5669_/B _3578_/A vddd vssd sg13cmos5l_inv_1
X_6366_ _6366_/Y _6366_/A _6370_/B vddd vssd sg13cmos5l_nand2_1
X_5317_ _5317_/Y _7142_/Q _5317_/B vddd vssd sg13cmos5l_nor2_1
X_6297_ _6297_/Y _6297_/A vddd vssd sg13cmos5l_inv_1
XFILLER_9_2062 vddd vssd sg13cmos5l_decap_8
XFILLER_29_58 vddd vssd sg13cmos5l_decap_8
X_5248_ _6195_/A _5264_/A _5248_/B vddd vssd sg13cmos5l_nor2_1
X_5179_ _6106_/C _5246_/B _5215_/B vddd vssd sg13cmos5l_nor2_1
XFILLER_28_134 vddd vssd sg13cmos5l_decap_8
XFILLER_16_2546 vddd vssd sg13cmos5l_decap_8
XFILLER_10_2112 vddd vssd sg13cmos5l_decap_4
XFILLER_12_1709 vddd vssd sg13cmos5l_decap_8
XFILLER_32_1157 vddd vssd sg13cmos5l_decap_8
XFILLER_10_1433 vddd vssd sg13cmos5l_decap_8
XFILLER_10_2189 vddd vssd sg13cmos5l_decap_4
XFILLER_4_756 vddd vssd sg13cmos5l_decap_8
XFILLER_4_789 vddd vssd sg13cmos5l_decap_8
XFILLER_10_1499 vddd vssd sg13cmos5l_decap_8
XFILLER_10_93 vddd vssd sg13cmos5l_decap_8
XFILLER_5_2460 vddd vssd sg13cmos5l_decap_8
XFILLER_19_91 vddd vssd sg13cmos5l_decap_8
XFILLER_5_1781 vddd vssd sg13cmos5l_decap_8
XFILLER_21_1584 vddd vssd sg13cmos5l_decap_8
XFILLER_19_1491 vddd vssd sg13cmos5l_decap_8
XFILLER_15_2067 vddd vssd sg13cmos5l_decap_4
XFILLER_15_1311 vddd vssd sg13cmos5l_decap_8
XFILLER_32_2370 vddd vssd sg13cmos5l_decap_8
X_4550_ _4550_/Y _4551_/B vddd vssd sg13cmos5l_inv_1
Xhold506 _3461_/A _7013_/Q vddd vssd sg13cmos5l_dlygate4sd3_1
Xhold517 _6992_/D _3470_/Y vddd vssd sg13cmos5l_dlygate4sd3_1
XFILLER_28_2406 vddd vssd sg13cmos5l_decap_8
X_4481_ _4484_/B _4628_/A _4481_/B vddd vssd sg13cmos5l_nor2_1
X_3501_ _6041_/A _7332_/Q vddd vssd sg13cmos5l_inv_1
Xhold528 _4603_/A _6987_/Q vddd vssd sg13cmos5l_dlygate4sd3_1
Xhold539 _6978_/D _3480_/Y vddd vssd sg13cmos5l_dlygate4sd3_1
X_6220_ _6220_/Y _6233_/B _7229_/Q _6220_/C vddd vssd sg13cmos5l_nand3_1
XFILLER_28_1716 vddd vssd sg13cmos5l_decap_8
X_6151_ _6152_/C _6151_/A _6151_/B vddd vssd sg13cmos5l_nand2_1
X_5102_ _5103_/D _5102_/A _5102_/B _5102_/C vddd vssd sg13cmos5l_nand3_1
Xhold1206 _6621_/A0 _7271_/Q vddd vssd sg13cmos5l_dlygate4sd3_1
XFILLER_25_0 vddd vssd sg13cmos5l_decap_8
X_6082_ _6082_/Y _3514_/Y _7287_/Q _5090_/B vddd vssd sg13cmos5l_a21oi_1
Xhold1239 _7060_/D _6724_/X vddd vssd sg13cmos5l_dlygate4sd3_1
X_5033_ sram_read _5031_/B _7362_/Q _5996_/A vddd vssd sg13cmos5l_a21o_1
Xhold1217 _4971_/A _4304_/C vddd vssd sg13cmos5l_dlygate4sd3_1
Xhold1228 _5292_/A _5291_/Y vddd vssd sg13cmos5l_dlygate4sd3_1
Xoutbuffers\[39\] bandgap_trim[0] _6288_/X vddd vssd sg13cmos5l_buf_16
X_6984_ _6984_/Q _7012_/CLK _6984_/D _6931_/Y vddd vssd sg13cmos5l_dfrbpq_1
XFILLER_20_1094 vddd vssd sg13cmos5l_decap_8
X_5935_ _5954_/A _6973_/D _5935_/B _5935_/C vddd vssd sg13cmos5l_nand3_1
XFILLER_15_49 vddd vssd sg13cmos5l_decap_8
X_5866_ _5879_/A _5887_/A _5866_/B vddd vssd sg13cmos5l_nor2_1
XFILLER_22_855 vddd vssd sg13cmos5l_decap_8
X_4817_ _4819_/B _7077_/Q _4817_/B vddd vssd sg13cmos5l_xnor2_1
X_5797_ _5798_/B _5799_/C _5794_/Y _5799_/B vddd vssd sg13cmos5l_a21oi_1
XFILLER_31_37 vddd vssd sg13cmos5l_decap_8
X_4748_ _4748_/Y _4769_/A1 _4730_/Y _4744_/Y _4747_/Y vddd vssd sg13cmos5l_a22oi_1
X_4679_ _4680_/B _4814_/A1 _3604_/Y _4773_/B1 _4674_/X vddd vssd sg13cmos5l_a22oi_1
X_6418_ _6418_/Y _6465_/A _6418_/B vddd vssd sg13cmos5l_nor2_1
XFILLER_11_2498 vddd vssd sg13cmos5l_decap_8
X_7398_ _7398_/Q _7398_/CLK _7398_/D _6910_/Y vddd vssd sg13cmos5l_dfrbpq_1
X_6349_ _6359_/S _6349_/A _6615_/C vddd vssd sg13cmos5l_nor2_1
XFILLER_0_225 vddd vssd sg13cmos5l_decap_8
XFILLER_27_1259 vddd vssd sg13cmos5l_decap_8
XFILLER_0_269 vddd vssd sg13cmos5l_decap_8
XFILLER_31_107 vddd vssd sg13cmos5l_decap_8
XFILLER_13_811 vddd vssd sg13cmos5l_decap_8
XFILLER_16_1642 vddd vssd sg13cmos5l_decap_4
XFILLER_9_848 vddd vssd sg13cmos5l_decap_8
XFILLER_8_347 vddd vssd sg13cmos5l_decap_8
Xtiedowns\[75\] mask_rev_in[31] vddd vssd sg13cmos5l_antennanp
XFILLER_12_1539 vddd vssd sg13cmos5l_decap_8
XFILLER_21_70 vddd vssd sg13cmos5l_decap_8
XFILLER_4_553 vddd vssd sg13cmos5l_decap_8
XFILLER_7_2533 vddd vssd sg13cmos5l_decap_8
XFILLER_21_2082 vddd vssd sg13cmos5l_decap_8
X_3981_ _6378_/A _6361_/A _3981_/B vddd vssd sg13cmos5l_nand2_1
XFILLER_22_129 vddd vssd sg13cmos5l_decap_8
XFILLER_16_671 vddd vssd sg13cmos5l_decap_4
X_5720_ _5736_/C _7200_/Q _7201_/Q vddd vssd sg13cmos5l_nand2b_1
X_5651_ _5654_/C _5651_/A _5651_/B vddd vssd sg13cmos5l_nor2_1
X_5582_ _5597_/C _7180_/Q _7181_/Q vddd vssd sg13cmos5l_nand2_1
X_4602_ _4602_/Y _4616_/A _4593_/Y _4601_/X vddd vssd sg13cmos5l_o21ai_1
XFILLER_15_1152 vddd vssd sg13cmos5l_decap_8
X_4533_ _4534_/B _4533_/A _4533_/B vddd vssd sg13cmos5l_xnor2_1
X_7321_ _7321_/Q _7395_/CLK _7321_/D _6834_/Y vddd vssd sg13cmos5l_dfrbpq_1
XFILLER_28_2214 vddd vssd sg13cmos5l_decap_8
X_7252_ _7252_/Q _7252_/CLK _7252_/D fanout389/X vddd vssd sg13cmos5l_dfrbpq_1
XFILLER_11_1049 vddd vssd sg13cmos5l_decap_8
XFILLER_28_1502 vddd vssd sg13cmos5l_decap_8
X_6203_ _6204_/C _6203_/A _6203_/B vddd vssd sg13cmos5l_nand2_1
X_4464_ _4707_/B _4464_/A _4464_/B vddd vssd sg13cmos5l_and2_1
X_7183_ _7183_/Q _7188_/CLK _7183_/D fanout370/X vddd vssd sg13cmos5l_dfrbpq_1
X_4395_ _4395_/Y _4395_/A vddd vssd sg13cmos5l_inv_1
Xclkbuf_leaf_0_SCK_regs _7372_/CLK clkbuf_3_0_0_SCK_regs/X vddd vssd sg13cmos5l_buf_8
XFILLER_28_1557 vddd vssd sg13cmos5l_decap_4
X_6134_ _6134_/Y _4195_/Y _5204_/D _6132_/Y _6133_/Y _5193_/A vddd vssd sg13cmos5l_a221oi_1
X_6065_ _6065_/X _6243_/A _6065_/B _6065_/C vddd vssd sg13cmos5l_or3_1
Xhold1014 _6584_/A _7248_/Q vddd vssd sg13cmos5l_dlygate4sd3_1
Xhold1003 _7363_/D _4306_/Y vddd vssd sg13cmos5l_dlygate4sd3_1
XFILLER_6_2065 vddd vssd sg13cmos5l_decap_8
Xhold1025 _5999_/A0 _4863_/A vddd vssd sg13cmos5l_dlygate4sd3_1
X_5016_ _5275_/A _7262_/Q _7263_/Q vddd vssd sg13cmos5l_nand2b_1
Xhold1036 _3613_/A _7232_/Q vddd vssd sg13cmos5l_dlygate4sd3_1
Xhold1047 _6653_/A _7292_/Q vddd vssd sg13cmos5l_dlygate4sd3_1
Xhold1058 _4420_/B _4419_/Y vddd vssd sg13cmos5l_dlygate4sd3_1
Xhold1069 _6458_/A1 _5552_/B vddd vssd sg13cmos5l_dlygate4sd3_1
XFILLER_26_435 vddd vssd sg13cmos5l_decap_8
X_6967_ _6967_/Q _7003_/CLK _6967_/D _6914_/Y vddd vssd sg13cmos5l_dfrbpq_1
X_5918_ _5918_/X _7091_/Q _6966_/Q vddd vssd sg13cmos5l_or2_1
XFILLER_10_803 vddd vssd sg13cmos5l_decap_4
X_5849_ _5849_/Y _5849_/A _5849_/B _5849_/C vddd vssd sg13cmos5l_nor3_1
XFILLER_6_807 vddd vssd sg13cmos5l_decap_8
XFILLER_10_869 vddd vssd sg13cmos5l_decap_4
XFILLER_11_2240 vddd vssd sg13cmos5l_decap_8
Xhold881 _7373_/D _4275_/X vddd vssd sg13cmos5l_dlygate4sd3_1
Xhold870 hold870/X _4347_/Y vddd vssd sg13cmos5l_dlygate4sd3_1
Xhold892 _6421_/A _7160_/Q vddd vssd sg13cmos5l_dlygate4sd3_1
XFILLER_27_1067 vddd vssd sg13cmos5l_decap_8
XFILLER_17_446 vddd vssd sg13cmos5l_decap_8
XFILLER_32_427 vddd vssd sg13cmos5l_decap_8
XFILLER_26_991 vddd vssd sg13cmos5l_decap_8
XFILLER_16_70 vddd vssd sg13cmos5l_decap_8
XFILLER_9_601 vddd vssd sg13cmos5l_decap_8
XFILLER_16_2151 vddd vssd sg13cmos5l_decap_8
XFILLER_13_674 vddd vssd sg13cmos5l_decap_8
XFILLER_32_91 vddd vssd sg13cmos5l_decap_8
XFILLER_29_2534 vddd vssd sg13cmos5l_decap_8
XFILLER_5_884 vddd vssd sg13cmos5l_decap_8
XFILLER_29_1822 vddd vssd sg13cmos5l_decap_8
XFILLER_4_383 vddd vssd sg13cmos5l_decap_8
XFILLER_9_1905 vddd vssd sg13cmos5l_decap_4
XFILLER_25_1708 vddd vssd sg13cmos5l_decap_8
X_4180_ _4180_/Y _7284_/Q _3687_/Y _6636_/A _7280_/Q wire99/X vddd vssd sg13cmos5l_a221oi_1
XFILLER_23_1410 vddd vssd sg13cmos5l_decap_8
XFILLER_23_1443 vddd vssd sg13cmos5l_decap_8
XFILLER_7_1695 vddd vssd sg13cmos5l_decap_8
XFILLER_24_917 vddd vssd sg13cmos5l_decap_8
X_6821_ _6821_/Y _6908_/A _6908_/B_N vddd vssd sg13cmos5l_nor2b_1
XFILLER_32_961 vddd vssd sg13cmos5l_decap_8
X_6752_ _6752_/Y _3530_/Y _6753_/B _6751_/Y vddd vssd sg13cmos5l_a21oi_1
X_3964_ _3964_/Y _7151_/Q _6399_/A _4053_/B vddd vssd sg13cmos5l_a21oi_1
Xoutbuffers\[2\] analog_bus_ena[0] _7030_/Q vddd vssd sg13cmos5l_buf_16
X_6683_ _6690_/S _6683_/A _6733_/B vddd vssd sg13cmos5l_nor2_1
X_5703_ _5703_/Y _5703_/A _5703_/B _5703_/C vddd vssd sg13cmos5l_nor3_1
X_3895_ _3895_/X _3896_/A _3896_/B vddd vssd sg13cmos5l_and2_1
XFILLER_30_2115 vddd vssd sg13cmos5l_decap_4
X_5634_ _5634_/Y _5916_/A1 _5605_/Y _5633_/Y vddd vssd sg13cmos5l_a21oi_1
XFILLER_12_28 vddd vssd sg13cmos5l_decap_8
X_5565_ _5568_/A _7176_/Q _7177_/Q _5567_/C vddd vssd sg13cmos5l_nor3_1
X_7304_ _7304_/Q _7307_/CLK _7304_/D _6817_/Y vddd vssd sg13cmos5l_dfrbpq_1
XFILLER_12_2582 vddd vssd sg13cmos5l_decap_8
XFILLER_28_2011 vddd vssd sg13cmos5l_decap_8
X_4516_ _4517_/B _4430_/B _3611_/Y _4794_/B1 _4510_/B vddd vssd sg13cmos5l_a22oi_1
XFILLER_2_309 vddd vssd sg13cmos5l_decap_8
X_5496_ _5496_/Y _5509_/C _5495_/Y _5511_/A vddd vssd sg13cmos5l_o21ai_1
X_7235_ _7235_/Q _7295_/CLK _7235_/D _6829_/B_N vddd vssd sg13cmos5l_dfrbpq_1
X_4447_ _4448_/B _4712_/A _4689_/B vddd vssd sg13cmos5l_nand2_1
X_7166_ _7166_/Q _7206_/CLK _7166_/D fanout368/X vddd vssd sg13cmos5l_dfrbpq_1
XFILLER_28_1365 vddd vssd sg13cmos5l_decap_4
XFILLER_24_1218 vddd vssd sg13cmos5l_decap_8
X_4378_ _4379_/D _7333_/Q _7121_/Q vddd vssd sg13cmos5l_xor2_1
X_6117_ _6117_/Y _3904_/X _5186_/B _5189_/A vddd vssd sg13cmos5l_o21ai_1
XFILLER_28_1398 vddd vssd sg13cmos5l_decap_4
X_7097_ _7097_/Q _7100_/CLK _7097_/D fanout412/X vddd vssd sg13cmos5l_dfrbpq_1
X_6048_ _6049_/C _6048_/A _6048_/B vddd vssd sg13cmos5l_nor2_1
XFILLER_26_210 vddd vssd sg13cmos5l_decap_8
XFILLER_6_1194 vddd vssd sg13cmos5l_decap_8
XFILLER_14_427 vddd vssd sg13cmos5l_decap_8
XFILLER_23_961 vddd vssd sg13cmos5l_decap_4
XFILLER_22_482 vddd vssd sg13cmos5l_decap_8
XFILLER_10_677 vddd vssd sg13cmos5l_decap_8
XFILLER_13_1667 vddd vssd sg13cmos5l_decap_8
XFILLER_5_114 vddd vssd sg13cmos5l_decap_8
XFILLER_11_1380 vddd vssd sg13cmos5l_decap_4
XFILLER_2_898 vddd vssd sg13cmos5l_decap_8
Xtiedowns\[38\] dbus_in_right[6] vddd vssd sg13cmos5l_antennanp
XFILLER_24_2464 vddd vssd sg13cmos5l_decap_8
XFILLER_4_2558 vddd vssd sg13cmos5l_decap_8
XFILLER_20_1616 vddd vssd sg13cmos5l_decap_8
XFILLER_27_91 vddd vssd sg13cmos5l_decap_8
XFILLER_17_287 vddd vssd sg13cmos5l_decap_8
XFILLER_32_224 vddd vssd sg13cmos5l_decap_8
XFILLER_18_2268 vddd vssd sg13cmos5l_decap_8
XFILLER_18_1512 vddd vssd sg13cmos5l_decap_8
XFILLER_18_1567 vddd vssd sg13cmos5l_decap_8
XFILLER_31_2468 vddd vssd sg13cmos5l_decap_8
X_3680_ _6667_/A _4002_/A _3929_/A _4002_/B _4002_/C vddd vssd sg13cmos5l_nor4_1
XFILLER_16_1280 vddd vssd sg13cmos5l_decap_8
XFILLER_9_464 vddd vssd sg13cmos5l_decap_4
XFILLER_31_1756 vddd vssd sg13cmos5l_decap_8
X_5350_ _5368_/A _7148_/Q _7149_/Q vddd vssd sg13cmos5l_nor2_1
X_4301_ _4301_/Y _4301_/A _4301_/B vddd vssd sg13cmos5l_xnor2_1
X_5281_ _5281_/Y _7396_/Q _3641_/Y _5285_/D _4828_/B vddd vssd sg13cmos5l_a22oi_1
X_7020_ _7020_/Q _7188_/CLK _7020_/D fanout375/X vddd vssd sg13cmos5l_dfrbpq_1
X_4232_ _4232_/Y _7044_/Q _3766_/Y _6691_/A vddd vssd sg13cmos5l_o21ai_1
XFILLER_9_1724 vddd vssd sg13cmos5l_decap_8
XFILLER_9_2458 vddd vssd sg13cmos5l_decap_8
XFILLER_4_84 vddd vssd sg13cmos5l_decap_8
X_4163_ _4163_/Y _3530_/Y _6748_/A _4161_/Y _4162_/Y vddd vssd sg13cmos5l_a22oi_1
X_4094_ _4094_/Y _7273_/Q _3868_/Y _3862_/Y vddd vssd sg13cmos5l_a21oi_1
XFILLER_23_1240 vddd vssd sg13cmos5l_decap_8
Xoutbuffers\[21\] voltgen_source[2] _7069_/Q vddd vssd sg13cmos5l_buf_16
XFILLER_24_747 vddd vssd sg13cmos5l_decap_4
X_4996_ _4997_/C _6270_/A _6262_/B _4996_/C _6278_/B vddd vssd sg13cmos5l_nand4_1
X_6804_ _6804_/Y _6806_/A _6908_/B_N vddd vssd sg13cmos5l_nor2b_1
X_6735_ _7067_/D _6735_/A1 _6739_/S hold971/X vddd vssd sg13cmos5l_a21oi_1
X_3947_ _3947_/Y _5543_/B _6443_/A _3944_/Y _3941_/Y _6435_/A vddd vssd sg13cmos5l_a221oi_1
XFILLER_32_1509 vddd vssd sg13cmos5l_decap_8
XFILLER_23_49 vddd vssd sg13cmos5l_decap_8
XFILLER_20_942 vddd vssd sg13cmos5l_decap_8
X_6666_ _6666_/X _6739_/A1 _6666_/A1 _6666_/S vddd vssd sg13cmos5l_mux2_1
X_3878_ _3878_/Y _7271_/Q _3862_/Y _3872_/Y _3873_/Y _3877_/X vddd vssd sg13cmos5l_a221oi_1
XFILLER_20_986 vddd vssd sg13cmos5l_decap_4
X_5617_ _5617_/Y _5615_/Y _5616_/Y _5628_/C vddd vssd sg13cmos5l_o21ai_1
X_6597_ _7256_/D _6333_/A _6601_/S hold954/X vddd vssd sg13cmos5l_a21oi_1
XFILLER_14_1976 vddd vssd sg13cmos5l_decap_8
X_5548_ _5550_/C _7178_/Q _7179_/Q vddd vssd sg13cmos5l_nor2_1
X_7218_ _7218_/Q _7218_/CLK _7218_/D _6825_/B_N vddd vssd sg13cmos5l_dfrbpq_1
X_5479_ _5482_/B _5903_/A _5483_/B _5480_/D vddd vssd sg13cmos5l_nor3_1
Xfanout421 _6216_/A1 io_in[9] vddd vssd sg13cmos5l_buf_1
Xfanout432 _5594_/A _3548_/A vddd vssd sg13cmos5l_buf_1
Xfanout410 _6860_/B_N fanout413/X vddd vssd sg13cmos5l_buf_1
Xfanout454 _5024_/A _6400_/A vddd vssd sg13cmos5l_buf_1
Xfanout443 _5828_/A _6239_/A1 vddd vssd sg13cmos5l_buf_1
X_7149_ _7149_/Q _7179_/CLK _7149_/D _6827_/B_N vddd vssd sg13cmos5l_dfrbpq_1
XFILLER_21_1947 vddd vssd sg13cmos5l_decap_8
XFILLER_27_585 vddd vssd sg13cmos5l_decap_4
XFILLER_19_2555 vddd vssd sg13cmos5l_decap_8
Xfanout72 _6330_/B _6320_/B vddd vssd sg13cmos5l_buf_1
XFILLER_19_1876 vddd vssd sg13cmos5l_decap_8
Xfanout83 _3852_/A _3745_/Y vddd vssd sg13cmos5l_buf_1
Xfanout94 _4067_/B1 _3695_/Y vddd vssd sg13cmos5l_buf_1
XFILLER_13_1442 vddd vssd sg13cmos5l_decap_8
XFILLER_13_1464 vddd vssd sg13cmos5l_decap_8
XFILLER_26_2504 vddd vssd sg13cmos5l_decap_8
XFILLER_29_7 vddd vssd sg13cmos5l_decap_4
XFILLER_4_1676 vddd vssd sg13cmos5l_decap_8
X_4850_ _4850_/Y _4848_/A _4839_/B _4849_/Y vddd vssd sg13cmos5l_a21oi_1
Xoutbuffers\[111\] dbus_out[14] _5714_/Y vddd vssd sg13cmos5l_buf_16
X_3801_ _3805_/A _7111_/Q _4067_/B1 _4242_/A2 _3520_/Y _3800_/Y vddd vssd sg13cmos5l_a221oi_1
X_4781_ _4782_/B _5393_/A _4781_/B vddd vssd sg13cmos5l_xnor2_1
X_6520_ _6520_/Y _6520_/A _6524_/S vddd vssd sg13cmos5l_nor2_1
X_3732_ _6773_/B _3929_/B _3863_/C vddd vssd sg13cmos5l_or2_1
X_3663_ _3750_/B _4344_/A _4343_/A _3669_/S vddd vssd sg13cmos5l_mux2_1
X_6451_ _6451_/Y _6451_/A _6457_/B vddd vssd sg13cmos5l_nand2_1
X_6382_ _6382_/Y _6393_/A _6381_/B hold679/X vddd vssd sg13cmos5l_a21oi_1
X_5402_ _5402_/Y _5428_/A _5401_/A _5401_/B vddd vssd sg13cmos5l_o21ai_1
X_5333_ _5333_/Y _3546_/Y _5339_/C _5331_/Y _5338_/C _5332_/Y vddd vssd sg13cmos5l_a221oi_1
X_3594_ _3594_/Y _7095_/Q vddd vssd sg13cmos5l_inv_1
Xoutbuffers\[69\] idac1_value[1] _7035_/Q vddd vssd sg13cmos5l_buf_16
X_5264_ _5278_/B _5264_/A _5264_/B vddd vssd sg13cmos5l_nor2_1
XFILLER_25_1324 vddd vssd sg13cmos5l_decap_8
X_7003_ _7003_/Q _7003_/CLK _7003_/D _6950_/Y vddd vssd sg13cmos5l_dfrbpq_1
X_4215_ _4215_/Y _5581_/A _6459_/A _6450_/A vddd vssd sg13cmos5l_a21oi_1
X_5195_ _5206_/A _5269_/B _5214_/B vddd vssd sg13cmos5l_nor2_1
XFILLER_9_1565 vddd vssd sg13cmos5l_decap_8
X_4146_ _4146_/Y _7057_/Q wire78/X _4085_/B vddd vssd sg13cmos5l_a21oi_1
XFILLER_9_1598 vddd vssd sg13cmos5l_decap_8
XFILLER_18_49 vddd vssd sg13cmos5l_decap_8
XFILLER_28_349 vddd vssd sg13cmos5l_decap_8
XFILLER_3_1164 vddd vssd sg13cmos5l_decap_8
X_4077_ _4077_/Y mask_rev_in[10] _4077_/B vddd vssd sg13cmos5l_nand2b_1
XFILLER_24_588 vddd vssd sg13cmos5l_decap_8
X_4979_ _4979_/X _4979_/A _6041_/B vddd vssd sg13cmos5l_or2_1
X_6718_ _6724_/S wire78/X _6725_/B vddd vssd sg13cmos5l_nand2_1
Xclkload3 clkload3/X clkload3/A vddd vssd sg13cmos5l_buf_8
XFILLER_14_2485 vddd vssd sg13cmos5l_decap_8
X_6649_ _6649_/X _6649_/A0 _6768_/A _6650_/S vddd vssd sg13cmos5l_mux2_1
XFILLER_30_1052 vddd vssd sg13cmos5l_decap_4
XFILLER_10_1604 vddd vssd sg13cmos5l_decap_8
XFILLER_4_927 vddd vssd sg13cmos5l_decap_8
Xfanout240 _4545_/A _4577_/A vddd vssd sg13cmos5l_buf_1
XFILLER_25_2592 vddd vssd sg13cmos5l_decap_8
Xfanout273 _5148_/A _7255_/Q vddd vssd sg13cmos5l_buf_1
Xfanout251 _4771_/A _4786_/A vddd vssd sg13cmos5l_buf_1
Xfanout262 _4920_/A _4914_/A vddd vssd sg13cmos5l_buf_1
XFILLER_21_2456 vddd vssd sg13cmos5l_decap_8
XFILLER_19_327 vddd vssd sg13cmos5l_decap_8
Xfanout295 _5711_/B hold1483/X vddd vssd sg13cmos5l_buf_1
XFILLER_1_2506 vddd vssd sg13cmos5l_decap_4
Xfanout284 _5910_/B _7224_/Q vddd vssd sg13cmos5l_buf_1
XFILLER_21_1733 vddd vssd sg13cmos5l_decap_8
XFILLER_21_1788 vddd vssd sg13cmos5l_decap_8
XFILLER_19_2374 vddd vssd sg13cmos5l_decap_8
XFILLER_19_2352 vddd vssd sg13cmos5l_decap_8
XFILLER_32_2552 vddd vssd sg13cmos5l_decap_8
XFILLER_24_70 vddd vssd sg13cmos5l_decap_8
XFILLER_19_1695 vddd vssd sg13cmos5l_decap_8
XFILLER_15_1559 vddd vssd sg13cmos5l_decap_8
XFILLER_32_1873 vddd vssd sg13cmos5l_decap_8
XFILLER_26_2378 vddd vssd sg13cmos5l_decap_8
XFILLER_26_1644 vddd vssd sg13cmos5l_decap_8
X_4000_ _4000_/Y _4000_/A _4173_/B vddd vssd sg13cmos5l_nand2_1
XFILLER_6_1727 vddd vssd sg13cmos5l_decap_4
XFILLER_24_2080 vddd vssd sg13cmos5l_decap_4
XFILLER_0_2027 vddd vssd sg13cmos5l_decap_8
XFILLER_4_2185 vddd vssd sg13cmos5l_decap_8
X_5951_ _5952_/B _5954_/A _5951_/B vddd vssd sg13cmos5l_nor2_1
XFILLER_20_1254 vddd vssd sg13cmos5l_decap_8
XFILLER_1_85 vddd vssd sg13cmos5l_decap_8
XFILLER_0_1337 vddd vssd sg13cmos5l_decap_8
X_4902_ _4934_/B _4899_/Y _4901_/Y _4889_/B vddd vssd sg13cmos5l_a21o_1
X_5882_ _5882_/X _5882_/A _5882_/B vddd vssd sg13cmos5l_and2_1
XFILLER_21_514 vddd vssd sg13cmos5l_decap_4
X_4833_ _4833_/X _4835_/A _4833_/B vddd vssd sg13cmos5l_xor2_1
XFILLER_18_1172 vddd vssd sg13cmos5l_decap_4
X_4764_ _4764_/Y _4628_/A _4751_/Y _4511_/Y vddd vssd sg13cmos5l_o21ai_1
X_3715_ _3919_/B _3717_/A _3728_/B vddd vssd sg13cmos5l_nand2_1
X_6503_ _6509_/S _6503_/A _6660_/B vddd vssd sg13cmos5l_nand2_1
X_6434_ _6434_/X _6465_/A _6434_/A1 _6434_/S vddd vssd sg13cmos5l_mux2_1
X_4695_ _4696_/B _4740_/B _3603_/Y _4694_/Y vddd vssd sg13cmos5l_a21oi_1
XFILLER_20_28 vddd vssd sg13cmos5l_decap_8
X_3646_ _4837_/B _3647_/B _4841_/A vddd vssd sg13cmos5l_nor2_1
X_6365_ _7131_/D _6393_/A _6370_/B hold702/X vddd vssd sg13cmos5l_o21ai_1
X_3577_ _3577_/Y _3577_/A vddd vssd sg13cmos5l_inv_1
X_6296_ _6297_/A _7074_/Q _7075_/Q _7076_/Q vddd vssd sg13cmos5l_a21oi_1
X_5316_ _5316_/Y _5316_/A _7143_/Q _5316_/C vddd vssd sg13cmos5l_nor3_1
XFILLER_9_2041 vddd vssd sg13cmos5l_decap_8
X_5247_ _5252_/A _7293_/Q _5247_/B _5247_/C vddd vssd sg13cmos5l_nor3_1
XFILLER_0_429 vddd vssd sg13cmos5l_decap_8
XFILLER_29_37 vddd vssd sg13cmos5l_decap_8
XFILLER_9_2096 vddd vssd sg13cmos5l_decap_8
XFILLER_28_113 vddd vssd sg13cmos5l_decap_8
XFILLER_25_1165 vddd vssd sg13cmos5l_decap_8
XFILLER_5_1226 vddd vssd sg13cmos5l_decap_8
X_5178_ _6122_/B _5257_/B _5214_/B vddd vssd sg13cmos5l_or2_1
X_4129_ _4129_/Y _7185_/Q _3934_/Y _3937_/Y vddd vssd sg13cmos5l_o21ai_1
XFILLER_16_2525 vddd vssd sg13cmos5l_decap_8
XFILLER_8_518 vddd vssd sg13cmos5l_decap_8
XFILLER_32_1136 vddd vssd sg13cmos5l_decap_8
XFILLER_10_1401 vddd vssd sg13cmos5l_decap_8
XFILLER_4_735 vddd vssd sg13cmos5l_decap_8
XFILLER_10_2168 vddd vssd sg13cmos5l_decap_8
XFILLER_10_72 vddd vssd sg13cmos5l_decap_8
Xclkbuf_leaf_24_SCK_regs _7259_/CLK clkload8/A vddd vssd sg13cmos5l_buf_8
XFILLER_0_930 vddd vssd sg13cmos5l_decap_8
Xtiedowns\[20\] dbus_in_left[0] vddd vssd sg13cmos5l_antennanp
XFILLER_19_70 vddd vssd sg13cmos5l_decap_8
XFILLER_5_1760 vddd vssd sg13cmos5l_decap_8
XFILLER_19_179 vddd vssd sg13cmos5l_decap_4
XFILLER_28_691 vddd vssd sg13cmos5l_decap_8
XFILLER_16_831 vddd vssd sg13cmos5l_decap_4
XFILLER_15_2024 vddd vssd sg13cmos5l_decap_4
XFILLER_19_1470 vddd vssd sg13cmos5l_decap_8
XFILLER_30_388 vddd vssd sg13cmos5l_decap_4
X_3500_ _6063_/A _7333_/Q vddd vssd sg13cmos5l_inv_1
XFILLER_11_1209 vddd vssd sg13cmos5l_decap_4
Xhold507 _7014_/D _3461_/Y vddd vssd sg13cmos5l_dlygate4sd3_1
X_4480_ _4481_/B _4480_/A _7013_/D vddd vssd sg13cmos5l_xnor2_1
Xhold518 _4751_/B _6980_/Q vddd vssd sg13cmos5l_dlygate4sd3_1
Xhold529 _6988_/D _3473_/Y vddd vssd sg13cmos5l_dlygate4sd3_1
XFILLER_28_1706 vddd vssd sg13cmos5l_decap_4
X_6150_ _6152_/B _6243_/A _6150_/B _6150_/C _6151_/B vddd vssd sg13cmos5l_or4_1
XFILLER_26_2142 vddd vssd sg13cmos5l_decap_4
XFILLER_6_2214 vddd vssd sg13cmos5l_decap_8
X_5101_ _5102_/C _5136_/B _5271_/B vddd vssd sg13cmos5l_nand2_1
Xhold1207 _7271_/D _6621_/X vddd vssd sg13cmos5l_dlygate4sd3_1
XFILLER_6_2258 vddd vssd sg13cmos5l_decap_8
X_6081_ _6081_/Y _6122_/A _6080_/A _6080_/Y vddd vssd sg13cmos5l_o21ai_1
Xhold1229 _6729_/A1 _7063_/Q vddd vssd sg13cmos5l_dlygate4sd3_1
Xhold1218 _4976_/D _4971_/Y vddd vssd sg13cmos5l_dlygate4sd3_1
X_5032_ sram_write _7382_/Q _5032_/B vddd vssd sg13cmos5l_and2_1
XFILLER_18_0 vddd vssd sg13cmos5l_decap_8
X_6983_ _6983_/Q _7016_/CLK _6983_/D _6930_/Y vddd vssd sg13cmos5l_dfrbpq_1
XFILLER_25_149 vddd vssd sg13cmos5l_decap_8
XFILLER_19_691 vddd vssd sg13cmos5l_decap_8
X_5934_ _5934_/Y _5935_/B hold929/X _5933_/Y vddd vssd sg13cmos5l_a21oi_1
XFILLER_15_28 vddd vssd sg13cmos5l_decap_8
X_5865_ _5866_/B _5865_/A _5865_/B vddd vssd sg13cmos5l_nor2_1
X_4816_ _4818_/B _4815_/B _3597_/Y _4815_/Y vddd vssd sg13cmos5l_a21oi_1
XFILLER_31_16 vddd vssd sg13cmos5l_decap_8
Xtiedowns\[4\] sram_odata[4] vddd vssd sg13cmos5l_antennanp
X_5796_ _5798_/A _5882_/A _5793_/Y _5795_/Y vddd vssd sg13cmos5l_a21oi_1
XFILLER_15_2591 vddd vssd sg13cmos5l_decap_8
X_4747_ _4747_/Y _4511_/A _4746_/Y _4769_/A1 vddd vssd sg13cmos5l_a21oi_1
XFILLER_11_2477 vddd vssd sg13cmos5l_decap_8
X_4678_ _4681_/B _4774_/B _4678_/B vddd vssd sg13cmos5l_nor2_1
X_3629_ _3629_/Y mask_rev_in[14] vddd vssd sg13cmos5l_inv_1
X_6417_ _6417_/Y _6417_/A1 _6418_/B _6416_/Y vddd vssd sg13cmos5l_a21oi_1
X_7397_ _7397_/Q _7398_/CLK _7397_/D _6909_/Y vddd vssd sg13cmos5l_dfrbpq_1
X_6348_ _6348_/Y _6330_/A _6347_/B hold646/X vddd vssd sg13cmos5l_o21ai_1
X_6279_ _6279_/Y _6279_/A _6279_/B vddd vssd sg13cmos5l_nor2_1
XFILLER_5_1001 vddd vssd sg13cmos5l_decap_8
XFILLER_5_1023 vddd vssd sg13cmos5l_decap_8
XFILLER_9_1192 vddd vssd sg13cmos5l_decap_8
XFILLER_29_433 vddd vssd sg13cmos5l_decap_8
XFILLER_22_2595 vddd vssd sg13cmos5l_decap_8
XFILLER_22_1861 vddd vssd sg13cmos5l_decap_8
XFILLER_5_1089 vddd vssd sg13cmos5l_decap_8
XFILLER_2_1999 vddd vssd sg13cmos5l_decap_4
XFILLER_25_694 vddd vssd sg13cmos5l_decap_8
XFILLER_16_2311 vddd vssd sg13cmos5l_decap_8
XFILLER_24_182 vddd vssd sg13cmos5l_decap_8
XFILLER_16_1621 vddd vssd sg13cmos5l_decap_8
XFILLER_8_304 vddd vssd sg13cmos5l_decap_8
XFILLER_12_366 vddd vssd sg13cmos5l_decap_4
XFILLER_13_889 vddd vssd sg13cmos5l_decap_8
XFILLER_12_1518 vddd vssd sg13cmos5l_decap_8
Xtiedowns\[68\] mask_rev_in[24] vddd vssd sg13cmos5l_antennanp
XFILLER_7_2512 vddd vssd sg13cmos5l_decap_8
XFILLER_27_2495 vddd vssd sg13cmos5l_decap_8
XFILLER_23_2326 vddd vssd sg13cmos5l_decap_8
XFILLER_0_793 vddd vssd sg13cmos5l_decap_4
XFILLER_11_7 vddd vssd sg13cmos5l_decap_8
X_3980_ _3984_/B _3975_/Y _3976_/Y _3979_/Y vddd vssd sg13cmos5l_o21ai_1
XFILLER_16_650 vddd vssd sg13cmos5l_decap_8
X_5650_ _5653_/C _5727_/A _5651_/B _5639_/B vddd vssd sg13cmos5l_o21ai_1
Xclkbuf_0_clk clkbuf_0_clk/X clk vddd vssd sg13cmos5l_buf_8
X_4601_ _4601_/X _4601_/A _4601_/B _4601_/C vddd vssd sg13cmos5l_or3_1
XFILLER_30_185 vddd vssd sg13cmos5l_decap_8
X_5581_ _5599_/C _5581_/A _7181_/Q vddd vssd sg13cmos5l_nand2_1
X_4532_ _4532_/Y _4532_/A _4532_/B _4532_/C vddd vssd sg13cmos5l_nor3_1
XFILLER_15_1197 vddd vssd sg13cmos5l_decap_8
X_7320_ _7320_/Q _7396_/CLK _7320_/D _6833_/Y vddd vssd sg13cmos5l_dfrbpq_1
X_7251_ _7251_/Q _7252_/CLK _7251_/D fanout389/X vddd vssd sg13cmos5l_dfrbpq_1
X_4463_ _4464_/B _4776_/A _4778_/A vddd vssd sg13cmos5l_nor2b_1
XFILLER_7_84 vddd vssd sg13cmos5l_decap_4
X_6202_ _6204_/B _3819_/Y _5261_/C _6201_/Y vddd vssd sg13cmos5l_o21ai_1
X_7182_ _7182_/Q _7191_/CLK _7182_/D fanout370/X vddd vssd sg13cmos5l_dfrbpq_1
XFILLER_28_1536 vddd vssd sg13cmos5l_decap_8
X_4394_ _4394_/Y hold738/X _4393_/Y _6973_/D vddd vssd sg13cmos5l_o21ai_1
X_6133_ _6133_/Y _6194_/A _5206_/B _5204_/D vddd vssd sg13cmos5l_a21oi_1
Xoutbuffers\[51\] bandgap_trim[12] _6300_/X vddd vssd sg13cmos5l_buf_16
Xhold1004 _3568_/A _7177_/Q vddd vssd sg13cmos5l_dlygate4sd3_1
Xsram_clk_mux sram_clk sram_clk_mux/A0 clkload0/A _5996_/A vddd vssd sg13cmos5l_mux2_1
X_6064_ _6064_/Y _5393_/A _6063_/B _6063_/Y vddd vssd sg13cmos5l_a21oi_1
Xhold1015 _6585_/B1 _6584_/Y vddd vssd sg13cmos5l_dlygate4sd3_1
XFILLER_6_2044 vddd vssd sg13cmos5l_decap_8
Xhold1026 _4939_/A _4938_/Y vddd vssd sg13cmos5l_dlygate4sd3_1
X_5015_ _5216_/A _7260_/Q _7261_/Q vddd vssd sg13cmos5l_nand2_1
Xhold1037 _6558_/A1 _5963_/A vddd vssd sg13cmos5l_dlygate4sd3_1
Xhold1048 _6654_/B1 _6653_/Y vddd vssd sg13cmos5l_dlygate4sd3_1
XFILLER_27_915 vddd vssd sg13cmos5l_decap_8
Xhold1059 _7344_/D _4420_/Y vddd vssd sg13cmos5l_dlygate4sd3_1
XFILLER_26_49 vddd vssd sg13cmos5l_decap_8
X_6966_ _6966_/Q _7001_/CLK _6966_/D _6913_/Y vddd vssd sg13cmos5l_dfrbpq_1
X_5917_ _5935_/B _7080_/Q _7081_/Q vddd vssd sg13cmos5l_nand2b_1
XFILLER_22_686 vddd vssd sg13cmos5l_decap_8
XFILLER_13_2539 vddd vssd sg13cmos5l_decap_8
X_5848_ _5849_/C _5846_/X _5847_/X _5854_/C vddd vssd sg13cmos5l_a21oi_1
X_5779_ _5779_/Y _5897_/A _7208_/Q _5786_/B vddd vssd sg13cmos5l_nor3_1
XFILLER_10_848 vddd vssd sg13cmos5l_decap_8
XFILLER_11_1573 vddd vssd sg13cmos5l_decap_8
Xhold882 hold882/X hold882/A vddd vssd sg13cmos5l_dlygate4sd3_1
Xhold871 _7353_/D _4348_/Y vddd vssd sg13cmos5l_dlygate4sd3_1
Xhold860 _7096_/D _6783_/X vddd vssd sg13cmos5l_dlygate4sd3_1
Xhold893 hold893/X _6421_/Y vddd vssd sg13cmos5l_dlygate4sd3_1
XFILLER_2_2497 vddd vssd sg13cmos5l_decap_4
XFILLER_32_406 vddd vssd sg13cmos5l_decap_8
XFILLER_26_970 vddd vssd sg13cmos5l_decap_8
XFILLER_18_2439 vddd vssd sg13cmos5l_decap_8
XFILLER_18_1705 vddd vssd sg13cmos5l_decap_8
XFILLER_12_2005 vddd vssd sg13cmos5l_decap_4
XFILLER_9_646 vddd vssd sg13cmos5l_decap_8
XFILLER_32_70 vddd vssd sg13cmos5l_decap_8
XFILLER_29_2513 vddd vssd sg13cmos5l_decap_8
XFILLER_5_841 vddd vssd sg13cmos5l_decap_4
XFILLER_12_1348 vddd vssd sg13cmos5l_decap_8
XFILLER_29_1801 vddd vssd sg13cmos5l_decap_8
XFILLER_4_362 vddd vssd sg13cmos5l_decap_8
XFILLER_10_1094 vddd vssd sg13cmos5l_decap_8
XFILLER_9_1928 vddd vssd sg13cmos5l_decap_8
XFILLER_27_1591 vddd vssd sg13cmos5l_decap_4
XFILLER_23_1422 vddd vssd sg13cmos5l_decap_8
XFILLER_3_2239 vddd vssd sg13cmos5l_decap_8
XFILLER_7_1652 vddd vssd sg13cmos5l_decap_8
X_6820_ _6820_/Y _6906_/A _6820_/B_N vddd vssd sg13cmos5l_nor2b_1
XFILLER_17_1215 vddd vssd sg13cmos5l_decap_8
X_6751_ _6751_/Y _6788_/A _6753_/B vddd vssd sg13cmos5l_nor2_1
X_3963_ _6390_/A _3963_/A _3966_/B vddd vssd sg13cmos5l_nor2_1
X_6682_ _6682_/X _6682_/A0 _6330_/A _6682_/S vddd vssd sg13cmos5l_mux2_1
X_5702_ _5703_/C _5700_/X _5701_/X _5708_/C vddd vssd sg13cmos5l_a21oi_1
X_3894_ _3901_/A _3922_/A _6622_/B vddd vssd sg13cmos5l_nor2_1
XFILLER_30_2138 vddd vssd sg13cmos5l_decap_8
X_5633_ _5633_/Y _5571_/A _5631_/Y _5632_/Y _5630_/Y _5605_/Y vddd vssd sg13cmos5l_a221oi_1
X_5564_ _5564_/Y _5553_/Y _5558_/Y _5563_/Y vddd vssd sg13cmos5l_o21ai_1
XFILLER_12_2561 vddd vssd sg13cmos5l_decap_8
Xoutbuffers\[99\] dbus_out[2] _5377_/Y vddd vssd sg13cmos5l_buf_16
X_4515_ _4518_/B _4807_/A _4515_/B vddd vssd sg13cmos5l_nor2_1
X_7303_ _7303_/Q _7307_/CLK _7303_/D _6816_/Y vddd vssd sg13cmos5l_dfrbpq_1
X_5495_ _5495_/Y _7333_/Q _5495_/B vddd vssd sg13cmos5l_nor2_1
XFILLER_28_2023 vddd vssd sg13cmos5l_decap_8
X_7234_ _7234_/Q _7293_/CLK _7234_/D fanout383/X vddd vssd sg13cmos5l_dfrbpq_1
X_4446_ _4659_/B _6041_/A _4737_/A _4446_/C vddd vssd sg13cmos5l_nor3_1
XFILLER_8_2117 vddd vssd sg13cmos5l_decap_8
XFILLER_28_2067 vddd vssd sg13cmos5l_decap_8
XFILLER_28_1344 vddd vssd sg13cmos5l_decap_8
X_4377_ _4379_/C _4740_/A _7118_/Q vddd vssd sg13cmos5l_xor2_1
X_7165_ _7165_/Q _7171_/CLK _7165_/D fanout368/X vddd vssd sg13cmos5l_dfrbpq_1
X_6116_ _6116_/Y _3820_/X _5176_/Y _6115_/Y vddd vssd sg13cmos5l_o21ai_1
X_7096_ _7096_/Q _7100_/CLK _7096_/D fanout412/X vddd vssd sg13cmos5l_dfrbpq_1
XFILLER_27_701 vddd vssd sg13cmos5l_decap_8
X_6047_ _6049_/B _6047_/A _6047_/B vddd vssd sg13cmos5l_nor2_1
X_6949_ _6949_/Y _6949_/A _6949_/B_N vddd vssd sg13cmos5l_nor2b_1
XFILLER_17_2483 vddd vssd sg13cmos5l_decap_8
XFILLER_17_1760 vddd vssd sg13cmos5l_decap_4
XFILLER_13_1624 vddd vssd sg13cmos5l_decap_8
XFILLER_10_667 vddd vssd sg13cmos5l_decap_4
Xclkbuf_3_5_0_clk_regs clkbuf_3_5_0_clk_regs/X clkbuf_0_clk_regs/X vddd vssd sg13cmos5l_buf_8
XFILLER_13_1657 vddd vssd sg13cmos5l_decap_4
Xhold690 _6379_/A _7138_/Q vddd vssd sg13cmos5l_dlygate4sd3_1
XFILLER_24_2443 vddd vssd sg13cmos5l_decap_8
XFILLER_4_2526 vddd vssd sg13cmos5l_decap_8
XFILLER_8_1950 vddd vssd sg13cmos5l_decap_8
Xhold1390 _7071_/D _6739_/X vddd vssd sg13cmos5l_dlygate4sd3_1
XFILLER_27_70 vddd vssd sg13cmos5l_decap_8
XFILLER_32_203 vddd vssd sg13cmos5l_decap_8
XFILLER_17_266 vddd vssd sg13cmos5l_decap_4
XFILLER_31_2447 vddd vssd sg13cmos5l_decap_8
X_5280_ _5280_/Y _5280_/A _6241_/B _5280_/C _5280_/D vddd vssd sg13cmos5l_nand4_1
XFILLER_5_682 vddd vssd sg13cmos5l_decap_8
X_4300_ _4300_/X _4300_/A _4300_/B vddd vssd sg13cmos5l_and2_1
XFILLER_29_2387 vddd vssd sg13cmos5l_decap_8
X_4231_ _4231_/Y _7051_/Q _3787_/X wire78/X _7056_/Q _4231_/C1 vddd vssd sg13cmos5l_a221oi_1
XFILLER_4_63 vddd vssd sg13cmos5l_decap_8
XFILLER_25_1539 vddd vssd sg13cmos5l_decap_8
X_4162_ _4162_/Y _7081_/Q _3841_/Y _6748_/A vddd vssd sg13cmos5l_a21oi_1
X_4093_ _4093_/Y _4089_/Y _4091_/Y _4092_/Y vddd vssd sg13cmos5l_o21ai_1
XFILLER_24_704 vddd vssd sg13cmos5l_decap_8
XFILLER_23_1296 vddd vssd sg13cmos5l_decap_8
XFILLER_24_737 vddd vssd sg13cmos5l_decap_4
XFILLER_23_214 vddd vssd sg13cmos5l_decap_8
Xoutbuffers\[14\] proj_sel[1] _7019_/Q vddd vssd sg13cmos5l_buf_16
X_6803_ _6803_/Y _6806_/A _6908_/B_N vddd vssd sg13cmos5l_nor2b_1
X_4995_ _6278_/B _5208_/A _5265_/A vddd vssd sg13cmos5l_nand2b_1
X_6734_ _6734_/Y _6734_/A _6739_/S vddd vssd sg13cmos5l_nor2_1
XFILLER_23_28 vddd vssd sg13cmos5l_decap_8
X_3946_ _3946_/Y _3981_/B _3967_/B vddd vssd sg13cmos5l_nand2_1
XFILLER_20_921 vddd vssd sg13cmos5l_decap_8
XFILLER_17_1034 vddd vssd sg13cmos5l_decap_8
X_6665_ _6665_/X _6665_/A0 _6665_/A1 _6666_/S vddd vssd sg13cmos5l_mux2_1
X_3877_ _3877_/X _7267_/Q _4175_/B _3875_/Y vddd vssd sg13cmos5l_a21o_1
XFILLER_20_965 vddd vssd sg13cmos5l_decap_8
X_5616_ _5616_/Y _5649_/A1 _5620_/B _5614_/Y vddd vssd sg13cmos5l_o21ai_1
X_6596_ _6596_/Y _6596_/A _6601_/S vddd vssd sg13cmos5l_nor2_1
X_5547_ _5550_/B _7176_/Q _7177_/Q vddd vssd sg13cmos5l_nor2_1
XFILLER_2_107 vddd vssd sg13cmos5l_decap_8
X_5478_ _5482_/A _5483_/A _5478_/B vddd vssd sg13cmos5l_nor2_1
XFILLER_12_1690 vddd vssd sg13cmos5l_decap_8
X_7217_ _7217_/Q _7217_/CLK _7217_/D _6825_/B_N vddd vssd sg13cmos5l_dfrbpq_1
X_4429_ _4734_/A _4460_/A _4430_/B vddd vssd sg13cmos5l_nor2b_1
Xfanout400 fanout400/X fanout418/X vddd vssd sg13cmos5l_buf_1
Xfanout422 _5897_/A _6215_/A vddd vssd sg13cmos5l_buf_1
XFILLER_8_1213 vddd vssd sg13cmos5l_decap_8
Xfanout411 _6863_/B_N fanout413/X vddd vssd sg13cmos5l_buf_1
X_7148_ _7148_/Q _7355_/CLK _7148_/D _6827_/B_N vddd vssd sg13cmos5l_dfrbpq_1
Xfanout455 _6400_/A _6518_/A vddd vssd sg13cmos5l_buf_1
Xfanout433 _5732_/A _3548_/A vddd vssd sg13cmos5l_buf_1
Xfanout444 _6239_/A1 io_in[1] vddd vssd sg13cmos5l_buf_1
X_7079_ _7079_/Q _7125_/CLK _7079_/D fanout396/X vddd vssd sg13cmos5l_dfrbpq_1
XFILLER_19_2534 vddd vssd sg13cmos5l_decap_8
Xfanout40 _4745_/B1 _4806_/A1 vddd vssd sg13cmos5l_buf_1
XFILLER_13_2122 vddd vssd sg13cmos5l_decap_8
XFILLER_13_2111 vddd vssd sg13cmos5l_decap_4
Xfanout73 _3966_/B _3957_/B vddd vssd sg13cmos5l_buf_1
Xfanout51 _4053_/B _6390_/A vddd vssd sg13cmos5l_buf_1
XFILLER_22_280 vddd vssd sg13cmos5l_decap_4
Xfanout84 _4168_/B1 _3743_/Y vddd vssd sg13cmos5l_buf_1
Xfanout95 _4918_/C _4920_/C vddd vssd sg13cmos5l_buf_1
XFILLER_6_435 vddd vssd sg13cmos5l_decap_8
XFILLER_7_958 vddd vssd sg13cmos5l_decap_4
XFILLER_30_2480 vddd vssd sg13cmos5l_decap_8
Xtiedowns\[50\] mask_rev_in[6] vddd vssd sg13cmos5l_antennanp
XFILLER_2_663 vddd vssd sg13cmos5l_decap_8
XFILLER_4_1611 vddd vssd sg13cmos5l_decap_8
XFILLER_18_2077 vddd vssd sg13cmos5l_decap_8
XFILLER_18_2066 vddd vssd sg13cmos5l_decap_4
X_3800_ _3800_/Y _3529_/Y _4156_/A _3797_/Y _3799_/Y vddd vssd sg13cmos5l_a22oi_1
X_4780_ _4781_/B _4786_/A _4780_/B vddd vssd sg13cmos5l_nor2_1
Xoutbuffers\[104\] dbus_out[7] _5516_/Y vddd vssd sg13cmos5l_buf_16
X_3731_ _3921_/A _3929_/B _3863_/C vddd vssd sg13cmos5l_nor2_1
XFILLER_18_1354 vddd vssd sg13cmos5l_decap_8
XFILLER_18_1387 vddd vssd sg13cmos5l_decap_8
X_6450_ _6457_/B _6450_/A _6459_/B vddd vssd sg13cmos5l_nand2_1
XFILLER_9_295 vddd vssd sg13cmos5l_decap_8
X_3662_ _3750_/A _4336_/B _4344_/A _3669_/S vddd vssd sg13cmos5l_mux2_1
XFILLER_31_1554 vddd vssd sg13cmos5l_decap_4
X_6381_ _6381_/Y _6381_/A _6381_/B vddd vssd sg13cmos5l_nor2_1
X_3593_ _3593_/Y _3593_/A vddd vssd sg13cmos5l_inv_1
X_5401_ _5401_/X _5401_/A _5401_/B vddd vssd sg13cmos5l_and2_1
XFILLER_31_1587 vddd vssd sg13cmos5l_decap_8
X_5332_ _5332_/Y _7144_/Q _5332_/B vddd vssd sg13cmos5l_nor2_1
X_5263_ _5279_/A _5263_/A _5263_/B vddd vssd sg13cmos5l_nor2_1
X_7002_ _7002_/Q _7351_/CLK _7002_/D _6949_/Y vddd vssd sg13cmos5l_dfrbpq_1
X_4214_ _4214_/Y _4211_/Y _4212_/X _4213_/Y vddd vssd sg13cmos5l_o21ai_1
XFILLER_9_1544 vddd vssd sg13cmos5l_decap_8
X_5194_ _5205_/B _7290_/Q _5247_/B vddd vssd sg13cmos5l_nor2_1
X_4145_ _4145_/Y _7062_/Q _4145_/B vddd vssd sg13cmos5l_nor2_1
XFILLER_18_28 vddd vssd sg13cmos5l_decap_8
XFILLER_23_1060 vddd vssd sg13cmos5l_decap_8
X_4076_ _4076_/Y _4073_/Y _4074_/X _4075_/Y vddd vssd sg13cmos5l_o21ai_1
XFILLER_24_512 vddd vssd sg13cmos5l_decap_8
X_4978_ _4978_/Y _4979_/A _6041_/B vddd vssd sg13cmos5l_nor2_1
X_6717_ _6717_/X _6717_/A0 _6404_/A _6717_/S vddd vssd sg13cmos5l_mux2_1
X_3929_ _3929_/Y _3929_/A _3929_/B _3957_/B vddd vssd sg13cmos5l_nor3_1
Xclkload4 clkload4/X clkload4/A vddd vssd sg13cmos5l_buf_8
XFILLER_14_2464 vddd vssd sg13cmos5l_decap_8
X_6648_ _6648_/X _6648_/A0 _6324_/A _6650_/S vddd vssd sg13cmos5l_mux2_1
XFILLER_30_1086 vddd vssd sg13cmos5l_decap_4
X_6579_ _6579_/Y _6655_/A _6582_/S vddd vssd sg13cmos5l_nand2_1
Xfanout241 _4577_/A hold1464/X vddd vssd sg13cmos5l_buf_1
Xfanout230 _6863_/A _6845_/A vddd vssd sg13cmos5l_buf_1
XFILLER_25_2571 vddd vssd sg13cmos5l_decap_8
Xfanout252 _5329_/A _4817_/B vddd vssd sg13cmos5l_buf_1
Xfanout263 _4403_/A _6973_/D vddd vssd sg13cmos5l_buf_1
Xfanout274 _5149_/B _7254_/Q vddd vssd sg13cmos5l_buf_1
XFILLER_21_2435 vddd vssd sg13cmos5l_decap_8
XFILLER_21_1712 vddd vssd sg13cmos5l_decap_8
Xfanout285 _5887_/B hold1413/X vddd vssd sg13cmos5l_buf_1
XFILLER_5_1931 vddd vssd sg13cmos5l_decap_4
Xfanout296 _5701_/B hold1435/X vddd vssd sg13cmos5l_buf_1
XFILLER_28_851 vddd vssd sg13cmos5l_decap_8
XFILLER_32_2531 vddd vssd sg13cmos5l_decap_8
XFILLER_32_1852 vddd vssd sg13cmos5l_decap_8
XFILLER_7_755 vddd vssd sg13cmos5l_decap_8
XFILLER_26_2357 vddd vssd sg13cmos5l_decap_8
XFILLER_4_2153 vddd vssd sg13cmos5l_decap_8
XFILLER_4_1463 vddd vssd sg13cmos5l_decap_8
X_5950_ _5950_/Y _5949_/A _5950_/A2 _5949_/B vddd vssd sg13cmos5l_a21oi_1
XFILLER_20_1277 vddd vssd sg13cmos5l_decap_8
X_4901_ _4901_/Y _4901_/A _4900_/Y vddd vssd sg13cmos5l_nor2b_1
X_5881_ _5881_/Y _3548_/A _5879_/B _5879_/Y _5873_/Y _5882_/B vddd vssd sg13cmos5l_a221oi_1
X_4832_ _4832_/Y _4832_/A _4832_/B _4832_/C vddd vssd sg13cmos5l_nand3_1
X_4763_ _4765_/B _4767_/A1 _4762_/Y _4760_/Y vddd vssd sg13cmos5l_o21ai_1
X_3714_ _6615_/B _3749_/B _3869_/D vddd vssd sg13cmos5l_or2_1
X_4694_ _4694_/Y _4712_/A _4740_/B vddd vssd sg13cmos5l_nor2_1
X_6502_ _6502_/Y _6502_/A1 _6501_/B _6501_/Y vddd vssd sg13cmos5l_o21ai_1
XFILLER_14_1037 vddd vssd sg13cmos5l_decap_8
XFILLER_31_2085 vddd vssd sg13cmos5l_decap_4
X_6433_ _6433_/X _6455_/A _6433_/A1 _6434_/S vddd vssd sg13cmos5l_mux2_1
Xoutbuffers\[81\] io_oe[8] _5245_/Y vddd vssd sg13cmos5l_buf_16
X_3645_ _4841_/A _4845_/A _4845_/B vddd vssd sg13cmos5l_nand2_1
X_3576_ _5682_/A _3576_/A vddd vssd sg13cmos5l_inv_1
X_6364_ _6364_/Y _6364_/A _6370_/B vddd vssd sg13cmos5l_nand2_1
X_6295_ _6295_/X _7072_/Q _6285_/B _6294_/Y vddd vssd sg13cmos5l_a21o_1
X_5315_ _5315_/X _5626_/A _5315_/B vddd vssd sg13cmos5l_and2_1
XFILLER_0_408 vddd vssd sg13cmos5l_decap_8
XFILLER_9_2020 vddd vssd sg13cmos5l_decap_8
XFILLER_29_16 vddd vssd sg13cmos5l_decap_8
X_5246_ _5247_/C _5266_/C _5246_/B vddd vssd sg13cmos5l_nor2_1
XFILLER_29_604 vddd vssd sg13cmos5l_decap_8
X_5177_ _5186_/B _5258_/B _5221_/B vddd vssd sg13cmos5l_or2_1
X_4128_ _4128_/Y _5651_/A _4212_/A2 _4126_/Y _4127_/Y _6467_/A vddd vssd sg13cmos5l_a221oi_1
XFILLER_28_169 vddd vssd sg13cmos5l_decap_8
X_4059_ _4059_/Y _6287_/A _4085_/B _4057_/Y _4058_/Y _4231_/C1 vddd vssd sg13cmos5l_a221oi_1
XFILLER_0_2584 vddd vssd sg13cmos5l_decap_8
XFILLER_16_2504 vddd vssd sg13cmos5l_decap_8
XFILLER_32_1115 vddd vssd sg13cmos5l_decap_8
XFILLER_27_2600 vddd vssd sg13cmos5l_decap_8
XFILLER_10_51 vddd vssd sg13cmos5l_decap_8
Xclkbuf_regs_0_clk clkbuf_regs_0_clk/X clk vddd vssd sg13cmos5l_buf_8
XFILLER_27_1976 vddd vssd sg13cmos5l_decap_8
XFILLER_19_114 vddd vssd sg13cmos5l_decap_8
XFILLER_21_1542 vddd vssd sg13cmos5l_decap_8
Xtiedowns\[13\] _6231_/A1 vddd vssd sg13cmos5l_antennanp
XFILLER_19_2161 vddd vssd sg13cmos5l_decap_8
XFILLER_16_898 vddd vssd sg13cmos5l_decap_8
XFILLER_15_2003 vddd vssd sg13cmos5l_decap_4
XFILLER_15_2047 vddd vssd sg13cmos5l_decap_8
XFILLER_15_1302 vddd vssd sg13cmos5l_decap_4
XFILLER_15_1379 vddd vssd sg13cmos5l_decap_8
Xhold508 _4533_/B _6990_/Q vddd vssd sg13cmos5l_dlygate4sd3_1
Xhold519 _6981_/D _3478_/Y vddd vssd sg13cmos5l_dlygate4sd3_1
X_5100_ _5271_/B _7244_/Q _5200_/B vddd vssd sg13cmos5l_nor2_1
X_6080_ _6080_/Y _6080_/A _6080_/B _6080_/C vddd vssd sg13cmos5l_nand3_1
X_5031_ sram_idata[7] _6330_/A _5031_/B vddd vssd sg13cmos5l_and2_1
Xhold1208 _4712_/A _7332_/Q vddd vssd sg13cmos5l_dlygate4sd3_1
Xhold1219 _7297_/D _4975_/Y vddd vssd sg13cmos5l_dlygate4sd3_1
XFILLER_22_1339 vddd vssd sg13cmos5l_decap_8
XFILLER_4_1271 vddd vssd sg13cmos5l_decap_4
X_6982_ _6982_/Q _7012_/CLK _6982_/D _6929_/Y vddd vssd sg13cmos5l_dfrbpq_1
XFILLER_25_128 vddd vssd sg13cmos5l_decap_8
XFILLER_0_1124 vddd vssd sg13cmos5l_decap_8
X_5933_ _5933_/Y _3493_/Y _5935_/B _4914_/A vddd vssd sg13cmos5l_o21ai_1
X_5864_ _5865_/B _5637_/A _5887_/C _5887_/B vddd vssd sg13cmos5l_o21ai_1
XFILLER_21_323 vddd vssd sg13cmos5l_decap_4
X_4815_ _4815_/Y _4815_/A _4815_/B vddd vssd sg13cmos5l_nor2_1
XFILLER_15_2570 vddd vssd sg13cmos5l_decap_8
X_5795_ _5795_/Y _3548_/A _5778_/Y _5781_/Y _5792_/Y _5793_/Y vddd vssd sg13cmos5l_a221oi_1
XFILLER_11_2412 vddd vssd sg13cmos5l_decap_4
X_4746_ _4746_/Y _4767_/A1 _4741_/Y _4745_/X vddd vssd sg13cmos5l_o21ai_1
XFILLER_15_1891 vddd vssd sg13cmos5l_decap_8
XFILLER_11_2456 vddd vssd sg13cmos5l_decap_8
X_4677_ _4678_/B _4461_/Y _4664_/Y _4676_/Y vddd vssd sg13cmos5l_a21oi_1
X_3628_ _3628_/Y _3628_/A vddd vssd sg13cmos5l_inv_1
X_6416_ _6416_/Y _6455_/A _6418_/B vddd vssd sg13cmos5l_nor2_1
X_7396_ _7396_/Q _7396_/CLK _7396_/D _6908_/Y vddd vssd sg13cmos5l_dfrbpq_1
X_6347_ _6347_/Y _6347_/A _6347_/B vddd vssd sg13cmos5l_nand2_1
X_3559_ _5416_/C _3559_/A vddd vssd sg13cmos5l_inv_1
XFILLER_0_249 vddd vssd sg13cmos5l_decap_8
X_6278_ _6279_/B _6278_/A _6278_/B vddd vssd sg13cmos5l_nor2_1
X_5229_ _5243_/A _7256_/Q _7257_/Q _5273_/A vddd vssd sg13cmos5l_nor3_1
XFILLER_22_2574 vddd vssd sg13cmos5l_decap_8
XFILLER_5_1068 vddd vssd sg13cmos5l_decap_8
XFILLER_22_1873 vddd vssd sg13cmos5l_decap_8
XFILLER_24_161 vddd vssd sg13cmos5l_decap_8
XFILLER_0_1691 vddd vssd sg13cmos5l_decap_4
XFILLER_16_2367 vddd vssd sg13cmos5l_decap_8
XFILLER_10_1243 vddd vssd sg13cmos5l_decap_8
XFILLER_10_1287 vddd vssd sg13cmos5l_decap_8
XFILLER_27_2474 vddd vssd sg13cmos5l_decap_8
XFILLER_0_750 vddd vssd sg13cmos5l_decap_8
XFILLER_7_1845 vddd vssd sg13cmos5l_decap_8
XFILLER_7_2568 vddd vssd sg13cmos5l_decap_8
XFILLER_21_2095 vddd vssd sg13cmos5l_decap_8
XFILLER_30_164 vddd vssd sg13cmos5l_decap_8
X_4600_ _4601_/C _4671_/A _4599_/Y _4499_/Y vddd vssd sg13cmos5l_a21oi_1
X_5580_ _5580_/Y _5597_/A _5580_/B vddd vssd sg13cmos5l_nor2_1
X_4531_ _4532_/C _4616_/A _4530_/Y _4499_/Y vddd vssd sg13cmos5l_a21oi_1
XFILLER_7_63 vddd vssd sg13cmos5l_decap_8
XFILLER_8_883 vddd vssd sg13cmos5l_decap_8
X_4462_ _4778_/A _4771_/A _5329_/A _4815_/A vddd vssd sg13cmos5l_nor3_1
X_7250_ _7250_/Q _7252_/CLK _7250_/D fanout389/X vddd vssd sg13cmos5l_dfrbpq_1
X_6201_ _6201_/Y _6199_/Y _6200_/Y _6203_/B vddd vssd sg13cmos5l_a21oi_1
X_7181_ _7181_/Q _7187_/CLK _7181_/D fanout366/X vddd vssd sg13cmos5l_dfrbpq_1
X_4393_ _4393_/Y _4436_/A _4393_/B _4393_/C _4818_/A vddd vssd sg13cmos5l_nor4_1
XFILLER_30_0 vddd vssd sg13cmos5l_decap_8
X_6132_ _6132_/Y _6151_/A _5207_/C _6131_/Y vddd vssd sg13cmos5l_o21ai_1
XFILLER_6_2012 vddd vssd sg13cmos5l_decap_8
Xhold1005 _6454_/A1 _5557_/B vddd vssd sg13cmos5l_dlygate4sd3_1
X_6063_ _6063_/Y _6063_/A _6063_/B vddd vssd sg13cmos5l_nor2_1
XFILLER_6_1311 vddd vssd sg13cmos5l_decap_8
Xhold1016 _6616_/A _7268_/Q vddd vssd sg13cmos5l_dlygate4sd3_1
Xoutbuffers\[44\] bandgap_trim[5] _6291_/Y vddd vssd sg13cmos5l_buf_16
X_5014_ _5021_/B _5210_/A _5264_/A vddd vssd sg13cmos5l_nor2_1
Xhold1038 _5949_/A _6970_/Q vddd vssd sg13cmos5l_dlygate4sd3_1
Xhold1027 _3578_/A _7195_/Q vddd vssd sg13cmos5l_dlygate4sd3_1
Xhold1049 _6433_/A1 _7166_/Q vddd vssd sg13cmos5l_dlygate4sd3_1
XFILLER_6_1355 vddd vssd sg13cmos5l_decap_8
XFILLER_26_28 vddd vssd sg13cmos5l_decap_8
X_6965_ _6965_/Q _7351_/CLK _6965_/D _6912_/Y vddd vssd sg13cmos5l_dfrbpq_1
XFILLER_4_1090 vddd vssd sg13cmos5l_decap_8
X_5916_ _5916_/Y _5916_/A1 _5892_/Y _5915_/Y vddd vssd sg13cmos5l_a21oi_1
XFILLER_22_643 vddd vssd sg13cmos5l_decap_8
XFILLER_13_2518 vddd vssd sg13cmos5l_decap_8
X_5847_ _5847_/X _5973_/A _5854_/A vddd vssd sg13cmos5l_or2_1
XFILLER_17_1997 vddd vssd sg13cmos5l_decap_8
X_5778_ _5778_/Y _5799_/C _5793_/C vddd vssd sg13cmos5l_nor2_1
X_4729_ _4729_/Y _4729_/A _7002_/D vddd vssd sg13cmos5l_xnor2_1
XFILLER_11_1563 vddd vssd sg13cmos5l_decap_4
Xhold872 _3571_/A _7180_/Q vddd vssd sg13cmos5l_dlygate4sd3_1
X_7379_ _7379_/Q _7379_/CLK _7379_/D _6892_/Y vddd vssd sg13cmos5l_dfrbpq_1
Xhold861 hold861/X _7234_/Q vddd vssd sg13cmos5l_dlygate4sd3_1
Xhold850 _4826_/A _7391_/Q vddd vssd sg13cmos5l_dlygate4sd3_1
Xhold894 hold894/X hold894/A vddd vssd sg13cmos5l_dlygate4sd3_1
Xhold883 hold883/X _4959_/A vddd vssd sg13cmos5l_dlygate4sd3_1
XFILLER_29_253 vddd vssd sg13cmos5l_decap_8
XFILLER_24_1968 vddd vssd sg13cmos5l_decap_4
XFILLER_22_2382 vddd vssd sg13cmos5l_decap_4
XFILLER_17_404 vddd vssd sg13cmos5l_decap_4
Xclkbuf_4_15__f_clk_regs _7003_/CLK clkbuf_3_7_0_clk_regs/X vddd vssd sg13cmos5l_buf_8
XFILLER_16_2197 vddd vssd sg13cmos5l_decap_8
XFILLER_12_2028 vddd vssd sg13cmos5l_decap_8
Xtiedowns\[80\] _6919_/B_N vddd vssd sg13cmos5l_antennanp
XFILLER_29_2569 vddd vssd sg13cmos5l_decap_8
XFILLER_10_1073 vddd vssd sg13cmos5l_decap_8
XFILLER_27_1570 vddd vssd sg13cmos5l_decap_8
XFILLER_0_591 vddd vssd sg13cmos5l_decap_4
XFILLER_7_1631 vddd vssd sg13cmos5l_decap_8
X_6750_ _7077_/D _6564_/A _6753_/B _6749_/Y vddd vssd sg13cmos5l_o21ai_1
X_5701_ _5701_/X _5973_/A _5701_/B vddd vssd sg13cmos5l_or2_1
X_3962_ _3962_/Y _7155_/Q _4139_/B _3961_/Y vddd vssd sg13cmos5l_o21ai_1
X_6681_ _6681_/X _6681_/A0 _6328_/A _6681_/S vddd vssd sg13cmos5l_mux2_1
X_3893_ _3898_/C _7243_/Q _4017_/B _6563_/A _7239_/Q vddd vssd sg13cmos5l_a22oi_1
XFILLER_32_996 vddd vssd sg13cmos5l_decap_8
X_5632_ _5632_/Y _5632_/A1 _5628_/Y _5631_/Y vddd vssd sg13cmos5l_a21oi_1
X_5563_ _5563_/Y _5553_/Y _5560_/Y _5562_/X _3569_/Y vddd vssd sg13cmos5l_a22oi_1
XFILLER_12_2540 vddd vssd sg13cmos5l_decap_8
X_4514_ _4515_/B _4805_/B1 _4496_/Y _4508_/Y _4513_/Y vddd vssd sg13cmos5l_a22oi_1
X_7302_ _7302_/Q _7307_/CLK _7302_/D _6815_/Y vddd vssd sg13cmos5l_dfrbpq_1
XFILLER_8_680 vddd vssd sg13cmos5l_decap_8
XFILLER_12_1850 vddd vssd sg13cmos5l_decap_8
X_5494_ _5509_/C _7168_/Q _7169_/Q vddd vssd sg13cmos5l_nand2_1
XFILLER_12_1872 vddd vssd sg13cmos5l_decap_4
XFILLER_12_1883 vddd vssd sg13cmos5l_decap_8
X_7233_ _7233_/Q _7233_/CLK _7233_/D fanout382/X vddd vssd sg13cmos5l_dfrbpq_1
X_4445_ _4689_/B _4737_/A _4446_/C vddd vssd sg13cmos5l_nor2_1
XFILLER_28_1323 vddd vssd sg13cmos5l_decap_8
X_4376_ _4379_/B _4776_/A _7117_/Q vddd vssd sg13cmos5l_xor2_1
X_7164_ _7164_/Q _7218_/CLK _7164_/D fanout368/X vddd vssd sg13cmos5l_dfrbpq_1
X_6115_ _6115_/Y _6114_/Y _6115_/B vddd vssd sg13cmos5l_nand2b_1
X_7095_ _7095_/Q _7100_/CLK _7095_/D fanout412/X vddd vssd sg13cmos5l_dfrbpq_1
X_6046_ _6047_/B _4107_/Y _5102_/B _6048_/B vddd vssd sg13cmos5l_o21ai_1
XFILLER_27_779 vddd vssd sg13cmos5l_decap_8
XFILLER_27_746 vddd vssd sg13cmos5l_decap_8
XFILLER_15_908 vddd vssd sg13cmos5l_decap_4
X_6948_ _6948_/Y _6960_/A _6961_/B_N vddd vssd sg13cmos5l_nor2b_1
XFILLER_17_2462 vddd vssd sg13cmos5l_decap_8
X_6879_ _6879_/Y _6885_/A _6885_/B_N vddd vssd sg13cmos5l_nor2b_1
XFILLER_13_1603 vddd vssd sg13cmos5l_decap_8
XFILLER_10_646 vddd vssd sg13cmos5l_decap_8
XFILLER_6_628 vddd vssd sg13cmos5l_decap_4
XFILLER_11_2061 vddd vssd sg13cmos5l_decap_4
Xhold680 _7139_/D _6382_/Y vddd vssd sg13cmos5l_dlygate4sd3_1
XFILLER_24_2422 vddd vssd sg13cmos5l_decap_8
Xhold691 hold691/X _6379_/Y vddd vssd sg13cmos5l_dlygate4sd3_1
XFILLER_4_2505 vddd vssd sg13cmos5l_decap_8
XFILLER_24_1732 vddd vssd sg13cmos5l_decap_8
XFILLER_24_2499 vddd vssd sg13cmos5l_decap_8
XFILLER_24_1754 vddd vssd sg13cmos5l_decap_8
XFILLER_8_1995 vddd vssd sg13cmos5l_decap_8
XFILLER_2_2262 vddd vssd sg13cmos5l_decap_8
Xhold1391 hold1391/X _7189_/Q vddd vssd sg13cmos5l_dlygate4sd3_1
Xhold1380 _6403_/A1 _5363_/B vddd vssd sg13cmos5l_dlygate4sd3_1
XFILLER_18_779 vddd vssd sg13cmos5l_decap_8
XFILLER_32_259 vddd vssd sg13cmos5l_decap_8
XFILLER_31_2426 vddd vssd sg13cmos5l_decap_8
XFILLER_12_1146 vddd vssd sg13cmos5l_decap_8
XFILLER_29_2366 vddd vssd sg13cmos5l_decap_8
X_4230_ _4230_/Y _7061_/Q _4145_/B _4229_/Y vddd vssd sg13cmos5l_o21ai_1
XFILLER_4_42 vddd vssd sg13cmos5l_decap_8
XFILLER_4_171 vddd vssd sg13cmos5l_decap_4
XFILLER_9_2438 vddd vssd sg13cmos5l_decap_8
X_4161_ _4161_/Y _4157_/Y _4159_/X _4160_/Y vddd vssd sg13cmos5l_o21ai_1
XFILLER_29_1698 vddd vssd sg13cmos5l_decap_8
X_4092_ _4092_/Y _5266_/B wire99/X _3868_/Y vddd vssd sg13cmos5l_a21oi_1
XFILLER_7_1472 vddd vssd sg13cmos5l_decap_4
X_6802_ _6802_/Y _6806_/A _6908_/B_N vddd vssd sg13cmos5l_nor2b_1
X_4994_ _5265_/A _7242_/Q _7243_/Q vddd vssd sg13cmos5l_nor2b_1
X_6733_ _6739_/S _6733_/A _6733_/B vddd vssd sg13cmos5l_nor2_1
XFILLER_23_248 vddd vssd sg13cmos5l_decap_4
XFILLER_17_1013 vddd vssd sg13cmos5l_decap_8
X_3945_ _6435_/A _3945_/A _3966_/B vddd vssd sg13cmos5l_nor2_1
XFILLER_32_782 vddd vssd sg13cmos5l_decap_8
X_6664_ _6664_/X _6678_/A1 _6664_/A1 _6666_/S vddd vssd sg13cmos5l_mux2_1
X_5615_ _5615_/Y _5753_/A _5615_/B _5621_/B vddd vssd sg13cmos5l_nor3_1
X_3876_ _6602_/A _3896_/A _3876_/B vddd vssd sg13cmos5l_nand2_1
X_6595_ _6601_/S _6595_/A _6615_/C vddd vssd sg13cmos5l_nor2_1
X_5546_ _5546_/Y _5604_/A1 _5517_/Y _5545_/Y vddd vssd sg13cmos5l_a21oi_1
X_5477_ _5477_/Y _7166_/Q _5470_/Y _5476_/Y vddd vssd sg13cmos5l_o21ai_1
X_4428_ _4460_/B _4435_/A _4755_/A vddd vssd sg13cmos5l_and2_1
X_7216_ _7216_/Q _7218_/CLK _7216_/D _6825_/B_N vddd vssd sg13cmos5l_dfrbpq_1
Xfanout401 _6958_/B_N _6959_/B_N vddd vssd sg13cmos5l_buf_1
Xfanout423 _5607_/A io_in[8] vddd vssd sg13cmos5l_buf_1
Xfanout412 fanout412/X fanout413/X vddd vssd sg13cmos5l_buf_1
Xfanout445 _5527_/A _5753_/A vddd vssd sg13cmos5l_buf_1
X_7147_ _7147_/Q _7180_/CLK _7147_/D fanout361/X vddd vssd sg13cmos5l_dfrbpq_1
Xfanout456 _6518_/A _6564_/A vddd vssd sg13cmos5l_buf_1
X_4359_ _4359_/Y _4409_/A _4360_/B _4356_/Y _4357_/Y _4358_/Y vddd vssd sg13cmos5l_a221oi_1
XFILLER_8_1236 vddd vssd sg13cmos5l_decap_8
Xfanout434 _3548_/A _6231_/A1 vddd vssd sg13cmos5l_buf_1
X_7078_ _7078_/Q _7255_/CLK _7078_/D _6959_/B_N vddd vssd sg13cmos5l_dfrbpq_1
X_6029_ _6029_/Y _3768_/X _5088_/C _5074_/Y vddd vssd sg13cmos5l_a21oi_1
XFILLER_3_2560 vddd vssd sg13cmos5l_decap_8
XFILLER_19_2513 vddd vssd sg13cmos5l_decap_8
XFILLER_27_598 vddd vssd sg13cmos5l_decap_8
Xfanout30 _4859_/A2 _4832_/Y vddd vssd sg13cmos5l_buf_1
Xfanout74 _3957_/B _3919_/X vddd vssd sg13cmos5l_buf_1
Xfanout63 _6781_/S _6773_/Y vddd vssd sg13cmos5l_buf_1
Xfanout41 _4806_/A1 _4391_/Y vddd vssd sg13cmos5l_buf_1
Xfanout52 _6412_/A _3954_/Y vddd vssd sg13cmos5l_buf_1
XFILLER_13_1411 vddd vssd sg13cmos5l_decap_8
Xfanout85 _4253_/B1 _3743_/Y vddd vssd sg13cmos5l_buf_1
Xfanout96 _4920_/C _4905_/Y vddd vssd sg13cmos5l_buf_1
Xclkbuf_leaf_18_SCK_regs _7278_/CLK clkload7/A vddd vssd sg13cmos5l_buf_8
XFILLER_11_988 vddd vssd sg13cmos5l_decap_8
XFILLER_13_84 vddd vssd sg13cmos5l_decap_8
XFILLER_8_0 vddd vssd sg13cmos5l_decap_8
Xtiedowns\[43\] dbus_in_right[11] vddd vssd sg13cmos5l_antennanp
XFILLER_26_2539 vddd vssd sg13cmos5l_decap_8
XFILLER_24_1573 vddd vssd sg13cmos5l_decap_8
XFILLER_24_1595 vddd vssd sg13cmos5l_decap_8
XFILLER_2_2070 vddd vssd sg13cmos5l_decap_8
X_3730_ _3730_/Y _6773_/A _6759_/B vddd vssd sg13cmos5l_nor2_1
X_3661_ _3661_/Y _4344_/A _3669_/S vddd vssd sg13cmos5l_nand2_1
X_6380_ _6380_/Y _6400_/A _6381_/B hold691/X vddd vssd sg13cmos5l_a21oi_1
X_5400_ _5400_/Y _7154_/Q _5387_/Y _5399_/Y vddd vssd sg13cmos5l_o21ai_1
X_3592_ _3592_/Y _3592_/A vddd vssd sg13cmos5l_inv_1
X_5331_ _5331_/Y _5527_/A _5332_/B vddd vssd sg13cmos5l_nor2_1
XFILLER_5_480 vddd vssd sg13cmos5l_decap_4
X_5262_ _5262_/X _5262_/A _5262_/B vddd vssd sg13cmos5l_or2_1
X_7001_ _7001_/Q _7001_/CLK _7001_/D _6948_/Y vddd vssd sg13cmos5l_dfrbpq_1
XFILLER_9_1501 vddd vssd sg13cmos5l_decap_8
X_4213_ _4213_/Y _7184_/Q _6467_/A _6459_/A vddd vssd sg13cmos5l_a21oi_1
X_5193_ _5207_/A _5193_/A vddd vssd sg13cmos5l_inv_1
X_4144_ _4144_/Y _7141_/Q _3966_/Y _4141_/Y _4142_/Y _4143_/X vddd vssd sg13cmos5l_a221oi_1
XFILLER_28_329 vddd vssd sg13cmos5l_decap_4
X_4075_ _4075_/Y mask_rev_in[2] _3739_/Y _4077_/B vddd vssd sg13cmos5l_a21oi_1
XFILLER_23_1094 vddd vssd sg13cmos5l_decap_4
XFILLER_24_524 vddd vssd sg13cmos5l_decap_4
XFILLER_20_1993 vddd vssd sg13cmos5l_decap_8
XFILLER_12_719 vddd vssd sg13cmos5l_decap_8
X_6716_ _7054_/D _6716_/A1 _6717_/S _6715_/Y vddd vssd sg13cmos5l_o21ai_1
X_4977_ _4977_/Y _4974_/B _4977_/B vddd vssd sg13cmos5l_nand2b_1
XFILLER_32_1319 vddd vssd sg13cmos5l_decap_8
XFILLER_14_2443 vddd vssd sg13cmos5l_decap_8
X_3928_ _3928_/Y _7203_/Q _6496_/A _3925_/Y vddd vssd sg13cmos5l_o21ai_1
Xclkload5 clkload5/X clkload5/A vddd vssd sg13cmos5l_buf_8
XFILLER_20_774 vddd vssd sg13cmos5l_decap_8
XFILLER_14_1731 vddd vssd sg13cmos5l_decap_8
X_6647_ _6647_/X _6647_/A0 _6704_/A0 _6650_/S vddd vssd sg13cmos5l_mux2_1
X_3859_ _3859_/Y _3859_/A _3961_/A vddd vssd sg13cmos5l_nand2_1
X_6578_ _7244_/D _6710_/A1 _6582_/S hold975/X vddd vssd sg13cmos5l_a21oi_1
X_5529_ _5529_/Y _5527_/Y _5528_/Y _5540_/C vddd vssd sg13cmos5l_o21ai_1
XFILLER_10_1639 vddd vssd sg13cmos5l_decap_8
XFILLER_3_439 vddd vssd sg13cmos5l_decap_8
XFILLER_1_7 vddd vssd sg13cmos5l_decap_8
Xfanout220 _6959_/A _6845_/A vddd vssd sg13cmos5l_buf_1
XFILLER_25_2550 vddd vssd sg13cmos5l_decap_8
Xfanout231 _6845_/A _6829_/A vddd vssd sg13cmos5l_buf_1
Xfanout253 _4815_/A _6018_/A vddd vssd sg13cmos5l_buf_1
Xfanout242 _4599_/A _6149_/A1 vddd vssd sg13cmos5l_buf_1
Xfanout264 _6973_/D _4914_/A vddd vssd sg13cmos5l_buf_1
XFILLER_8_1044 vddd vssd sg13cmos5l_decap_8
Xfanout286 _5887_/A hold1420/X vddd vssd sg13cmos5l_buf_1
Xfanout275 _5240_/B _7253_/Q vddd vssd sg13cmos5l_buf_1
Xfanout297 _5683_/B hold1366/X vddd vssd sg13cmos5l_buf_1
XFILLER_5_1998 vddd vssd sg13cmos5l_decap_4
XFILLER_32_2510 vddd vssd sg13cmos5l_decap_8
XFILLER_32_2587 vddd vssd sg13cmos5l_decap_8
XFILLER_32_1831 vddd vssd sg13cmos5l_decap_8
XFILLER_26_2336 vddd vssd sg13cmos5l_decap_8
XFILLER_1_21 vddd vssd sg13cmos5l_decap_8
XFILLER_20_1201 vddd vssd sg13cmos5l_decap_8
XFILLER_20_1245 vddd vssd sg13cmos5l_decap_4
XFILLER_19_863 vddd vssd sg13cmos5l_decap_8
X_4900_ _4900_/Y _4900_/A _4871_/Y vddd vssd sg13cmos5l_nor2b_1
X_5880_ _5882_/B _7220_/Q _7221_/Q _5880_/C vddd vssd sg13cmos5l_nor3_1
X_4831_ _4832_/C _3652_/A _5285_/C _4841_/B vddd vssd sg13cmos5l_o21ai_1
XFILLER_21_549 vddd vssd sg13cmos5l_decap_8
X_4762_ _4762_/Y _4786_/B _3600_/Y _4761_/Y vddd vssd sg13cmos5l_a21oi_1
X_3713_ _3869_/D _3750_/B _3750_/A vddd vssd sg13cmos5l_nand2b_1
X_6501_ _6501_/Y _6501_/A _6501_/B vddd vssd sg13cmos5l_nand2_1
X_4693_ _4693_/Y _4687_/X _4688_/Y _4692_/Y _4499_/A vddd vssd sg13cmos5l_a22oi_1
XFILLER_14_1016 vddd vssd sg13cmos5l_decap_8
X_3644_ _4845_/B _4848_/A _4848_/B vddd vssd sg13cmos5l_and2_1
X_6432_ _6432_/X _6470_/A _6432_/A1 _6434_/S vddd vssd sg13cmos5l_mux2_1
X_3575_ _5654_/B _3575_/A vddd vssd sg13cmos5l_inv_1
X_6363_ _7130_/D _6400_/A _6376_/B hold696/X vddd vssd sg13cmos5l_o21ai_1
X_6294_ _6294_/Y _6294_/A _6294_/B vddd vssd sg13cmos5l_nor2_1
X_5314_ _5314_/Y _5303_/Y _5310_/Y _5312_/Y _5594_/A _5315_/B vddd vssd sg13cmos5l_a221oi_1
Xoutbuffers\[74\] io_oe[1] _5091_/Y vddd vssd sg13cmos5l_buf_16
X_5245_ _5245_/Y _5245_/A _6171_/C _5245_/C _5245_/D vddd vssd sg13cmos5l_nand4_1
XFILLER_29_1281 vddd vssd sg13cmos5l_decap_8
XFILLER_21_1009 vddd vssd sg13cmos5l_decap_8
X_5176_ _5176_/Y _5255_/B _5190_/B vddd vssd sg13cmos5l_nand2_1
XFILLER_28_148 vddd vssd sg13cmos5l_decap_8
X_4127_ _4127_/Y _5682_/A _6480_/A _4212_/A2 vddd vssd sg13cmos5l_a21oi_1
X_4058_ _4058_/Y _7058_/Q wire78/X _4085_/B vddd vssd sg13cmos5l_a21oi_1
XFILLER_0_2563 vddd vssd sg13cmos5l_decap_8
XFILLER_25_855 vddd vssd sg13cmos5l_decap_8
XFILLER_25_899 vddd vssd sg13cmos5l_decap_8
XFILLER_14_1550 vddd vssd sg13cmos5l_decap_8
XFILLER_4_715 vddd vssd sg13cmos5l_decap_4
XFILLER_10_30 vddd vssd sg13cmos5l_decap_8
XFILLER_10_1447 vddd vssd sg13cmos5l_decap_8
XFILLER_23_2509 vddd vssd sg13cmos5l_decap_8
XFILLER_27_1955 vddd vssd sg13cmos5l_decap_8
XFILLER_27_1999 vddd vssd sg13cmos5l_decap_4
XFILLER_25_1690 vddd vssd sg13cmos5l_decap_8
XFILLER_5_2474 vddd vssd sg13cmos5l_decap_8
XFILLER_5_1795 vddd vssd sg13cmos5l_decap_8
Xclkbuf_leaf_33_SCK_regs _7292_/CLK clkload5/A vddd vssd sg13cmos5l_buf_8
XFILLER_15_1325 vddd vssd sg13cmos5l_decap_8
XFILLER_32_2384 vddd vssd sg13cmos5l_decap_8
Xhold509 _6991_/D _3471_/Y vddd vssd sg13cmos5l_dlygate4sd3_1
XFILLER_13_1093 vddd vssd sg13cmos5l_decap_8
XFILLER_26_2111 vddd vssd sg13cmos5l_decap_8
XFILLER_10_1992 vddd vssd sg13cmos5l_decap_8
X_5030_ sram_idata[6] _5030_/A _5032_/B vddd vssd sg13cmos5l_and2_1
Xhold1209 _4704_/B1 _4683_/Y vddd vssd sg13cmos5l_dlygate4sd3_1
XFILLER_6_1537 vddd vssd sg13cmos5l_decap_8
X_6981_ _6981_/Q _7003_/CLK _6981_/D _6928_/Y vddd vssd sg13cmos5l_dfrbpq_1
XFILLER_25_107 vddd vssd sg13cmos5l_decap_8
XFILLER_20_1053 vddd vssd sg13cmos5l_decap_8
X_5932_ _5932_/Y _5936_/A _5935_/C vddd vssd sg13cmos5l_nand2b_1
X_5863_ _5865_/A _5897_/A _7220_/Q _7221_/Q vddd vssd sg13cmos5l_nor3_1
X_4814_ _4814_/Y _4814_/A1 _3597_/Y _4485_/Y _4813_/Y vddd vssd sg13cmos5l_a22oi_1
X_5794_ _5794_/Y _5398_/A _5789_/A _5783_/X _6233_/A vddd vssd sg13cmos5l_a22oi_1
X_4745_ _4745_/X _4446_/C _4737_/B _4745_/B1 vddd vssd sg13cmos5l_a21o_1
XFILLER_11_1723 vddd vssd sg13cmos5l_decap_8
X_4676_ _4676_/Y _4676_/A _4676_/B vddd vssd sg13cmos5l_nor2_1
X_6415_ _7157_/D _6470_/A _6415_/A1 _6418_/B vddd vssd sg13cmos5l_mux2_1
X_3627_ _3627_/Y mask_rev_in[4] vddd vssd sg13cmos5l_inv_1
X_7395_ _7395_/Q _7395_/CLK _7395_/D _6907_/Y vddd vssd sg13cmos5l_dfrbpq_1
XFILLER_11_1767 vddd vssd sg13cmos5l_decap_8
X_3558_ _5401_/A _3558_/A vddd vssd sg13cmos5l_inv_1
X_6346_ _6346_/Y _6328_/A _6332_/Y hold612/X vddd vssd sg13cmos5l_o21ai_1
X_3489_ _3489_/Y _3489_/A vddd vssd sg13cmos5l_inv_1
X_6277_ _6277_/Y _6278_/B _6277_/B _6277_/C vddd vssd sg13cmos5l_nand3_1
X_5228_ _6171_/B _5228_/A _7277_/Q _5266_/C vddd vssd sg13cmos5l_nor3_1
XFILLER_22_2553 vddd vssd sg13cmos5l_decap_8
X_5159_ _6130_/C _7283_/Q _7282_/Q vddd vssd sg13cmos5l_nor2b_1
XFILLER_25_652 vddd vssd sg13cmos5l_decap_4
XFILLER_24_140 vddd vssd sg13cmos5l_decap_8
Xclkbuf_4_14__f_clk_regs _7001_/CLK clkbuf_3_7_0_clk_regs/X vddd vssd sg13cmos5l_buf_8
XFILLER_0_1670 vddd vssd sg13cmos5l_decap_8
XFILLER_14_2092 vddd vssd sg13cmos5l_decap_8
XFILLER_4_523 vddd vssd sg13cmos5l_decap_8
XFILLER_21_84 vddd vssd sg13cmos5l_decap_8
XFILLER_4_567 vddd vssd sg13cmos5l_decap_8
XFILLER_27_2453 vddd vssd sg13cmos5l_decap_8
XFILLER_7_2547 vddd vssd sg13cmos5l_decap_8
XFILLER_23_1627 vddd vssd sg13cmos5l_decap_8
XFILLER_5_2260 vddd vssd sg13cmos5l_decap_4
Xmax_cap82 wire81/A _3755_/B vddd vssd sg13cmos5l_buf_4
XFILLER_16_696 vddd vssd sg13cmos5l_decap_8
XFILLER_30_143 vddd vssd sg13cmos5l_decap_8
XFILLER_12_891 vddd vssd sg13cmos5l_decap_8
XFILLER_15_1166 vddd vssd sg13cmos5l_decap_4
X_4530_ _4530_/Y _4530_/A _4530_/B _4530_/C vddd vssd sg13cmos5l_nand3_1
XFILLER_7_42 vddd vssd sg13cmos5l_decap_8
X_4461_ _4461_/Y _4461_/A _4734_/A _4713_/A vddd vssd sg13cmos5l_nor3_1
XFILLER_28_2228 vddd vssd sg13cmos5l_decap_8
X_7180_ _7180_/Q _7180_/CLK _7180_/D fanout366/X vddd vssd sg13cmos5l_dfrbpq_1
X_6200_ _6200_/Y _5255_/A _5255_/B _5260_/D _6138_/A vddd vssd sg13cmos5l_a22oi_1
X_6131_ _6131_/Y _5207_/C _6130_/Y _5206_/B vddd vssd sg13cmos5l_a21oi_1
X_4392_ _4392_/X _4392_/A _4392_/B _4392_/C _4392_/D vddd vssd sg13cmos5l_or4_1
Xhold1006 _6635_/A0 _7279_/Q vddd vssd sg13cmos5l_dlygate4sd3_1
XFILLER_23_0 vddd vssd sg13cmos5l_decap_8
X_6062_ _6062_/Y _5241_/A _6042_/Y _6061_/Y vddd vssd sg13cmos5l_o21ai_1
Xhold1017 _6617_/B1 _6616_/Y vddd vssd sg13cmos5l_dlygate4sd3_1
X_5013_ _5264_/A _7270_/Q _7271_/Q vddd vssd sg13cmos5l_nand2b_1
Xhold1039 _5948_/B _5947_/Y vddd vssd sg13cmos5l_dlygate4sd3_1
Xhold1028 _6488_/A1 _5669_/B vddd vssd sg13cmos5l_dlygate4sd3_1
XFILLER_6_2079 vddd vssd sg13cmos5l_decap_8
Xoutbuffers\[37\] biasgen_coarse _7053_/Q vddd vssd sg13cmos5l_buf_16
X_5915_ _5915_/Y _5828_/A _5914_/A _5914_/Y _5911_/Y _5892_/Y vddd vssd sg13cmos5l_a221oi_1
X_5846_ _5846_/X _5902_/A _5854_/B vddd vssd sg13cmos5l_or2_1
XFILLER_21_165 vddd vssd sg13cmos5l_decap_4
XFILLER_13_1807 vddd vssd sg13cmos5l_decap_8
X_5777_ _5793_/C _7211_/Q _7210_/Q vddd vssd sg13cmos5l_nand2b_1
X_4728_ _4728_/Y _4740_/A _4771_/B vddd vssd sg13cmos5l_nand2_1
X_4659_ _4659_/Y _4661_/A _4659_/B vddd vssd sg13cmos5l_nor2_1
Xhold873 hold873/X _5581_/A vddd vssd sg13cmos5l_dlygate4sd3_1
Xhold862 _7234_/D _6561_/X vddd vssd sg13cmos5l_dlygate4sd3_1
X_7378_ _7378_/Q _7378_/CLK _7378_/D _6891_/Y vddd vssd sg13cmos5l_dfrbpq_1
Xhold840 _7129_/D _6360_/X vddd vssd sg13cmos5l_dlygate4sd3_1
Xhold851 hold851/X _5285_/A vddd vssd sg13cmos5l_dlygate4sd3_1
X_6329_ _7112_/D hold926/X _6330_/B _6328_/Y vddd vssd sg13cmos5l_o21ai_1
Xhold895 hold895/X _4968_/A vddd vssd sg13cmos5l_dlygate4sd3_1
Xhold884 hold884/X _4958_/Y vddd vssd sg13cmos5l_dlygate4sd3_1
XFILLER_29_221 vddd vssd sg13cmos5l_decap_8
XFILLER_24_1925 vddd vssd sg13cmos5l_decap_8
XFILLER_0_2190 vddd vssd sg13cmos5l_decap_4
XFILLER_25_482 vddd vssd sg13cmos5l_decap_4
XFILLER_16_84 vddd vssd sg13cmos5l_decap_8
XFILLER_16_2176 vddd vssd sg13cmos5l_decap_8
XFILLER_16_1453 vddd vssd sg13cmos5l_decap_8
XFILLER_13_688 vddd vssd sg13cmos5l_decap_4
XFILLER_16_1497 vddd vssd sg13cmos5l_decap_8
XFILLER_12_1317 vddd vssd sg13cmos5l_decap_8
Xtiedowns\[73\] mask_rev_in[29] vddd vssd sg13cmos5l_antennanp
XFILLER_29_2548 vddd vssd sg13cmos5l_decap_8
XFILLER_4_397 vddd vssd sg13cmos5l_decap_8
XFILLER_23_2103 vddd vssd sg13cmos5l_decap_8
XFILLER_0_570 vddd vssd sg13cmos5l_decap_8
XFILLER_23_1457 vddd vssd sg13cmos5l_decap_8
XFILLER_17_983 vddd vssd sg13cmos5l_decap_4
X_3961_ _3961_/Y _3961_/A _3967_/B vddd vssd sg13cmos5l_nand2_1
X_5700_ _5700_/X _5902_/A _5708_/B vddd vssd sg13cmos5l_or2_1
X_6680_ _6680_/X _6680_/A0 _5029_/A _6681_/S vddd vssd sg13cmos5l_mux2_1
X_3892_ _6563_/A _6622_/A _4071_/C vddd vssd sg13cmos5l_nor2_1
X_5631_ _5631_/Y _7186_/Q _7187_/Q _5631_/C vddd vssd sg13cmos5l_nor3_1
X_5562_ _5562_/X _3545_/Y _5550_/B _5561_/Y vddd vssd sg13cmos5l_a21o_1
X_4513_ _4513_/Y _4513_/A _4652_/A vddd vssd sg13cmos5l_nor2_1
X_7301_ _7301_/Q _7307_/CLK _7301_/D _6814_/Y vddd vssd sg13cmos5l_dfrbpq_1
X_7232_ _7232_/Q _7293_/CLK _7232_/D fanout382/X vddd vssd sg13cmos5l_dfrbpq_1
X_5493_ _5511_/C _7168_/Q _7169_/Q vddd vssd sg13cmos5l_nand2b_1
XFILLER_7_191 vddd vssd sg13cmos5l_decap_8
XFILLER_12_2596 vddd vssd sg13cmos5l_decap_8
X_4444_ _4446_/C _4740_/A _4736_/B vddd vssd sg13cmos5l_nand2_1
X_4375_ _4379_/A _5329_/A _7115_/Q vddd vssd sg13cmos5l_xor2_1
X_7163_ _7163_/Q _7179_/CLK _7163_/D fanout364/X vddd vssd sg13cmos5l_dfrbpq_1
X_6114_ _6114_/Y _6138_/A _6113_/A _5176_/Y vddd vssd sg13cmos5l_o21ai_1
X_7094_ _7094_/Q _7100_/CLK _7094_/D fanout412/X vddd vssd sg13cmos5l_dfrbpq_1
X_6045_ _6047_/A _5119_/A _6043_/Y _6044_/Y vddd vssd sg13cmos5l_a21oi_1
XFILLER_6_1164 vddd vssd sg13cmos5l_decap_8
X_6947_ _6947_/Y _6963_/A _6963_/B_N vddd vssd sg13cmos5l_nor2b_1
XFILLER_17_2441 vddd vssd sg13cmos5l_decap_8
X_6878_ _6878_/Y _6885_/A _6885_/B_N vddd vssd sg13cmos5l_nor2b_1
XFILLER_10_603 vddd vssd sg13cmos5l_decap_8
X_5829_ _5829_/Y _5829_/A _5829_/B _5829_/C vddd vssd sg13cmos5l_nor3_1
XFILLER_17_1773 vddd vssd sg13cmos5l_decap_8
XFILLER_17_1784 vddd vssd sg13cmos5l_decap_8
XFILLER_6_607 vddd vssd sg13cmos5l_decap_4
XFILLER_11_1350 vddd vssd sg13cmos5l_decap_4
Xhold670 _7115_/D _6336_/Y vddd vssd sg13cmos5l_dlygate4sd3_1
Xhold681 _4828_/A _7393_/Q vddd vssd sg13cmos5l_dlygate4sd3_1
XFILLER_28_2581 vddd vssd sg13cmos5l_decap_8
XFILLER_24_2401 vddd vssd sg13cmos5l_decap_8
Xhold692 _7138_/D _6380_/Y vddd vssd sg13cmos5l_dlygate4sd3_1
XFILLER_24_1711 vddd vssd sg13cmos5l_decap_8
XFILLER_24_2478 vddd vssd sg13cmos5l_decap_8
XFILLER_20_2309 vddd vssd sg13cmos5l_decap_4
XFILLER_18_703 vddd vssd sg13cmos5l_decap_8
Xhold1370 _3558_/A _7152_/Q vddd vssd sg13cmos5l_dlygate4sd3_1
Xhold1392 _6477_/A1 _5651_/A vddd vssd sg13cmos5l_dlygate4sd3_1
XFILLER_18_758 vddd vssd sg13cmos5l_decap_8
Xhold1381 hold1381/X _7237_/Q vddd vssd sg13cmos5l_dlygate4sd3_1
XFILLER_32_238 vddd vssd sg13cmos5l_decap_8
XFILLER_25_290 vddd vssd sg13cmos5l_decap_8
XFILLER_31_2405 vddd vssd sg13cmos5l_decap_8
XFILLER_29_2345 vddd vssd sg13cmos5l_decap_8
XFILLER_4_21 vddd vssd sg13cmos5l_decap_8
XFILLER_29_1655 vddd vssd sg13cmos5l_decap_8
X_4160_ _4160_/Y _3598_/Y _3803_/B _3841_/Y vddd vssd sg13cmos5l_a21oi_1
XFILLER_4_98 vddd vssd sg13cmos5l_decap_4
XFILLER_7_2174 vddd vssd sg13cmos5l_decap_8
X_4091_ _4091_/Y _4091_/A vddd vssd sg13cmos5l_inv_1
X_6801_ _6801_/Y _6806_/A _6906_/B_N vddd vssd sg13cmos5l_nor2b_1
X_4993_ _5208_/A _7240_/Q _7241_/Q vddd vssd sg13cmos5l_nand2_1
XFILLER_32_761 vddd vssd sg13cmos5l_decap_8
X_6732_ _6732_/X _5029_/A _6732_/A1 _6732_/S vddd vssd sg13cmos5l_mux2_1
X_3944_ _3944_/Y _5552_/B _6450_/A _6443_/A vddd vssd sg13cmos5l_a21oi_1
Xoutbuffers\[0\] project_zero wire136/X vddd vssd sg13cmos5l_buf_16
X_6663_ _6663_/X _6676_/A _6663_/A1 _6666_/S vddd vssd sg13cmos5l_mux2_1
X_3875_ _3875_/Y _6622_/A _3948_/A vddd vssd sg13cmos5l_nor2_1
X_5614_ _5614_/Y _5627_/C _5613_/Y _5621_/B vddd vssd sg13cmos5l_o21ai_1
XFILLER_14_1924 vddd vssd sg13cmos5l_decap_8
X_6594_ _6594_/X hold673/X _6743_/A _6594_/S vddd vssd sg13cmos5l_mux2_1
X_5545_ _5545_/Y _5571_/A _5543_/Y _5544_/Y _5542_/Y _5517_/Y vddd vssd sg13cmos5l_a221oi_1
X_5476_ _5476_/Y _5475_/Y _5476_/B vddd vssd sg13cmos5l_nand2b_1
X_4427_ _4427_/Y _4482_/B _4427_/B vddd vssd sg13cmos5l_nor2_1
X_7215_ _7215_/Q _7217_/CLK _7215_/D _6825_/B_N vddd vssd sg13cmos5l_dfrbpq_1
Xfanout402 _6957_/B_N _6959_/B_N vddd vssd sg13cmos5l_buf_1
X_7146_ _7146_/Q _7180_/CLK _7146_/D fanout361/X vddd vssd sg13cmos5l_dfrbpq_1
Xfanout413 fanout413/X fanout417/X vddd vssd sg13cmos5l_buf_1
Xfanout424 _6215_/A io_in[8] vddd vssd sg13cmos5l_buf_1
Xfanout446 _5753_/A _6221_/A vddd vssd sg13cmos5l_buf_1
Xfanout457 _6564_/A SDI vddd vssd sg13cmos5l_buf_1
Xfanout435 _6231_/A1 io_in[5] vddd vssd sg13cmos5l_buf_1
X_4358_ _4358_/Y _4358_/A _7086_/Q vddd vssd sg13cmos5l_nor2_1
X_7077_ _7077_/Q _7125_/CLK _7077_/D fanout396/X vddd vssd sg13cmos5l_dfrbpq_1
X_4289_ _4303_/B _4308_/A _4289_/B vddd vssd sg13cmos5l_nor2_1
XFILLER_27_511 vddd vssd sg13cmos5l_decap_8
X_6028_ _6028_/Y _6241_/A _5089_/D _6027_/Y vddd vssd sg13cmos5l_a21oi_1
XFILLER_3_2594 vddd vssd sg13cmos5l_decap_8
XFILLER_30_709 vddd vssd sg13cmos5l_decap_8
XFILLER_23_750 vddd vssd sg13cmos5l_decap_4
Xfanout20 _4633_/A _4489_/X vddd vssd sg13cmos5l_buf_1
XFILLER_19_2569 vddd vssd sg13cmos5l_decap_8
XFILLER_19_1846 vddd vssd sg13cmos5l_decap_8
Xfanout42 _6745_/S _6746_/B vddd vssd sg13cmos5l_buf_1
Xfanout64 _6784_/B _6773_/Y vddd vssd sg13cmos5l_buf_1
XFILLER_10_411 vddd vssd sg13cmos5l_decap_8
Xfanout53 _6420_/A _3951_/Y vddd vssd sg13cmos5l_buf_1
Xfanout97 _4511_/A _4805_/B1 vddd vssd sg13cmos5l_buf_1
XFILLER_13_2146 vddd vssd sg13cmos5l_decap_8
Xfanout86 _4077_/B _3740_/Y vddd vssd sg13cmos5l_buf_1
Xfanout75 _3967_/B _3918_/Y vddd vssd sg13cmos5l_buf_1
XFILLER_13_63 vddd vssd sg13cmos5l_decap_8
XFILLER_13_1478 vddd vssd sg13cmos5l_decap_8
XFILLER_26_2518 vddd vssd sg13cmos5l_decap_8
XFILLER_26_1828 vddd vssd sg13cmos5l_decap_8
Xtiedowns\[36\] dbus_in_right[4] vddd vssd sg13cmos5l_antennanp
XFILLER_24_1530 vddd vssd sg13cmos5l_decap_8
XFILLER_20_2106 vddd vssd sg13cmos5l_decap_8
XFILLER_4_2325 vddd vssd sg13cmos5l_decap_8
XFILLER_8_2483 vddd vssd sg13cmos5l_decap_4
XFILLER_20_2128 vddd vssd sg13cmos5l_decap_8
XFILLER_18_1312 vddd vssd sg13cmos5l_decap_4
XFILLER_14_783 vddd vssd sg13cmos5l_decap_8
XFILLER_31_1512 vddd vssd sg13cmos5l_decap_4
X_3660_ _3660_/Y _3762_/A _4258_/B _7017_/D vddd vssd sg13cmos5l_o21ai_1
X_3591_ _3591_/Y _3591_/A vddd vssd sg13cmos5l_inv_1
X_5330_ _5330_/Y _5342_/A _5329_/Y _7146_/Q vddd vssd sg13cmos5l_o21ai_1
X_5261_ _5262_/B _6206_/S _6204_/A _5261_/C _5261_/D vddd vssd sg13cmos5l_nand4_1
XFILLER_9_2214 vddd vssd sg13cmos5l_decap_8
X_7000_ _7000_/Q _7003_/CLK _7000_/D _6947_/Y vddd vssd sg13cmos5l_dfrbpq_1
X_4212_ _4212_/X _5654_/B _4212_/A2 _6467_/A vddd vssd sg13cmos5l_a21o_1
X_5192_ _5193_/A _5272_/B _5219_/B vddd vssd sg13cmos5l_nor2_1
X_4143_ _4143_/X _7068_/Q _3817_/Y _6725_/A vddd vssd sg13cmos5l_a21o_1
XFILLER_7_1281 vddd vssd sg13cmos5l_decap_8
X_4074_ _4074_/X _7084_/Q _4073_/A _3739_/Y vddd vssd sg13cmos5l_a21o_1
XFILLER_23_1073 vddd vssd sg13cmos5l_decap_8
XFILLER_3_1178 vddd vssd sg13cmos5l_decap_8
X_6715_ _6715_/Y _6715_/A _6717_/S vddd vssd sg13cmos5l_nand2_1
X_4976_ _4977_/B _5996_/A _4976_/B _4976_/C _4976_/D vddd vssd sg13cmos5l_nand4_1
XFILLER_20_731 vddd vssd sg13cmos5l_decap_8
X_3927_ _3927_/Y _6489_/A vddd vssd sg13cmos5l_inv_1
X_6646_ _6646_/X _6646_/A0 _6544_/A _6650_/S vddd vssd sg13cmos5l_mux2_1
X_3858_ _6517_/A _3922_/A _3961_/A vddd vssd sg13cmos5l_nor2b_1
Xclkload6 clkload6/X clkload6/A vddd vssd sg13cmos5l_buf_8
X_3789_ _6138_/A dbus_in_left[5] dbus_in_right[5] vddd vssd sg13cmos5l_nor2_1
XFILLER_14_2499 vddd vssd sg13cmos5l_decap_8
X_6577_ _6577_/Y _6577_/A _6582_/S vddd vssd sg13cmos5l_nor2_1
XFILLER_10_1618 vddd vssd sg13cmos5l_decap_8
X_5528_ _5528_/Y _5649_/A1 _5540_/B _5526_/Y vddd vssd sg13cmos5l_o21ai_1
X_5459_ _5459_/Y _5428_/A _5457_/Y _5458_/Y _5456_/Y _5431_/Y vddd vssd sg13cmos5l_a221oi_1
Xfanout210 _6777_/A1 _6625_/A1 vddd vssd sg13cmos5l_buf_1
Xfanout221 _6956_/A _6845_/A vddd vssd sg13cmos5l_buf_1
Xfanout232 _6829_/A _7364_/Q vddd vssd sg13cmos5l_buf_1
Xfanout243 _6149_/A1 hold1479/X vddd vssd sg13cmos5l_buf_1
Xfanout254 _6018_/A _7326_/Q vddd vssd sg13cmos5l_buf_1
X_7129_ _7129_/Q _7255_/CLK _7129_/D fanout395/X vddd vssd sg13cmos5l_dfrbpq_1
Xfanout265 _4914_/A _7296_/Q vddd vssd sg13cmos5l_buf_1
Xfanout298 _5651_/B hold1384/X vddd vssd sg13cmos5l_buf_1
Xfanout287 _5854_/B _5857_/B vddd vssd sg13cmos5l_buf_1
XFILLER_8_1078 vddd vssd sg13cmos5l_decap_8
Xfanout276 _5240_/A _7252_/Q vddd vssd sg13cmos5l_buf_1
XFILLER_28_842 vddd vssd sg13cmos5l_decap_4
XFILLER_21_1747 vddd vssd sg13cmos5l_decap_8
XFILLER_15_2219 vddd vssd sg13cmos5l_decap_8
XFILLER_24_84 vddd vssd sg13cmos5l_decap_8
XFILLER_15_1518 vddd vssd sg13cmos5l_decap_8
XFILLER_32_2566 vddd vssd sg13cmos5l_decap_8
XFILLER_32_1810 vddd vssd sg13cmos5l_decap_8
XFILLER_7_713 vddd vssd sg13cmos5l_decap_4
XFILLER_32_1887 vddd vssd sg13cmos5l_decap_8
XFILLER_26_1658 vddd vssd sg13cmos5l_decap_8
XFILLER_27_7 vddd vssd sg13cmos5l_decap_8
XFILLER_4_1410 vddd vssd sg13cmos5l_decap_8
XFILLER_19_842 vddd vssd sg13cmos5l_decap_8
XFILLER_1_55 vddd vssd sg13cmos5l_decap_8
XFILLER_24_1393 vddd vssd sg13cmos5l_decap_8
XFILLER_1_99 vddd vssd sg13cmos5l_decap_8
X_4830_ _4832_/B _4890_/A _4829_/Y _4856_/A2 vddd vssd sg13cmos5l_o21ai_1
X_4761_ _4761_/Y _4776_/A _4786_/B vddd vssd sg13cmos5l_nor2_1
XFILLER_18_1186 vddd vssd sg13cmos5l_decap_4
X_6500_ _6500_/X _6500_/A0 _6553_/A _6501_/B vddd vssd sg13cmos5l_mux2_1
X_4692_ _4692_/Y _4670_/C _4687_/B _4671_/A vddd vssd sg13cmos5l_o21ai_1
X_3712_ _3712_/Y _7121_/Q _3701_/Y _3711_/Y vddd vssd sg13cmos5l_o21ai_1
X_3643_ _4848_/B _3643_/A _4855_/A _4855_/B vddd vssd sg13cmos5l_nor3_1
X_6431_ _7164_/D _6431_/A1 _6434_/S _6430_/Y vddd vssd sg13cmos5l_a21oi_1
XFILLER_11_1916 vddd vssd sg13cmos5l_decap_8
X_6362_ _6362_/Y _6362_/A _6376_/B vddd vssd sg13cmos5l_nand2_1
X_5313_ _5315_/B _7140_/Q _7141_/Q _5313_/C vddd vssd sg13cmos5l_nor3_1
X_3574_ _5615_/B _3574_/A vddd vssd sg13cmos5l_inv_1
X_6293_ _6293_/Y _3623_/Y _6290_/B _6294_/A vddd vssd sg13cmos5l_o21ai_1
Xoutbuffers\[67\] idac2_value[4] _7043_/Q vddd vssd sg13cmos5l_buf_16
X_5244_ _5245_/D _7292_/Q _6171_/B _5244_/C vddd vssd sg13cmos5l_nor3_1
XFILLER_9_1332 vddd vssd sg13cmos5l_decap_8
XFILLER_9_2055 vddd vssd sg13cmos5l_decap_8
XFILLER_29_1271 vddd vssd sg13cmos5l_decap_4
X_5175_ _6113_/A _5259_/B _5212_/B vddd vssd sg13cmos5l_or2_1
Xclkbuf_leaf_3_SCK_regs _7355_/CLK clkbuf_3_0_0_SCK_regs/X vddd vssd sg13cmos5l_buf_8
XFILLER_9_1398 vddd vssd sg13cmos5l_decap_8
X_4126_ _4126_/Y _4123_/Y _4124_/Y _4125_/Y vddd vssd sg13cmos5l_o21ai_1
XFILLER_28_127 vddd vssd sg13cmos5l_decap_8
X_4057_ _4057_/Y _7063_/Q _4145_/B _4056_/Y vddd vssd sg13cmos5l_o21ai_1
XFILLER_0_2542 vddd vssd sg13cmos5l_decap_8
XFILLER_0_1841 vddd vssd sg13cmos5l_decap_8
Xclkbuf_4_13__f_clk_regs _7016_/CLK clkbuf_3_6_0_clk_regs/X vddd vssd sg13cmos5l_buf_8
XFILLER_24_322 vddd vssd sg13cmos5l_decap_8
XFILLER_16_2539 vddd vssd sg13cmos5l_decap_8
X_4959_ _4959_/Y _4959_/A _4959_/B vddd vssd sg13cmos5l_xnor2_1
X_6629_ _6635_/S _6629_/A _6733_/B vddd vssd sg13cmos5l_nor2_1
XFILLER_10_2105 vddd vssd sg13cmos5l_decap_8
XFILLER_10_1415 vddd vssd sg13cmos5l_decap_4
XFILLER_4_749 vddd vssd sg13cmos5l_decap_8
XFILLER_10_86 vddd vssd sg13cmos5l_decap_8
XFILLER_0_977 vddd vssd sg13cmos5l_decap_4
XFILLER_19_84 vddd vssd sg13cmos5l_decap_8
XFILLER_5_1774 vddd vssd sg13cmos5l_decap_8
XFILLER_28_672 vddd vssd sg13cmos5l_decap_8
XFILLER_27_182 vddd vssd sg13cmos5l_decap_8
XFILLER_16_845 vddd vssd sg13cmos5l_decap_8
XFILLER_15_399 vddd vssd sg13cmos5l_decap_8
XFILLER_19_1484 vddd vssd sg13cmos5l_decap_8
XFILLER_32_2363 vddd vssd sg13cmos5l_decap_8
XFILLER_32_1640 vddd vssd sg13cmos5l_decap_8
XFILLER_10_1971 vddd vssd sg13cmos5l_decap_8
XFILLER_26_1499 vddd vssd sg13cmos5l_decap_8
X_6980_ _6980_/Q _7016_/CLK _6980_/D _6927_/Y vddd vssd sg13cmos5l_dfrbpq_1
X_5931_ _5931_/Y _3537_/A _3593_/Y _5929_/Y _5930_/Y vddd vssd sg13cmos5l_a22oi_1
XFILLER_20_1087 vddd vssd sg13cmos5l_decap_8
X_5862_ _5887_/C _7220_/Q _5871_/B vddd vssd sg13cmos5l_nand2_1
X_4813_ _4813_/Y _4813_/A vddd vssd sg13cmos5l_inv_1
X_5793_ _5793_/Y _7208_/Q _7209_/Q _5793_/C vddd vssd sg13cmos5l_nor3_1
X_4744_ _4744_/Y _4743_/Y _4744_/B vddd vssd sg13cmos5l_nand2b_1
X_4675_ _4676_/B _4628_/A _4674_/X _4511_/Y vddd vssd sg13cmos5l_o21ai_1
X_3626_ _3626_/Y mask_rev_in[19] vddd vssd sg13cmos5l_inv_1
X_6414_ _7156_/D _6482_/A1 _6418_/B _6414_/B1 vddd vssd sg13cmos5l_o21ai_1
X_7394_ _7394_/Q _7395_/CLK _7394_/D _6906_/Y vddd vssd sg13cmos5l_dfrbpq_1
X_6345_ _6345_/Y _6345_/A _6347_/B vddd vssd sg13cmos5l_nand2_1
X_3557_ _3557_/Y _3557_/A vddd vssd sg13cmos5l_inv_1
X_6276_ _6277_/C _6276_/A _6276_/B vddd vssd sg13cmos5l_nand2_1
X_3488_ _3488_/Y _5996_/A vddd vssd sg13cmos5l_inv_1
X_5227_ _5242_/A _5271_/A _5227_/B vddd vssd sg13cmos5l_and2_1
XFILLER_22_2532 vddd vssd sg13cmos5l_decap_8
XFILLER_9_1151 vddd vssd sg13cmos5l_decap_8
X_5158_ _5168_/C _5230_/B _5209_/B vddd vssd sg13cmos5l_and2_1
X_4109_ _4109_/Y _4105_/Y _4106_/Y _4107_/Y _3901_/A vddd vssd sg13cmos5l_a22oi_1
X_5089_ _5090_/D _5089_/A _5089_/B _5089_/C _5089_/D vddd vssd sg13cmos5l_or4_1
XFILLER_25_631 vddd vssd sg13cmos5l_decap_8
XFILLER_12_303 vddd vssd sg13cmos5l_decap_8
XFILLER_13_804 vddd vssd sg13cmos5l_decap_8
XFILLER_24_196 vddd vssd sg13cmos5l_decap_8
XFILLER_9_808 vddd vssd sg13cmos5l_decap_8
XFILLER_16_1635 vddd vssd sg13cmos5l_decap_8
XFILLER_21_63 vddd vssd sg13cmos5l_decap_8
XFILLER_4_502 vddd vssd sg13cmos5l_decap_8
XFILLER_10_1267 vddd vssd sg13cmos5l_decap_4
XFILLER_27_2432 vddd vssd sg13cmos5l_decap_8
XFILLER_7_2526 vddd vssd sg13cmos5l_decap_8
XFILLER_21_2075 vddd vssd sg13cmos5l_decap_8
XFILLER_29_981 vddd vssd sg13cmos5l_decap_8
XFILLER_21_1396 vddd vssd sg13cmos5l_decap_8
XFILLER_16_664 vddd vssd sg13cmos5l_decap_8
XFILLER_15_185 vddd vssd sg13cmos5l_decap_8
XFILLER_30_122 vddd vssd sg13cmos5l_decap_8
XFILLER_19_1281 vddd vssd sg13cmos5l_decap_8
XFILLER_15_1145 vddd vssd sg13cmos5l_decap_8
XFILLER_7_21 vddd vssd sg13cmos5l_decap_8
XFILLER_12_870 vddd vssd sg13cmos5l_decap_8
XFILLER_30_199 vddd vssd sg13cmos5l_decap_8
XFILLER_32_1481 vddd vssd sg13cmos5l_decap_8
X_4460_ _4460_/X _4460_/A _4460_/B vddd vssd sg13cmos5l_and2_1
XFILLER_28_2207 vddd vssd sg13cmos5l_decap_8
X_4391_ _4391_/Y _4392_/A _4392_/B _4392_/C _4392_/D vddd vssd sg13cmos5l_nor4_1
X_6130_ _6130_/Y _6130_/A _6130_/B _6130_/C vddd vssd sg13cmos5l_nand3_1
X_6061_ _6061_/Y _6058_/Y _6059_/Y _6060_/Y vddd vssd sg13cmos5l_o21ai_1
XFILLER_6_2058 vddd vssd sg13cmos5l_decap_8
Xhold1007 _7279_/D _6635_/X vddd vssd sg13cmos5l_dlygate4sd3_1
X_5012_ _5210_/A _7268_/Q _7269_/Q vddd vssd sg13cmos5l_nand2_1
Xhold1018 _3579_/A _7196_/Q vddd vssd sg13cmos5l_dlygate4sd3_1
Xhold1029 _7195_/D _6488_/Y vddd vssd sg13cmos5l_dlygate4sd3_1
XFILLER_16_0 vddd vssd sg13cmos5l_decap_8
X_6963_ _6963_/Y _6963_/A _6963_/B_N vddd vssd sg13cmos5l_nor2b_1
X_5914_ _5914_/Y _5914_/A _5914_/B vddd vssd sg13cmos5l_nor2_1
X_6894_ _6894_/Y _6910_/A _6910_/B_N vddd vssd sg13cmos5l_nor2b_1
XFILLER_22_612 vddd vssd sg13cmos5l_decap_8
X_5845_ _5849_/B _5857_/C _5850_/C vddd vssd sg13cmos5l_nor2_1
Xtiedowns\[2\] sram_odata[2] vddd vssd sg13cmos5l_antennanp
X_5776_ _5799_/C _5786_/B _7208_/Q vddd vssd sg13cmos5l_nand2b_1
X_4727_ _4727_/Y _4681_/A _4725_/Y _4726_/Y vddd vssd sg13cmos5l_o21ai_1
XFILLER_11_2233 vddd vssd sg13cmos5l_decap_8
X_4658_ _4658_/X _4638_/A _4488_/Y _4657_/Y vddd vssd sg13cmos5l_a21o_1
XFILLER_11_1532 vddd vssd sg13cmos5l_decap_8
Xhold830 _7358_/D _4332_/X vddd vssd sg13cmos5l_dlygate4sd3_1
X_3609_ _3609_/Y _3609_/A vddd vssd sg13cmos5l_inv_1
XFILLER_11_2299 vddd vssd sg13cmos5l_decap_4
X_4589_ _4589_/X _6149_/A1 _4811_/B _4588_/Y vddd vssd sg13cmos5l_a21o_1
X_7377_ _7377_/Q _7379_/CLK _7377_/D _6890_/Y vddd vssd sg13cmos5l_dfrbpq_1
Xhold863 _3609_/A _7110_/Q vddd vssd sg13cmos5l_dlygate4sd3_1
Xhold841 _4298_/A _7367_/Q vddd vssd sg13cmos5l_dlygate4sd3_1
Xhold852 _4894_/A _4891_/Y vddd vssd sg13cmos5l_dlygate4sd3_1
XFILLER_11_1587 vddd vssd sg13cmos5l_decap_4
X_6328_ _6328_/Y _6328_/A _6330_/B vddd vssd sg13cmos5l_nand2_1
Xhold874 hold874/X _7206_/Q vddd vssd sg13cmos5l_dlygate4sd3_1
Xhold896 _7298_/D _4969_/Y vddd vssd sg13cmos5l_dlygate4sd3_1
Xhold885 _7301_/D _4960_/Y vddd vssd sg13cmos5l_dlygate4sd3_1
X_6259_ _6259_/X _7336_/Q _6189_/B _6258_/Y vddd vssd sg13cmos5l_a21o_1
XFILLER_29_200 vddd vssd sg13cmos5l_decap_8
XFILLER_2_2445 vddd vssd sg13cmos5l_decap_4
XFILLER_17_428 vddd vssd sg13cmos5l_decap_8
X_6898__468 _7386_/CLK _7399_/CLK vddd vssd sg13cmos5l_inv_1
XFILLER_29_299 vddd vssd sg13cmos5l_decap_8
XFILLER_22_1683 vddd vssd sg13cmos5l_decap_4
XFILLER_26_984 vddd vssd sg13cmos5l_decap_8
XFILLER_18_1719 vddd vssd sg13cmos5l_decap_4
XFILLER_16_63 vddd vssd sg13cmos5l_decap_8
XFILLER_32_84 vddd vssd sg13cmos5l_decap_8
XFILLER_5_822 vddd vssd sg13cmos5l_decap_8
XFILLER_29_2527 vddd vssd sg13cmos5l_decap_8
Xtiedowns\[66\] mask_rev_in[22] vddd vssd sg13cmos5l_antennanp
XFILLER_10_1042 vddd vssd sg13cmos5l_decap_8
XFILLER_29_1815 vddd vssd sg13cmos5l_decap_8
XFILLER_4_376 vddd vssd sg13cmos5l_decap_8
XFILLER_29_1848 vddd vssd sg13cmos5l_decap_8
XFILLER_7_1600 vddd vssd sg13cmos5l_decap_8
XFILLER_23_2148 vddd vssd sg13cmos5l_decap_8
XFILLER_0_560 vddd vssd sg13cmos5l_decap_8
XFILLER_7_2389 vddd vssd sg13cmos5l_decap_8
XFILLER_7_1666 vddd vssd sg13cmos5l_decap_8
XFILLER_7_1688 vddd vssd sg13cmos5l_decap_8
X_3960_ _6399_/A _3961_/A _3967_/B vddd vssd sg13cmos5l_and2_1
XFILLER_16_494 vddd vssd sg13cmos5l_decap_8
XFILLER_16_461 vddd vssd sg13cmos5l_decap_4
X_3891_ _6569_/A _3891_/A _3896_/A vddd vssd sg13cmos5l_nand2_1
XFILLER_30_2108 vddd vssd sg13cmos5l_decap_8
X_5630_ _5630_/Y _5625_/Y _5626_/X _5629_/Y vddd vssd sg13cmos5l_o21ai_1
X_5561_ _5561_/Y _3544_/A _5571_/C _7179_/Q vddd vssd sg13cmos5l_o21ai_1
X_4512_ _4652_/A _4511_/A _4512_/B vddd vssd sg13cmos5l_nand2b_1
X_5492_ _5492_/Y _7170_/Q _5492_/B vddd vssd sg13cmos5l_nor2_1
X_7300_ _7300_/Q _7393_/CLK _7300_/D _6813_/Y vddd vssd sg13cmos5l_dfrbpq_1
XFILLER_12_2575 vddd vssd sg13cmos5l_decap_8
XFILLER_28_2004 vddd vssd sg13cmos5l_decap_8
X_7231_ _7231_/Q _7293_/CLK _7231_/D fanout382/X vddd vssd sg13cmos5l_dfrbpq_1
X_4443_ _4736_/B _4776_/A _4757_/B vddd vssd sg13cmos5l_and2_1
X_4374_ _4390_/B _4614_/A _7123_/Q vddd vssd sg13cmos5l_nand2b_1
X_7162_ _7162_/Q _7179_/CLK _7162_/D fanout364/X vddd vssd sg13cmos5l_dfrbpq_1
X_6113_ _6115_/B _6113_/A _6113_/B _6113_/C vddd vssd sg13cmos5l_nand3_1
X_7093_ _7093_/Q _7100_/CLK _7093_/D fanout412/X vddd vssd sg13cmos5l_dfrbpq_1
X_6044_ _6044_/Y _6151_/A _5119_/A _5102_/B vddd vssd sg13cmos5l_o21ai_1
XFILLER_26_203 vddd vssd sg13cmos5l_decap_8
XFILLER_6_1187 vddd vssd sg13cmos5l_decap_8
X_6946_ _6946_/Y _6960_/A _6960_/B_N vddd vssd sg13cmos5l_nor2b_1
XFILLER_23_954 vddd vssd sg13cmos5l_decap_8
X_6877_ _6877_/Y _6881_/A _6877_/B_N vddd vssd sg13cmos5l_nor2b_1
XFILLER_17_2497 vddd vssd sg13cmos5l_decap_8
X_5828_ _5829_/C _5828_/A _5828_/B _5828_/C vddd vssd sg13cmos5l_nor3_1
X_5759_ _5759_/X _5973_/A _7206_/Q vddd vssd sg13cmos5l_or2_1
XFILLER_30_1930 vddd vssd sg13cmos5l_decap_8
XFILLER_13_1638 vddd vssd sg13cmos5l_decap_4
XFILLER_5_107 vddd vssd sg13cmos5l_decap_8
XFILLER_28_2560 vddd vssd sg13cmos5l_decap_8
Xhold660 hold660/X _6786_/Y vddd vssd sg13cmos5l_dlygate4sd3_1
Xhold671 _6339_/A _7117_/Q vddd vssd sg13cmos5l_dlygate4sd3_1
Xhold693 _4287_/A _7374_/Q vddd vssd sg13cmos5l_dlygate4sd3_1
Xhold682 _5284_/A _5283_/Y vddd vssd sg13cmos5l_dlygate4sd3_1
XFILLER_24_2457 vddd vssd sg13cmos5l_decap_8
XFILLER_8_1964 vddd vssd sg13cmos5l_decap_8
Xhold1360 _3527_/A _7277_/Q vddd vssd sg13cmos5l_dlygate4sd3_1
Xhold1393 _4432_/A _6975_/Q vddd vssd sg13cmos5l_dlygate4sd3_1
Xhold1382 _6566_/A1 _5163_/B vddd vssd sg13cmos5l_dlygate4sd3_1
Xhold1371 _6408_/A1 _5401_/A vddd vssd sg13cmos5l_dlygate4sd3_1
XFILLER_27_84 vddd vssd sg13cmos5l_decap_8
XFILLER_32_217 vddd vssd sg13cmos5l_decap_8
XFILLER_26_792 vddd vssd sg13cmos5l_decap_4
XFILLER_18_1505 vddd vssd sg13cmos5l_decap_8
XFILLER_13_442 vddd vssd sg13cmos5l_decap_4
XFILLER_9_457 vddd vssd sg13cmos5l_decap_8
XFILLER_31_1749 vddd vssd sg13cmos5l_decap_8
XFILLER_12_1159 vddd vssd sg13cmos5l_decap_8
XFILLER_5_696 vddd vssd sg13cmos5l_decap_8
XFILLER_4_77 vddd vssd sg13cmos5l_decap_8
X_4090_ _4091_/A _7285_/Q _3687_/Y _6636_/A _7281_/Q wire99/X vddd vssd sg13cmos5l_a221oi_1
XFILLER_7_1496 vddd vssd sg13cmos5l_decap_8
XFILLER_24_718 vddd vssd sg13cmos5l_decap_4
X_6800_ _6800_/Y _6885_/A _6885_/B_N vddd vssd sg13cmos5l_nor2b_1
X_4992_ _4996_/C _5221_/A _5263_/A vddd vssd sg13cmos5l_or2_1
XFILLER_32_740 vddd vssd sg13cmos5l_decap_8
X_6731_ _6731_/X _5028_/A _6731_/A1 _6732_/S vddd vssd sg13cmos5l_mux2_1
X_3943_ _3943_/Y _6443_/A vddd vssd sg13cmos5l_inv_1
X_6662_ _7018_/D _6675_/A1 _6666_/S hold988/X vddd vssd sg13cmos5l_o21ai_1
X_3874_ _4175_/B _6622_/A _6609_/B vddd vssd sg13cmos5l_nor2_1
XFILLER_20_935 vddd vssd sg13cmos5l_decap_8
XFILLER_17_1048 vddd vssd sg13cmos5l_decap_4
X_5613_ _5613_/Y _7337_/Q _5620_/B vddd vssd sg13cmos5l_nor2b_1
XFILLER_20_979 vddd vssd sg13cmos5l_decap_8
X_6593_ _6593_/X hold654/X _6599_/A _6594_/S vddd vssd sg13cmos5l_mux2_1
XFILLER_12_2361 vddd vssd sg13cmos5l_decap_4
Xoutbuffers\[97\] dbus_out[0] _5323_/Y vddd vssd sg13cmos5l_buf_16
X_5544_ _5544_/Y _5632_/A1 _5540_/Y _5543_/Y vddd vssd sg13cmos5l_a21oi_1
X_5475_ _5475_/Y _5478_/B _5473_/Y _7166_/Q vddd vssd sg13cmos5l_o21ai_1
XFILLER_12_1671 vddd vssd sg13cmos5l_decap_8
X_4426_ _4461_/A _4482_/B _4427_/B vddd vssd sg13cmos5l_or2_1
X_7214_ _7214_/Q _7217_/CLK _7214_/D _6825_/B_N vddd vssd sg13cmos5l_dfrbpq_1
Xfanout403 _6959_/B_N fanout418/X vddd vssd sg13cmos5l_buf_1
Xfanout414 _6943_/B_N _6919_/B_N vddd vssd sg13cmos5l_buf_1
XFILLER_28_1122 vddd vssd sg13cmos5l_decap_8
X_7145_ _7145_/Q _7180_/CLK _7145_/D fanout361/X vddd vssd sg13cmos5l_dfrbpq_1
Xfanout425 _5649_/A1 _3546_/A vddd vssd sg13cmos5l_buf_1
XFILLER_24_1008 vddd vssd sg13cmos5l_decap_8
Xfanout447 _5899_/A _6221_/A vddd vssd sg13cmos5l_buf_1
X_4357_ _4357_/Y _4358_/A _7086_/Q _7085_/Q _3492_/Y vddd vssd sg13cmos5l_a22oi_1
XFILLER_8_1227 vddd vssd sg13cmos5l_decap_4
Xfanout436 _5674_/A io_in[4] vddd vssd sg13cmos5l_buf_1
X_7076_ _7076_/Q _7108_/CLK _7076_/D fanout399/X vddd vssd sg13cmos5l_dfrbpq_1
X_4288_ _4294_/B _4288_/A _4303_/A vddd vssd sg13cmos5l_and2_1
Xfanout458 _6910_/A _6909_/A vddd vssd sg13cmos5l_buf_1
X_6027_ _6027_/Y _4195_/Y _5088_/B _6025_/Y _6026_/Y _5089_/D vddd vssd sg13cmos5l_a221oi_1
XFILLER_19_2548 vddd vssd sg13cmos5l_decap_8
XFILLER_3_1894 vddd vssd sg13cmos5l_decap_8
X_6929_ _6929_/Y _6952_/A _6949_/B_N vddd vssd sg13cmos5l_nor2b_1
XFILLER_22_250 vddd vssd sg13cmos5l_decap_4
XFILLER_19_1869 vddd vssd sg13cmos5l_decap_8
Xfanout54 _6443_/A _3942_/Y vddd vssd sg13cmos5l_buf_1
Xfanout43 _6360_/S _6359_/S vddd vssd sg13cmos5l_buf_1
XFILLER_17_2272 vddd vssd sg13cmos5l_decap_4
Xfanout32 _4594_/A1 _4616_/A vddd vssd sg13cmos5l_buf_1
Xfanout65 _6767_/S _6759_/Y vddd vssd sg13cmos5l_buf_1
Xfanout76 _3937_/B _3918_/Y vddd vssd sg13cmos5l_buf_1
Xfanout98 _4805_/B1 _4461_/Y vddd vssd sg13cmos5l_buf_1
Xfanout87 _4252_/A _3740_/Y vddd vssd sg13cmos5l_buf_1
XFILLER_13_42 vddd vssd sg13cmos5l_decap_8
XFILLER_17_1582 vddd vssd sg13cmos5l_decap_8
XFILLER_13_1435 vddd vssd sg13cmos5l_decap_8
XFILLER_13_1457 vddd vssd sg13cmos5l_decap_8
XFILLER_30_2494 vddd vssd sg13cmos5l_decap_8
Xhold490 _4968_/A hold894/X vddd vssd sg13cmos5l_dlygate4sd3_1
XFILLER_8_2451 vddd vssd sg13cmos5l_decap_4
Xclkbuf_leaf_27_SCK_regs _7120_/CLK clkload6/A vddd vssd sg13cmos5l_buf_8
Xtiedowns\[29\] dbus_in_left[9] vddd vssd sg13cmos5l_antennanp
XFILLER_4_1658 vddd vssd sg13cmos5l_decap_8
Xhold1190 _6732_/A1 _7066_/Q vddd vssd sg13cmos5l_dlygate4sd3_1
XFILLER_20_209 vddd vssd sg13cmos5l_decap_8
X_3590_ _5871_/B _3590_/A vddd vssd sg13cmos5l_inv_1
X_5260_ _5261_/D _5260_/A _6207_/A _6203_/B _5260_/D vddd vssd sg13cmos5l_nor4_1
X_4211_ _4211_/Y _7192_/Q _3929_/Y _4209_/Y _4210_/Y _4212_/A2 vddd vssd sg13cmos5l_a221oi_1
XFILLER_25_1317 vddd vssd sg13cmos5l_decap_8
X_5191_ _6138_/B _5273_/B _5212_/B vddd vssd sg13cmos5l_nor2_1
XFILLER_25_1339 vddd vssd sg13cmos5l_decap_8
X_4142_ _4142_/Y _5332_/B _4053_/B _3966_/Y vddd vssd sg13cmos5l_a21oi_1
XFILLER_9_1558 vddd vssd sg13cmos5l_decap_8
X_4073_ _4073_/Y _4073_/A _4073_/B _4073_/C _4073_/D vddd vssd sg13cmos5l_nor4_1
Xclkbuf_3_4_0_clk_regs clkbuf_3_4_0_clk_regs/X clkbuf_0_clk_regs/X vddd vssd sg13cmos5l_buf_8
XFILLER_3_1157 vddd vssd sg13cmos5l_decap_8
Xclkbuf_4_12__f_clk_regs _7013_/CLK clkbuf_3_6_0_clk_regs/X vddd vssd sg13cmos5l_buf_8
Xoutbuffers\[12\] proj_ena _7023_/Q vddd vssd sg13cmos5l_buf_16
X_4975_ _4975_/Y _4975_/A _4975_/B vddd vssd sg13cmos5l_nor2_1
X_6714_ _6714_/X _6714_/A0 _6393_/A _6717_/S vddd vssd sg13cmos5l_mux2_1
X_3926_ _6489_/A _6759_/B _3957_/B vddd vssd sg13cmos5l_nor2_1
XFILLER_20_765 vddd vssd sg13cmos5l_decap_4
XFILLER_18_1880 vddd vssd sg13cmos5l_decap_8
XFILLER_14_2478 vddd vssd sg13cmos5l_decap_8
Xclkload7 clkload7/X clkload7/A vddd vssd sg13cmos5l_buf_8
X_6645_ _6645_/X _6645_/A0 _6655_/A _6650_/S vddd vssd sg13cmos5l_mux2_1
X_3857_ _3857_/Y _3855_/Y _3856_/Y hold589/X vddd vssd sg13cmos5l_o21ai_1
X_3788_ _6708_/A _3788_/A _3842_/B vddd vssd sg13cmos5l_nand2_1
X_6576_ _6582_/S _6576_/A _6615_/C vddd vssd sg13cmos5l_nor2_1
X_5527_ _5527_/Y _5527_/A _5527_/B _5540_/A vddd vssd sg13cmos5l_nor3_1
X_5458_ _5458_/Y _5632_/A1 _5454_/Y _5457_/Y vddd vssd sg13cmos5l_a21oi_1
Xfanout222 _6952_/A _6949_/A vddd vssd sg13cmos5l_buf_1
Xfanout200 fanout200/X hold1461/X vddd vssd sg13cmos5l_buf_1
Xfanout211 _6625_/A1 _7375_/Q vddd vssd sg13cmos5l_buf_1
X_4409_ _4409_/X _4409_/A _4412_/A vddd vssd sg13cmos5l_xor2_1
X_5389_ _5389_/Y _3546_/Y _5401_/A _5388_/Y vddd vssd sg13cmos5l_o21ai_1
XFILLER_8_1002 vddd vssd sg13cmos5l_decap_4
Xfanout244 _4614_/A _6104_/A1 vddd vssd sg13cmos5l_buf_1
Xfanout255 _4614_/B _4800_/A vddd vssd sg13cmos5l_buf_1
X_7128_ _7128_/Q _7294_/CLK _7128_/D fanout389/X vddd vssd sg13cmos5l_dfrbpq_1
XFILLER_5_1901 vddd vssd sg13cmos5l_decap_4
Xfanout233 _5032_/B _5031_/B vddd vssd sg13cmos5l_buf_1
X_7059_ _7059_/Q _7069_/CLK _7059_/D fanout356/X vddd vssd sg13cmos5l_dfrbpq_1
XFILLER_25_2585 vddd vssd sg13cmos5l_decap_8
Xfanout299 _5651_/A hold1391/X vddd vssd sg13cmos5l_buf_1
XFILLER_21_2449 vddd vssd sg13cmos5l_decap_8
Xfanout266 _4979_/A hold1477/X vddd vssd sg13cmos5l_buf_1
Xfanout277 _5163_/B hold1381/X vddd vssd sg13cmos5l_buf_1
Xfanout288 _5857_/B hold1300/X vddd vssd sg13cmos5l_buf_1
XFILLER_21_1726 vddd vssd sg13cmos5l_decap_8
XFILLER_3_1691 vddd vssd sg13cmos5l_decap_4
XFILLER_15_537 vddd vssd sg13cmos5l_decap_4
XFILLER_19_1633 vddd vssd sg13cmos5l_decap_8
XFILLER_24_63 vddd vssd sg13cmos5l_decap_8
XFILLER_19_1688 vddd vssd sg13cmos5l_decap_8
XFILLER_19_1666 vddd vssd sg13cmos5l_decap_8
XFILLER_32_2545 vddd vssd sg13cmos5l_decap_8
XFILLER_32_1866 vddd vssd sg13cmos5l_decap_8
XFILLER_11_798 vddd vssd sg13cmos5l_decap_8
XFILLER_13_1287 vddd vssd sg13cmos5l_decap_4
XFILLER_3_986 vddd vssd sg13cmos5l_decap_4
XFILLER_26_1637 vddd vssd sg13cmos5l_decap_8
XFILLER_24_2073 vddd vssd sg13cmos5l_decap_8
XFILLER_1_78 vddd vssd sg13cmos5l_decap_8
XFILLER_2_1190 vddd vssd sg13cmos5l_decap_4
XFILLER_21_507 vddd vssd sg13cmos5l_decap_8
Xoutbuffers\[102\] dbus_out[5] _5460_/Y vddd vssd sg13cmos5l_buf_16
XFILLER_18_1165 vddd vssd sg13cmos5l_decap_8
XFILLER_18_1143 vddd vssd sg13cmos5l_decap_8
X_4760_ _4760_/Y _4552_/A _4756_/Y _4759_/Y vddd vssd sg13cmos5l_o21ai_1
X_4691_ _4691_/Y _4713_/A _4691_/B vddd vssd sg13cmos5l_nand2_1
X_3711_ _3711_/Y _3842_/B _3887_/B _4156_/A _7129_/Q wire62/X vddd vssd sg13cmos5l_a221oi_1
X_3642_ _4832_/A _4889_/B _5996_/A vddd vssd sg13cmos5l_nand2b_1
X_6430_ _6430_/Y _6518_/A _6434_/S vddd vssd sg13cmos5l_nor2_1
X_6361_ _6374_/B _6361_/A _6361_/B _6725_/B vddd vssd sg13cmos5l_nand3_1
X_5312_ _5312_/Y _5320_/C _5313_/C vddd vssd sg13cmos5l_nor2_1
X_3573_ _5583_/B _3573_/A vddd vssd sg13cmos5l_inv_1
XFILLER_6_791 vddd vssd sg13cmos5l_decap_8
X_6292_ _6292_/X _7072_/Q _7074_/Q _6291_/Y vddd vssd sg13cmos5l_a21o_1
XFILLER_9_2034 vddd vssd sg13cmos5l_decap_8
XFILLER_29_1250 vddd vssd sg13cmos5l_decap_8
X_5243_ _5245_/C _5243_/A _5243_/B _5243_/C _5243_/D vddd vssd sg13cmos5l_nor4_1
XFILLER_9_1311 vddd vssd sg13cmos5l_decap_8
X_5174_ _6106_/B _6023_/C _6130_/C vddd vssd sg13cmos5l_nand2_1
XFILLER_9_1355 vddd vssd sg13cmos5l_decap_4
XFILLER_25_1158 vddd vssd sg13cmos5l_decap_8
X_4125_ _4125_/Y _7197_/Q _6489_/A _6480_/A vddd vssd sg13cmos5l_a21oi_1
XFILLER_28_106 vddd vssd sg13cmos5l_decap_8
X_4056_ _4056_/Y _4054_/Y _4055_/Y _4145_/B vddd vssd sg13cmos5l_o21ai_1
XFILLER_0_2521 vddd vssd sg13cmos5l_decap_8
XFILLER_7_1090 vddd vssd sg13cmos5l_decap_8
XFILLER_20_2493 vddd vssd sg13cmos5l_decap_8
XFILLER_0_1820 vddd vssd sg13cmos5l_decap_8
XFILLER_0_2598 vddd vssd sg13cmos5l_decap_8
XFILLER_16_2518 vddd vssd sg13cmos5l_decap_8
X_4958_ _4958_/Y _4959_/A _4958_/B vddd vssd sg13cmos5l_nand2_1
XFILLER_32_1129 vddd vssd sg13cmos5l_decap_8
XFILLER_20_540 vddd vssd sg13cmos5l_decap_8
X_4889_ _4889_/X _5996_/A _4889_/B vddd vssd sg13cmos5l_and2_1
X_3909_ _3909_/Y _6226_/B _6548_/A _6540_/A vddd vssd sg13cmos5l_a21oi_1
X_6628_ _6628_/Y _6628_/A1 _6627_/B _6627_/Y vddd vssd sg13cmos5l_o21ai_1
X_6559_ _6559_/Y _6632_/A _6562_/S vddd vssd sg13cmos5l_nor2_1
XFILLER_0_923 vddd vssd sg13cmos5l_decap_8
XFILLER_10_65 vddd vssd sg13cmos5l_decap_8
XFILLER_19_63 vddd vssd sg13cmos5l_decap_8
XFILLER_5_1753 vddd vssd sg13cmos5l_decap_8
XFILLER_27_161 vddd vssd sg13cmos5l_decap_8
XFILLER_16_824 vddd vssd sg13cmos5l_decap_8
XFILLER_19_1463 vddd vssd sg13cmos5l_decap_8
XFILLER_15_2017 vddd vssd sg13cmos5l_decap_8
XFILLER_32_2342 vddd vssd sg13cmos5l_decap_8
XFILLER_26_2135 vddd vssd sg13cmos5l_decap_8
XFILLER_6_2207 vddd vssd sg13cmos5l_decap_8
XFILLER_26_1412 vddd vssd sg13cmos5l_decap_4
XFILLER_19_684 vddd vssd sg13cmos5l_decap_8
X_5930_ _5930_/Y _5953_/A _7097_/Q _7096_/Q _3538_/Y vddd vssd sg13cmos5l_a22oi_1
X_5861_ _5861_/Y _7220_/Q _7221_/Q _5887_/A _5887_/B vddd vssd sg13cmos5l_nor4_1
X_4812_ _4813_/A _6794_/A _4812_/B vddd vssd sg13cmos5l_xor2_1
X_5792_ _5792_/Y _5789_/A _5791_/Y _5789_/Y vddd vssd sg13cmos5l_a21oi_1
X_4743_ _4743_/Y _4628_/A _4729_/Y _4511_/Y vddd vssd sg13cmos5l_o21ai_1
XFILLER_15_2584 vddd vssd sg13cmos5l_decap_8
X_4674_ _4674_/X _4674_/A _4674_/B vddd vssd sg13cmos5l_xor2_1
X_6413_ _6413_/Y _6413_/A _6418_/B vddd vssd sg13cmos5l_nand2_1
X_3625_ _3625_/Y mask_rev_in[3] vddd vssd sg13cmos5l_inv_1
X_7393_ _7393_/Q _7393_/CLK _7393_/D _6905_/Y vddd vssd sg13cmos5l_dfrbpq_1
X_6344_ _7119_/D _6768_/A _6343_/B hold700/X vddd vssd sg13cmos5l_o21ai_1
X_3556_ _5355_/A _3556_/A vddd vssd sg13cmos5l_inv_1
X_6275_ _6277_/B _6203_/A _4996_/C _6274_/Y vddd vssd sg13cmos5l_o21ai_1
X_5226_ _5226_/Y _5226_/A _5226_/B _5226_/C vddd vssd sg13cmos5l_nand3_1
X_3487_ _3487_/Y _4315_/C vddd vssd sg13cmos5l_inv_1
XFILLER_22_2511 vddd vssd sg13cmos5l_decap_8
X_5157_ _5209_/B _7275_/Q _7274_/Q vddd vssd sg13cmos5l_nor2b_1
XFILLER_5_1016 vddd vssd sg13cmos5l_decap_8
X_4108_ _6194_/A dbus_in_left[9] dbus_in_right[9] vddd vssd sg13cmos5l_or2_1
XFILLER_26_1990 vddd vssd sg13cmos5l_decap_4
XFILLER_22_2588 vddd vssd sg13cmos5l_decap_8
X_5088_ _5091_/C _5088_/A _5088_/B _5088_/C vddd vssd sg13cmos5l_nor3_1
XFILLER_2_1926 vddd vssd sg13cmos5l_decap_4
XFILLER_22_1887 vddd vssd sg13cmos5l_decap_8
X_4039_ _4039_/Y _7190_/Q _4212_/A2 _4037_/Y _4038_/Y _6467_/A vddd vssd sg13cmos5l_a221oi_1
XFILLER_2_1948 vddd vssd sg13cmos5l_decap_4
XFILLER_16_2304 vddd vssd sg13cmos5l_decap_8
XFILLER_25_687 vddd vssd sg13cmos5l_decap_8
XFILLER_24_175 vddd vssd sg13cmos5l_decap_8
XFILLER_16_1614 vddd vssd sg13cmos5l_decap_8
XFILLER_21_882 vddd vssd sg13cmos5l_decap_8
XFILLER_16_1658 vddd vssd sg13cmos5l_decap_4
XFILLER_14_2072 vddd vssd sg13cmos5l_decap_8
XFILLER_21_42 vddd vssd sg13cmos5l_decap_8
XFILLER_10_1202 vddd vssd sg13cmos5l_decap_8
XFILLER_10_1257 vddd vssd sg13cmos5l_decap_4
XFILLER_27_2411 vddd vssd sg13cmos5l_decap_8
XFILLER_7_2505 vddd vssd sg13cmos5l_decap_8
XFILLER_0_720 vddd vssd sg13cmos5l_decap_8
XFILLER_27_2488 vddd vssd sg13cmos5l_decap_8
XFILLER_23_2319 vddd vssd sg13cmos5l_decap_8
XFILLER_1_2104 vddd vssd sg13cmos5l_decap_8
XFILLER_29_960 vddd vssd sg13cmos5l_decap_8
XFILLER_21_1353 vddd vssd sg13cmos5l_decap_8
Xtiedowns\[11\] io_in[3] vddd vssd sg13cmos5l_antennanp
XFILLER_16_643 vddd vssd sg13cmos5l_decap_8
XFILLER_30_101 vddd vssd sg13cmos5l_decap_8
XFILLER_19_1260 vddd vssd sg13cmos5l_decap_8
XFILLER_30_178 vddd vssd sg13cmos5l_decap_8
XFILLER_32_1460 vddd vssd sg13cmos5l_decap_8
XFILLER_7_77 vddd vssd sg13cmos5l_decap_8
XFILLER_8_897 vddd vssd sg13cmos5l_decap_8
X_4390_ _4392_/D _4390_/A _4390_/B _4390_/C _4390_/D vddd vssd sg13cmos5l_nand4_1
XFILLER_28_1529 vddd vssd sg13cmos5l_decap_8
X_6060_ _6060_/Y _5813_/A _7286_/Q _5090_/B vddd vssd sg13cmos5l_a21oi_1
Xhold1008 _6384_/A _7140_/Q vddd vssd sg13cmos5l_dlygate4sd3_1
Xhold1019 _6491_/A1 _5691_/A vddd vssd sg13cmos5l_dlygate4sd3_1
X_5011_ _6276_/B _5213_/A _5271_/A vddd vssd sg13cmos5l_nor2b_1
XFILLER_27_908 vddd vssd sg13cmos5l_decap_8
XFILLER_6_1369 vddd vssd sg13cmos5l_decap_8
X_6962_ _6962_/Y _6963_/A _6963_/B_N vddd vssd sg13cmos5l_nor2b_1
XFILLER_17_2602 vddd vssd sg13cmos5l_decap_4
X_5913_ _5914_/B io_in[2] _5913_/B vddd vssd sg13cmos5l_nor2_1
X_6893_ _6893_/Y _6910_/A _6910_/B_N vddd vssd sg13cmos5l_nor2b_1
XFILLER_21_112 vddd vssd sg13cmos5l_decap_8
X_5844_ _5850_/C _5854_/B _5854_/A vddd vssd sg13cmos5l_nand2b_1
XFILLER_22_657 vddd vssd sg13cmos5l_decap_8
XFILLER_22_679 vddd vssd sg13cmos5l_decap_8
X_5775_ _5800_/A _7208_/Q _5786_/B _5799_/B vddd vssd sg13cmos5l_nor3_1
X_4726_ _4726_/Y _4726_/A _4771_/B vddd vssd sg13cmos5l_nand2_1
X_4657_ _4657_/Y _4681_/A _4657_/B _4657_/C vddd vssd sg13cmos5l_nor3_1
X_7376_ _7376_/Q _7379_/CLK _7376_/D _6889_/Y vddd vssd sg13cmos5l_dfrbpq_1
X_3608_ _3608_/Y _3608_/A vddd vssd sg13cmos5l_inv_1
Xhold820 hold820/X _7088_/Q vddd vssd sg13cmos5l_dlygate4sd3_1
Xhold831 _6316_/A _7106_/Q vddd vssd sg13cmos5l_dlygate4sd3_1
X_4588_ _4588_/Y _4633_/A _4588_/B _4588_/C vddd vssd sg13cmos5l_nor3_1
X_6327_ _7111_/D hold912/X _6330_/B _6326_/Y vddd vssd sg13cmos5l_o21ai_1
Xhold864 hold864/X _3609_/Y vddd vssd sg13cmos5l_dlygate4sd3_1
Xhold842 _7367_/D _4298_/Y vddd vssd sg13cmos5l_dlygate4sd3_1
Xhold853 _4948_/B _4923_/Y vddd vssd sg13cmos5l_dlygate4sd3_1
Xhold886 _6451_/A _7176_/Q vddd vssd sg13cmos5l_dlygate4sd3_1
Xhold897 _4409_/A _7348_/Q vddd vssd sg13cmos5l_dlygate4sd3_1
Xhold875 _7206_/D _6508_/X vddd vssd sg13cmos5l_dlygate4sd3_1
X_3539_ _3539_/Y _4890_/A vddd vssd sg13cmos5l_inv_1
X_6258_ _6258_/Y _4492_/A _7295_/Q _6256_/Y _6257_/Y _6258_/C1 vddd vssd sg13cmos5l_a221oi_1
X_5209_ _6152_/A _5127_/A _5209_/B vddd vssd sg13cmos5l_nand2b_1
X_6189_ _6189_/Y _6189_/A _6189_/B vddd vssd sg13cmos5l_nor2_1
Xhold1520 _4974_/A _7297_/Q vddd vssd sg13cmos5l_dlygate4sd3_1
XFILLER_29_267 vddd vssd sg13cmos5l_decap_8
XFILLER_2_2468 vddd vssd sg13cmos5l_decap_4
XFILLER_26_963 vddd vssd sg13cmos5l_decap_8
XFILLER_16_42 vddd vssd sg13cmos5l_decap_8
XFILLER_16_1422 vddd vssd sg13cmos5l_decap_8
XFILLER_9_639 vddd vssd sg13cmos5l_decap_8
XFILLER_32_63 vddd vssd sg13cmos5l_decap_8
XFILLER_29_2506 vddd vssd sg13cmos5l_decap_8
XFILLER_4_311 vddd vssd sg13cmos5l_decap_4
XFILLER_5_834 vddd vssd sg13cmos5l_decap_8
XFILLER_10_1021 vddd vssd sg13cmos5l_decap_8
XFILLER_4_355 vddd vssd sg13cmos5l_decap_8
XFILLER_29_1838 vddd vssd sg13cmos5l_decap_8
Xtiedowns\[59\] mask_rev_in[15] vddd vssd sg13cmos5l_antennanp
XFILLER_10_1087 vddd vssd sg13cmos5l_decap_8
XFILLER_27_1584 vddd vssd sg13cmos5l_decap_8
XFILLER_7_1645 vddd vssd sg13cmos5l_decap_8
XFILLER_1_1211 vddd vssd sg13cmos5l_decap_8
XFILLER_16_440 vddd vssd sg13cmos5l_decap_8
XFILLER_1_1255 vddd vssd sg13cmos5l_decap_4
XFILLER_32_922 vddd vssd sg13cmos5l_decap_8
X_3890_ _4017_/B _3963_/A _6622_/A vddd vssd sg13cmos5l_nor2_1
X_5560_ _5560_/Y _5728_/A _7178_/Q _5559_/X vddd vssd sg13cmos5l_o21ai_1
X_4511_ _4511_/Y _4511_/A _4512_/B vddd vssd sg13cmos5l_nor2b_1
X_5491_ _5492_/B _3545_/Y _5507_/A _5513_/B _3544_/Y _5495_/B vddd vssd sg13cmos5l_a221oi_1
XFILLER_12_2554 vddd vssd sg13cmos5l_decap_8
X_7230_ _7230_/Q _7233_/CLK _7230_/D fanout376/X vddd vssd sg13cmos5l_dfrbpq_1
X_4442_ _4757_/B _4771_/A _4780_/B vddd vssd sg13cmos5l_and2_1
X_7161_ _7161_/Q _7179_/CLK _7161_/D fanout364/X vddd vssd sg13cmos5l_dfrbpq_1
X_4373_ _4392_/A _4373_/A _7122_/Q vddd vssd sg13cmos5l_nor2_1
XFILLER_28_1337 vddd vssd sg13cmos5l_decap_8
X_6112_ _6113_/C _6112_/A _6112_/B vddd vssd sg13cmos5l_nand2_1
X_7092_ _7092_/Q _7100_/CLK _7092_/D fanout413/X vddd vssd sg13cmos5l_dfrbpq_1
X_6043_ _6043_/Y _6130_/A _6043_/B _6130_/B vddd vssd sg13cmos5l_nand3_1
Xoutbuffers\[42\] bandgap_trim[3] _6286_/Y vddd vssd sg13cmos5l_buf_16
XFILLER_23_1971 vddd vssd sg13cmos5l_decap_4
X_6945_ _6945_/Y _6960_/A _6960_/B_N vddd vssd sg13cmos5l_nor2b_1
X_6876_ _6876_/Y _6911_/A _6877_/B_N vddd vssd sg13cmos5l_nor2b_1
XFILLER_17_2476 vddd vssd sg13cmos5l_decap_8
XFILLER_17_1753 vddd vssd sg13cmos5l_decap_8
X_5827_ _5829_/B _5827_/A _5827_/B vddd vssd sg13cmos5l_nor2_1
XFILLER_13_1617 vddd vssd sg13cmos5l_decap_8
X_5758_ _5758_/X _5902_/A _7207_/Q vddd vssd sg13cmos5l_or2_1
X_4709_ _4710_/B _4755_/A _4687_/X _4552_/A vddd vssd sg13cmos5l_a21oi_1
X_5689_ _5690_/B _5689_/A _5689_/B vddd vssd sg13cmos5l_nor2_1
XFILLER_11_2075 vddd vssd sg13cmos5l_decap_4
X_7359_ _7359_/Q _7379_/CLK _7359_/D _6872_/Y vddd vssd sg13cmos5l_dfrbpq_1
Xhold650 _7317_/D _4904_/Y vddd vssd sg13cmos5l_dlygate4sd3_1
Xhold661 _6341_/A _7118_/Q vddd vssd sg13cmos5l_dlygate4sd3_1
Xhold672 hold672/X _6339_/Y vddd vssd sg13cmos5l_dlygate4sd3_1
Xhold694 _7374_/D _4274_/X vddd vssd sg13cmos5l_dlygate4sd3_1
Xhold683 _4264_/A hold683/A vddd vssd sg13cmos5l_dlygate4sd3_1
XFILLER_24_2436 vddd vssd sg13cmos5l_decap_8
XFILLER_4_2519 vddd vssd sg13cmos5l_decap_8
XFILLER_8_1943 vddd vssd sg13cmos5l_decap_8
XFILLER_4_1807 vddd vssd sg13cmos5l_decap_4
Xhold1361 _6633_/A1 _5266_/B vddd vssd sg13cmos5l_dlygate4sd3_1
Xhold1350 hold847/A _7366_/Q vddd vssd sg13cmos5l_dlygate4sd3_1
XFILLER_27_63 vddd vssd sg13cmos5l_decap_8
Xhold1394 _4437_/B _4393_/B vddd vssd sg13cmos5l_dlygate4sd3_1
Xhold1383 _7237_/D _6566_/X vddd vssd sg13cmos5l_dlygate4sd3_1
Xhold1372 hold1372/X _7202_/Q vddd vssd sg13cmos5l_dlygate4sd3_1
XFILLER_17_259 vddd vssd sg13cmos5l_decap_8
XFILLER_26_771 vddd vssd sg13cmos5l_decap_8
XFILLER_5_675 vddd vssd sg13cmos5l_decap_8
XFILLER_4_56 vddd vssd sg13cmos5l_decap_8
Xclkbuf_4_11__f_clk_regs _7350_/CLK clkbuf_3_5_0_clk_regs/X vddd vssd sg13cmos5l_buf_8
X_6730_ _6730_/X _6404_/A _6730_/A1 _6732_/S vddd vssd sg13cmos5l_mux2_1
XFILLER_23_207 vddd vssd sg13cmos5l_decap_8
X_4991_ _5263_/A _7250_/Q _7251_/Q vddd vssd sg13cmos5l_nand2b_1
X_3942_ _3942_/Y _6615_/B _3966_/B vddd vssd sg13cmos5l_nor2_1
XFILLER_17_793 vddd vssd sg13cmos5l_decap_4
X_3873_ _3873_/Y _5004_/A _3868_/Y _3862_/Y vddd vssd sg13cmos5l_a21oi_1
X_6661_ _6661_/Y _6661_/A _6666_/S vddd vssd sg13cmos5l_nand2_1
XFILLER_20_914 vddd vssd sg13cmos5l_decap_8
XFILLER_17_1027 vddd vssd sg13cmos5l_decap_8
XFILLER_32_796 vddd vssd sg13cmos5l_decap_8
XFILLER_31_273 vddd vssd sg13cmos5l_decap_4
X_5612_ _5627_/C _7184_/Q _7185_/Q vddd vssd sg13cmos5l_nand2_1
XFILLER_20_958 vddd vssd sg13cmos5l_decap_8
X_6592_ _6592_/X hold688/X _6605_/A _6594_/S vddd vssd sg13cmos5l_mux2_1
X_5543_ _5543_/Y _5543_/A _5543_/B _5543_/C vddd vssd sg13cmos5l_nor3_1
X_5474_ _5480_/D _7167_/Q _7166_/Q vddd vssd sg13cmos5l_nand2b_1
X_4425_ _4427_/B _4435_/A _4755_/A vddd vssd sg13cmos5l_nor2_1
X_7213_ _7213_/Q _7217_/CLK _7213_/D _6825_/B_N vddd vssd sg13cmos5l_dfrbpq_1
X_7144_ _7144_/Q _7180_/CLK _7144_/D fanout361/X vddd vssd sg13cmos5l_dfrbpq_1
Xfanout404 _6844_/B_N _6846_/B_N vddd vssd sg13cmos5l_buf_1
X_4356_ _4356_/Y _3492_/Y _7085_/Q _4355_/Y vddd vssd sg13cmos5l_o21ai_1
Xfanout448 _6221_/A io_in[11] vddd vssd sg13cmos5l_buf_1
Xfanout415 _6963_/B_N _6919_/B_N vddd vssd sg13cmos5l_buf_1
Xfanout426 _5816_/A _3546_/A vddd vssd sg13cmos5l_buf_1
Xfanout437 _5372_/A _5737_/A vddd vssd sg13cmos5l_buf_1
X_7075_ _7075_/Q _7108_/CLK _7075_/D fanout398/X vddd vssd sg13cmos5l_dfrbpq_1
Xfanout459 _6885_/A _6909_/A vddd vssd sg13cmos5l_buf_1
X_4287_ _4287_/Y _4287_/A _4287_/B _4293_/A vddd vssd sg13cmos5l_nor3_1
X_6026_ _6026_/Y _6194_/A _5088_/A _5088_/B vddd vssd sg13cmos5l_a21oi_1
XFILLER_19_2527 vddd vssd sg13cmos5l_decap_8
X_6928_ _6928_/Y _6943_/A _6943_/B_N vddd vssd sg13cmos5l_nor2b_1
Xfanout55 _6450_/A _3939_/Y vddd vssd sg13cmos5l_buf_1
XFILLER_13_2104 vddd vssd sg13cmos5l_decap_8
Xfanout33 _4616_/A _4392_/X vddd vssd sg13cmos5l_buf_1
X_6859_ _6859_/Y _6863_/A _6860_/B_N vddd vssd sg13cmos5l_nor2b_1
Xfanout44 _6343_/B _6347_/B vddd vssd sg13cmos5l_buf_1
Xfanout88 _4250_/A _3739_/Y vddd vssd sg13cmos5l_buf_1
Xfanout77 _6533_/A _3911_/Y vddd vssd sg13cmos5l_buf_1
Xfanout66 _6771_/B _6759_/Y vddd vssd sg13cmos5l_buf_1
XFILLER_13_21 vddd vssd sg13cmos5l_decap_8
XFILLER_30_2473 vddd vssd sg13cmos5l_decap_8
Xhold480 _4933_/A hold480/A vddd vssd sg13cmos5l_dlygate4sd3_1
XFILLER_2_656 vddd vssd sg13cmos5l_decap_8
XFILLER_8_2430 vddd vssd sg13cmos5l_decap_8
Xhold491 sram_addr[0] _5987_/X vddd vssd sg13cmos5l_dlygate4sd3_1
XFILLER_20_1407 vddd vssd sg13cmos5l_decap_4
Xhold1191 _7066_/D _6732_/X vddd vssd sg13cmos5l_dlygate4sd3_1
Xhold1180 _6516_/A1 _7211_/Q vddd vssd sg13cmos5l_dlygate4sd3_1
XFILLER_2_1383 vddd vssd sg13cmos5l_decap_4
XFILLER_31_1547 vddd vssd sg13cmos5l_decap_8
XFILLER_9_288 vddd vssd sg13cmos5l_decap_8
XFILLER_6_951 vddd vssd sg13cmos5l_decap_8
X_4210_ _4210_/Y _5691_/A _6489_/A _6480_/A vddd vssd sg13cmos5l_a21oi_1
X_5190_ _6139_/A _5274_/B _5190_/B vddd vssd sg13cmos5l_nand2b_1
XFILLER_9_1537 vddd vssd sg13cmos5l_decap_8
X_4141_ _4141_/Y _4138_/Y _4139_/Y _4140_/Y vddd vssd sg13cmos5l_o21ai_1
X_4072_ _4073_/D _7092_/Q _6773_/A _6773_/B vddd vssd sg13cmos5l_nor3_1
XFILLER_23_1053 vddd vssd sg13cmos5l_decap_8
X_4974_ _4975_/B _4974_/A _4974_/B vddd vssd sg13cmos5l_nor2_1
XFILLER_32_560 vddd vssd sg13cmos5l_decap_8
X_6713_ _7052_/D _6735_/A1 _6717_/S _6713_/B1 vddd vssd sg13cmos5l_a21oi_1
X_3925_ _3925_/Y _3925_/A _3925_/B _3925_/C vddd vssd sg13cmos5l_nand3_1
XFILLER_32_593 vddd vssd sg13cmos5l_decap_8
XFILLER_18_2593 vddd vssd sg13cmos5l_decap_8
X_6644_ _7284_/D _6701_/A1 _6650_/S _6644_/B1 vddd vssd sg13cmos5l_a21oi_1
XFILLER_14_2457 vddd vssd sg13cmos5l_decap_8
Xclkload8 clkload8/X clkload8/A vddd vssd sg13cmos5l_buf_8
X_3856_ _3856_/Y _4000_/A _4258_/B _7017_/D vddd vssd sg13cmos5l_o21ai_1
X_3787_ _3787_/X _3931_/A _6361_/A vddd vssd sg13cmos5l_and2_1
XFILLER_14_1767 vddd vssd sg13cmos5l_decap_8
XFILLER_14_1745 vddd vssd sg13cmos5l_decap_4
X_6575_ _6575_/X _6575_/A0 _6704_/A0 _6575_/S vddd vssd sg13cmos5l_mux2_1
X_5526_ _5526_/Y _5539_/C _5525_/Y _5540_/A vddd vssd sg13cmos5l_o21ai_1
X_5457_ _5457_/Y _7162_/Q _7163_/Q _5457_/C vddd vssd sg13cmos5l_nor3_1
X_4408_ _4408_/Y _4420_/A _4408_/B vddd vssd sg13cmos5l_nor2_1
Xfanout201 _6393_/A _6686_/A vddd vssd sg13cmos5l_buf_1
Xfanout223 _6949_/A _6845_/A vddd vssd sg13cmos5l_buf_1
X_5388_ _5388_/Y _7155_/Q _5393_/B vddd vssd sg13cmos5l_nor2b_1
XFILLER_5_2603 vddd vssd sg13cmos5l_decap_4
Xfanout212 _4282_/A _4285_/C vddd vssd sg13cmos5l_buf_1
XFILLER_25_2564 vddd vssd sg13cmos5l_decap_8
Xfanout245 _6104_/A1 hold1457/X vddd vssd sg13cmos5l_buf_1
X_7127_ _7127_/Q _7127_/CLK _7127_/D fanout398/X vddd vssd sg13cmos5l_dfrbpq_1
Xfanout256 _4800_/A _4815_/B vddd vssd sg13cmos5l_buf_1
Xfanout234 _5031_/B hold1001/X vddd vssd sg13cmos5l_buf_1
X_4339_ _4339_/Y _4316_/A _4316_/B _4313_/X vddd vssd sg13cmos5l_a21oi_1
X_7058_ _7058_/Q _7069_/CLK _7058_/D _6820_/B_N vddd vssd sg13cmos5l_dfrbpq_1
XFILLER_25_1841 vddd vssd sg13cmos5l_decap_8
XFILLER_21_2428 vddd vssd sg13cmos5l_decap_8
Xfanout278 _5972_/B hold1433/X vddd vssd sg13cmos5l_buf_1
Xfanout289 _5854_/A _7218_/Q vddd vssd sg13cmos5l_buf_1
Xfanout267 _6041_/B _6189_/B vddd vssd sg13cmos5l_buf_1
X_6009_ _6009_/Y _3819_/Y _5062_/A _6007_/Y _6008_/Y _5046_/Y vddd vssd sg13cmos5l_a221oi_1
XFILLER_19_1612 vddd vssd sg13cmos5l_decap_8
XFILLER_24_42 vddd vssd sg13cmos5l_decap_8
XFILLER_32_2524 vddd vssd sg13cmos5l_decap_8
XFILLER_15_1509 vddd vssd sg13cmos5l_decap_4
XFILLER_32_1845 vddd vssd sg13cmos5l_decap_8
XFILLER_7_748 vddd vssd sg13cmos5l_decap_8
XFILLER_11_777 vddd vssd sg13cmos5l_decap_4
XFILLER_30_1580 vddd vssd sg13cmos5l_decap_8
XFILLER_3_910 vddd vssd sg13cmos5l_decap_8
XFILLER_6_0 vddd vssd sg13cmos5l_decap_8
Xtiedowns\[41\] dbus_in_right[9] vddd vssd sg13cmos5l_antennanp
XFILLER_4_2146 vddd vssd sg13cmos5l_decap_8
XFILLER_8_1570 vddd vssd sg13cmos5l_decap_4
XFILLER_20_1215 vddd vssd sg13cmos5l_decap_8
XFILLER_4_1456 vddd vssd sg13cmos5l_decap_8
XFILLER_19_899 vddd vssd sg13cmos5l_decap_8
XFILLER_19_888 vddd vssd sg13cmos5l_decap_8
XFILLER_19_877 vddd vssd sg13cmos5l_decap_4
X_3710_ _6349_/A _3842_/B _3880_/B vddd vssd sg13cmos5l_nand2_1
X_4690_ _4691_/B _7333_/Q _4690_/B vddd vssd sg13cmos5l_xnor2_1
X_3641_ _3641_/Y _5999_/S _4889_/B vddd vssd sg13cmos5l_nor2_1
XFILLER_31_1355 vddd vssd sg13cmos5l_decap_8
X_3572_ _5585_/B _3572_/A vddd vssd sg13cmos5l_inv_1
XFILLER_13_2490 vddd vssd sg13cmos5l_decap_8
X_6360_ _6360_/X hold839/X _6330_/A _6360_/S vddd vssd sg13cmos5l_mux2_1
X_5311_ _5313_/C _5304_/A _5316_/A vddd vssd sg13cmos5l_nand2b_1
X_6291_ _6291_/Y _6287_/A _3623_/Y _6294_/A vddd vssd sg13cmos5l_o21ai_1
X_5242_ _5243_/D _5242_/A _5242_/B _5242_/C vddd vssd sg13cmos5l_or3_1
XFILLER_25_1126 vddd vssd sg13cmos5l_decap_8
X_5173_ _5189_/A _7247_/Q _5254_/B _7246_/Q vddd vssd sg13cmos5l_nand3b_1
XFILLER_29_1295 vddd vssd sg13cmos5l_decap_4
X_4124_ _4124_/Y _7201_/Q _6496_/A vddd vssd sg13cmos5l_nor2_1
XFILLER_0_2500 vddd vssd sg13cmos5l_decap_8
X_4055_ _4055_/Y _7069_/Q _6733_/A vddd vssd sg13cmos5l_nor2_1
XFILLER_25_825 vddd vssd sg13cmos5l_decap_4
XFILLER_20_2472 vddd vssd sg13cmos5l_decap_8
XFILLER_25_869 vddd vssd sg13cmos5l_decap_8
XFILLER_0_2577 vddd vssd sg13cmos5l_decap_8
XFILLER_0_1898 vddd vssd sg13cmos5l_decap_8
X_4957_ _7302_/D _4957_/A vddd vssd sg13cmos5l_inv_1
XFILLER_14_2221 vddd vssd sg13cmos5l_decap_8
XFILLER_32_1108 vddd vssd sg13cmos5l_decap_8
X_3908_ _6540_/A _3908_/A _3911_/B vddd vssd sg13cmos5l_nor2_1
X_4888_ _4888_/Y _4903_/B vddd vssd sg13cmos5l_inv_1
X_6627_ _6627_/Y _6627_/A _6627_/B vddd vssd sg13cmos5l_nand2_1
X_3839_ _3839_/Y _7118_/Q _4242_/A2 _4067_/B1 vddd vssd sg13cmos5l_a21oi_1
X_6558_ _7232_/D _6558_/A1 _6562_/S _6557_/Y vddd vssd sg13cmos5l_a21oi_1
XFILLER_10_2129 vddd vssd sg13cmos5l_decap_8
X_5509_ _5509_/Y _5511_/A _7171_/Q _5509_/C vddd vssd sg13cmos5l_nor3_1
XFILLER_10_44 vddd vssd sg13cmos5l_decap_8
X_6489_ _6495_/S _6489_/A _6660_/B vddd vssd sg13cmos5l_nand2_1
XFILLER_27_1969 vddd vssd sg13cmos5l_decap_8
XFILLER_25_2372 vddd vssd sg13cmos5l_decap_8
XFILLER_9_2591 vddd vssd sg13cmos5l_decap_8
XFILLER_19_42 vddd vssd sg13cmos5l_decap_8
XFILLER_21_1535 vddd vssd sg13cmos5l_decap_8
XFILLER_27_140 vddd vssd sg13cmos5l_decap_8
XFILLER_19_2154 vddd vssd sg13cmos5l_decap_8
XFILLER_32_2398 vddd vssd sg13cmos5l_decap_8
XFILLER_7_556 vddd vssd sg13cmos5l_decap_4
XFILLER_32_1697 vddd vssd sg13cmos5l_decap_8
XFILLER_32_7 vddd vssd sg13cmos5l_decap_8
Xclkbuf_leaf_11_SCK_regs _7069_/CLK clkload3/A vddd vssd sg13cmos5l_buf_8
XFILLER_4_1231 vddd vssd sg13cmos5l_decap_8
XFILLER_4_1264 vddd vssd sg13cmos5l_decap_8
XFILLER_20_1078 vddd vssd sg13cmos5l_decap_4
X_5860_ _5860_/Y _5916_/A1 _5831_/Y _5859_/Y vddd vssd sg13cmos5l_a21oi_1
X_4811_ _4811_/Y _4815_/A _4811_/B vddd vssd sg13cmos5l_nand2_1
XFILLER_22_839 vddd vssd sg13cmos5l_decap_8
X_5791_ _5791_/Y _5973_/A _7210_/Q _5790_/X vddd vssd sg13cmos5l_o21ai_1
X_4742_ _4744_/B _4767_/A1 _4741_/Y _4739_/Y vddd vssd sg13cmos5l_o21ai_1
XFILLER_15_2563 vddd vssd sg13cmos5l_decap_8
X_4673_ _4676_/A _4669_/X _4672_/Y _4663_/Y vddd vssd sg13cmos5l_a21oi_1
X_3624_ _3624_/Y _6226_/B vddd vssd sg13cmos5l_inv_1
XFILLER_15_1884 vddd vssd sg13cmos5l_decap_8
X_6412_ _6418_/B _6412_/A _6725_/B vddd vssd sg13cmos5l_nand2_1
XFILLER_11_2449 vddd vssd sg13cmos5l_decap_8
X_7392_ _7392_/Q _7396_/CLK _7392_/D _6904_/Y vddd vssd sg13cmos5l_dfrbpq_1
XFILLER_11_1737 vddd vssd sg13cmos5l_decap_8
X_3555_ _5339_/C _3555_/A vddd vssd sg13cmos5l_inv_1
X_6343_ _6343_/Y _6343_/A _6343_/B vddd vssd sg13cmos5l_nand2_1
Xoutbuffers\[72\] idac1_value[4] _7038_/Q vddd vssd sg13cmos5l_buf_16
X_6274_ _6274_/Y _6276_/B _6274_/B vddd vssd sg13cmos5l_nor2_1
X_3486_ _3486_/Y _4343_/A vddd vssd sg13cmos5l_inv_1
X_5225_ _5226_/C _5278_/A _5225_/B _5225_/C _5225_/D vddd vssd sg13cmos5l_nor4_1
X_5156_ _5168_/B _7268_/Q _7269_/Q _5210_/B vddd vssd sg13cmos5l_nor3_1
XFILLER_5_1039 vddd vssd sg13cmos5l_decap_8
X_4107_ _4107_/Y dbus_in_left[9] dbus_in_right[9] vddd vssd sg13cmos5l_nor2_1
XFILLER_22_2567 vddd vssd sg13cmos5l_decap_8
X_5087_ _5091_/B _6043_/B _6023_/C _5255_/B _5076_/A _5074_/Y vddd vssd sg13cmos5l_a221oi_1
X_4038_ _4038_/Y _3577_/Y _6480_/A _4212_/A2 vddd vssd sg13cmos5l_a21oi_1
XFILLER_0_2330 vddd vssd sg13cmos5l_decap_4
XFILLER_20_1590 vddd vssd sg13cmos5l_decap_4
XFILLER_24_154 vddd vssd sg13cmos5l_decap_8
XFILLER_0_1684 vddd vssd sg13cmos5l_decap_8
X_5989_ _5989_/X _5989_/A0 _3750_/B _5994_/S vddd vssd sg13cmos5l_mux2_1
XANTENNA_50 _6784_/A vddd vssd sg13cmos5l_antennanp
XFILLER_21_21 vddd vssd sg13cmos5l_decap_8
XFILLER_21_98 vddd vssd sg13cmos5l_decap_8
XFILLER_27_2467 vddd vssd sg13cmos5l_decap_8
XFILLER_27_1755 vddd vssd sg13cmos5l_decap_8
XFILLER_0_743 vddd vssd sg13cmos5l_decap_8
XFILLER_23_1608 vddd vssd sg13cmos5l_decap_4
XFILLER_21_2000 vddd vssd sg13cmos5l_decap_8
XFILLER_7_1838 vddd vssd sg13cmos5l_decap_8
XFILLER_25_1490 vddd vssd sg13cmos5l_decap_8
XFILLER_21_2033 vddd vssd sg13cmos5l_decap_4
XFILLER_16_622 vddd vssd sg13cmos5l_decap_8
XFILLER_1_1459 vddd vssd sg13cmos5l_decap_4
XFILLER_31_603 vddd vssd sg13cmos5l_decap_8
XFILLER_15_1103 vddd vssd sg13cmos5l_decap_8
XFILLER_30_157 vddd vssd sg13cmos5l_decap_8
XFILLER_8_810 vddd vssd sg13cmos5l_decap_8
XFILLER_8_843 vddd vssd sg13cmos5l_decap_4
XFILLER_7_56 vddd vssd sg13cmos5l_decap_8
XFILLER_10_2482 vddd vssd sg13cmos5l_decap_8
X_5010_ _5271_/A _7246_/Q _7247_/Q vddd vssd sg13cmos5l_nor2b_1
Xhold1009 _6385_/B1 _6384_/Y vddd vssd sg13cmos5l_dlygate4sd3_1
XFILLER_6_1348 vddd vssd sg13cmos5l_decap_8
X_6961_ _6961_/Y _6961_/A _6961_/B_N vddd vssd sg13cmos5l_nor2b_1
XFILLER_4_1083 vddd vssd sg13cmos5l_decap_8
X_6892_ _6892_/Y _6909_/A _6892_/B_N vddd vssd sg13cmos5l_nor2b_1
X_5912_ _5914_/A _7226_/Q _7227_/Q _5912_/C vddd vssd sg13cmos5l_nor3_1
X_5843_ _5843_/Y _5841_/Y _5842_/Y _5854_/C vddd vssd sg13cmos5l_o21ai_1
X_5774_ _5799_/B _5774_/A vddd vssd sg13cmos5l_inv_1
X_4725_ _4725_/Y _4769_/A1 _4706_/Y _4721_/Y _4724_/Y vddd vssd sg13cmos5l_a22oi_1
X_4656_ _4657_/C _4680_/A _4656_/B vddd vssd sg13cmos5l_nor2_1
X_3607_ _3607_/Y _3607_/A vddd vssd sg13cmos5l_inv_1
X_4587_ _4588_/C _4609_/A _4587_/B vddd vssd sg13cmos5l_nor2_1
X_7375_ _7375_/Q _7378_/CLK _7375_/D _6888_/Y vddd vssd sg13cmos5l_dfrbpq_1
Xhold810 hold810/X _4293_/Y vddd vssd sg13cmos5l_dlygate4sd3_1
Xhold821 _7088_/D _6770_/X vddd vssd sg13cmos5l_dlygate4sd3_1
Xhold832 hold832/X _6316_/Y vddd vssd sg13cmos5l_dlygate4sd3_1
X_6326_ _6326_/Y _6768_/A _6330_/B vddd vssd sg13cmos5l_nand2_1
X_3538_ _3538_/Y _5949_/B vddd vssd sg13cmos5l_inv_1
Xhold843 hold843/X _7086_/Q vddd vssd sg13cmos5l_dlygate4sd3_1
Xhold854 _4967_/B _4958_/B vddd vssd sg13cmos5l_dlygate4sd3_1
Xhold865 _7110_/D _6325_/Y vddd vssd sg13cmos5l_dlygate4sd3_1
Xhold887 hold887/X _6451_/Y vddd vssd sg13cmos5l_dlygate4sd3_1
Xhold898 _4410_/B _4409_/X vddd vssd sg13cmos5l_dlygate4sd3_1
Xhold876 _6350_/A _7122_/Q vddd vssd sg13cmos5l_dlygate4sd3_1
X_3469_ _3469_/Y _4480_/A vddd vssd sg13cmos5l_inv_1
X_6257_ _6257_/Y _4194_/X _5279_/B _4979_/A vddd vssd sg13cmos5l_a21oi_1
Xhold1510 hold972/A _7303_/Q vddd vssd sg13cmos5l_dlygate4sd3_1
X_6188_ _6188_/X _6188_/A _6188_/B vddd vssd sg13cmos5l_or2_1
X_5208_ _5222_/A _5208_/A _5208_/B vddd vssd sg13cmos5l_nor2_1
XFILLER_6_2561 vddd vssd sg13cmos5l_decap_8
XFILLER_18_909 vddd vssd sg13cmos5l_decap_8
Xhold1521 _3659_/A _7367_/Q vddd vssd sg13cmos5l_dlygate4sd3_1
XFILLER_6_2594 vddd vssd sg13cmos5l_decap_8
X_5139_ _5140_/D _6080_/A _5139_/B _5139_/C _5139_/D vddd vssd sg13cmos5l_nand4_1
XFILLER_22_2375 vddd vssd sg13cmos5l_decap_8
XFILLER_0_2160 vddd vssd sg13cmos5l_decap_8
XFILLER_16_21 vddd vssd sg13cmos5l_decap_8
XFILLER_0_1492 vddd vssd sg13cmos5l_decap_4
XFILLER_32_42 vddd vssd sg13cmos5l_decap_8
XFILLER_16_1467 vddd vssd sg13cmos5l_decap_4
XFILLER_14_1191 vddd vssd sg13cmos5l_decap_8
XFILLER_10_1066 vddd vssd sg13cmos5l_decap_8
XFILLER_27_2275 vddd vssd sg13cmos5l_decap_4
XFILLER_27_1563 vddd vssd sg13cmos5l_decap_8
XFILLER_27_1552 vddd vssd sg13cmos5l_decap_8
XFILLER_7_1624 vddd vssd sg13cmos5l_decap_8
XFILLER_0_584 vddd vssd sg13cmos5l_decap_8
XFILLER_5_2071 vddd vssd sg13cmos5l_decap_8
Xclkbuf_4_10__f_clk_regs _7348_/CLK clkbuf_3_5_0_clk_regs/X vddd vssd sg13cmos5l_buf_8
XFILLER_32_901 vddd vssd sg13cmos5l_decap_8
XFILLER_21_1184 vddd vssd sg13cmos5l_decap_4
XFILLER_12_2533 vddd vssd sg13cmos5l_decap_8
X_4510_ _4513_/A _4789_/A _4510_/B vddd vssd sg13cmos5l_nor2_1
XFILLER_8_673 vddd vssd sg13cmos5l_decap_8
X_5490_ _5513_/B _7169_/Q _7168_/Q vddd vssd sg13cmos5l_nor2b_1
XFILLER_32_1291 vddd vssd sg13cmos5l_decap_8
X_4441_ _4780_/B _5329_/A _4815_/A vddd vssd sg13cmos5l_and2_1
XFILLER_12_1865 vddd vssd sg13cmos5l_decap_8
X_7160_ _7160_/Q _7179_/CLK _7160_/D fanout364/X vddd vssd sg13cmos5l_dfrbpq_1
X_6111_ _6113_/B _5187_/D _6109_/Y _6110_/Y vddd vssd sg13cmos5l_o21ai_1
X_4372_ _4372_/X _4473_/A _7129_/Q vddd vssd sg13cmos5l_xor2_1
X_7091_ _7091_/Q _7105_/CLK _7091_/D fanout413/X vddd vssd sg13cmos5l_dfrbpq_1
XFILLER_21_0 vddd vssd sg13cmos5l_decap_8
X_6042_ _6042_/Y _4771_/A _6041_/B _6041_/Y vddd vssd sg13cmos5l_a21oi_1
XFILLER_27_717 vddd vssd sg13cmos5l_decap_4
XFILLER_27_739 vddd vssd sg13cmos5l_decap_8
XFILLER_23_1994 vddd vssd sg13cmos5l_decap_8
Xoutbuffers\[35\] biasgen_ref_vbg _7055_/Q vddd vssd sg13cmos5l_buf_16
X_6944_ _6944_/Y _6963_/A _6963_/B_N vddd vssd sg13cmos5l_nor2b_1
XFILLER_17_2455 vddd vssd sg13cmos5l_decap_8
X_6875_ _6875_/Y _6910_/A _6885_/B_N vddd vssd sg13cmos5l_nor2b_1
X_5826_ _5827_/B _5828_/C _5823_/Y _5828_/B vddd vssd sg13cmos5l_a21oi_1
X_5757_ _5761_/B _5769_/C _5762_/C vddd vssd sg13cmos5l_nor2_1
XFILLER_10_639 vddd vssd sg13cmos5l_decap_8
XFILLER_17_1798 vddd vssd sg13cmos5l_decap_8
X_4708_ _4710_/A _4714_/B _4714_/C vddd vssd sg13cmos5l_or2_1
X_5688_ _5689_/B _5637_/A _5711_/C _5708_/B vddd vssd sg13cmos5l_o21ai_1
X_4639_ _4639_/Y _4800_/A _3605_/Y _4638_/Y vddd vssd sg13cmos5l_a21oi_1
X_7358_ _7358_/Q _7379_/CLK _7358_/D _6871_/Y vddd vssd sg13cmos5l_dfrbpq_1
Xhold651 _3506_/A _7321_/Q vddd vssd sg13cmos5l_dlygate4sd3_1
Xhold640 hold640/X _4283_/Y vddd vssd sg13cmos5l_dlygate4sd3_1
Xhold662 hold662/X _6341_/Y vddd vssd sg13cmos5l_dlygate4sd3_1
XFILLER_8_2601 vddd vssd sg13cmos5l_decap_4
XFILLER_24_2415 vddd vssd sg13cmos5l_decap_8
Xhold695 _6362_/A _7130_/Q vddd vssd sg13cmos5l_dlygate4sd3_1
Xhold673 hold673/X _7255_/Q vddd vssd sg13cmos5l_dlygate4sd3_1
X_7289_ _7289_/Q _7292_/CLK _7289_/D _6829_/B_N vddd vssd sg13cmos5l_dfrbpq_1
X_6309_ _6309_/Y _6768_/A _6311_/B vddd vssd sg13cmos5l_nand2_1
Xhold684 _7398_/D _5293_/X vddd vssd sg13cmos5l_dlygate4sd3_1
XFILLER_28_2595 vddd vssd sg13cmos5l_decap_8
XFILLER_28_1861 vddd vssd sg13cmos5l_decap_8
XFILLER_24_1747 vddd vssd sg13cmos5l_decap_8
XFILLER_24_1725 vddd vssd sg13cmos5l_decap_8
Xhold1340 _7174_/D _6448_/X vddd vssd sg13cmos5l_dlygate4sd3_1
XFILLER_18_717 vddd vssd sg13cmos5l_decap_8
XFILLER_8_1988 vddd vssd sg13cmos5l_decap_8
Xhold1351 _4300_/B _4299_/X vddd vssd sg13cmos5l_dlygate4sd3_1
Xhold1384 hold1384/X _7191_/Q vddd vssd sg13cmos5l_dlygate4sd3_1
XFILLER_27_42 vddd vssd sg13cmos5l_decap_8
Xhold1395 _7334_/D _4658_/X vddd vssd sg13cmos5l_dlygate4sd3_1
XFILLER_2_2255 vddd vssd sg13cmos5l_decap_8
Xhold1362 _3515_/A _7311_/Q vddd vssd sg13cmos5l_dlygate4sd3_1
Xhold1373 _6500_/A0 _5736_/A vddd vssd sg13cmos5l_dlygate4sd3_1
XFILLER_22_1482 vddd vssd sg13cmos5l_decap_8
XFILLER_31_2419 vddd vssd sg13cmos5l_decap_8
XFILLER_16_1242 vddd vssd sg13cmos5l_decap_8
Xtiedowns\[71\] mask_rev_in[27] vddd vssd sg13cmos5l_antennanp
XFILLER_12_1139 vddd vssd sg13cmos5l_decap_8
XFILLER_29_2359 vddd vssd sg13cmos5l_decap_8
XFILLER_29_1625 vddd vssd sg13cmos5l_decap_4
XFILLER_29_1603 vddd vssd sg13cmos5l_decap_4
XFILLER_4_35 vddd vssd sg13cmos5l_decap_8
XFILLER_27_2072 vddd vssd sg13cmos5l_decap_8
XFILLER_7_1443 vddd vssd sg13cmos5l_decap_4
XFILLER_1_1031 vddd vssd sg13cmos5l_decap_8
XFILLER_1_1075 vddd vssd sg13cmos5l_decap_8
X_4990_ _5221_/A _7248_/Q _7249_/Q vddd vssd sg13cmos5l_nand2_1
X_3941_ _3941_/Y _3935_/Y _3938_/Y _3940_/Y vddd vssd sg13cmos5l_o21ai_1
XFILLER_17_1006 vddd vssd sg13cmos5l_decap_8
XFILLER_32_775 vddd vssd sg13cmos5l_decap_8
X_6660_ _6666_/S _6660_/A _6660_/B vddd vssd sg13cmos5l_nand2_1
X_3872_ _3872_/Y _3872_/A _3872_/B _3872_/C _3872_/D vddd vssd sg13cmos5l_nand4_1
X_5611_ _5628_/C _7184_/Q _7185_/Q vddd vssd sg13cmos5l_nand2b_1
X_6591_ _7252_/D _6333_/A _6594_/S hold604/X vddd vssd sg13cmos5l_a21oi_1
X_5542_ _5542_/Y _5537_/Y _5538_/X _5541_/Y vddd vssd sg13cmos5l_o21ai_1
X_5473_ _5473_/Y _5727_/A _7167_/Q vddd vssd sg13cmos5l_nor2_1
X_7212_ _7212_/Q _7218_/CLK _7212_/D fanout372/X vddd vssd sg13cmos5l_dfrbpq_1
X_4424_ _4651_/A _4430_/B _4460_/A vddd vssd sg13cmos5l_nand2b_1
X_7143_ _7143_/Q _7143_/CLK _7143_/D fanout362/X vddd vssd sg13cmos5l_dfrbpq_1
X_4355_ _4355_/Y _7084_/Q _4416_/A _4354_/Y vddd vssd sg13cmos5l_o21ai_1
Xfanout405 _6846_/B_N fanout417/X vddd vssd sg13cmos5l_buf_1
Xfanout416 _6919_/B_N fanout417/X vddd vssd sg13cmos5l_buf_1
XFILLER_28_1146 vddd vssd sg13cmos5l_decap_8
X_7074_ _7074_/Q _7108_/CLK _7074_/D fanout398/X vddd vssd sg13cmos5l_dfrbpq_1
Xfanout427 _3546_/A io_in[7] vddd vssd sg13cmos5l_buf_1
Xfanout438 _5737_/A _6233_/A vddd vssd sg13cmos5l_buf_1
Xfanout449 _5533_/A _5728_/A vddd vssd sg13cmos5l_buf_1
X_4286_ _4286_/Y _4287_/B _4286_/B vddd vssd sg13cmos5l_nor2_1
X_6025_ _6025_/Y _5088_/A _6025_/B vddd vssd sg13cmos5l_nand2b_1
XFILLER_23_2481 vddd vssd sg13cmos5l_decap_8
XFILLER_3_2553 vddd vssd sg13cmos5l_decap_8
XFILLER_19_2506 vddd vssd sg13cmos5l_decap_8
X_6927_ _6927_/Y _6943_/A _6943_/B_N vddd vssd sg13cmos5l_nor2b_1
Xfanout23 _4771_/B _4811_/B vddd vssd sg13cmos5l_buf_1
Xfanout56 _4212_/A2 _6474_/A vddd vssd sg13cmos5l_buf_1
X_6858_ _6858_/Y _6863_/A _6860_/B_N vddd vssd sg13cmos5l_nor2b_1
Xfanout45 _6347_/B _6332_/Y vddd vssd sg13cmos5l_buf_1
Xfanout34 _4671_/A _4392_/X vddd vssd sg13cmos5l_buf_1
Xfanout67 _6681_/S _6682_/S vddd vssd sg13cmos5l_buf_1
X_5809_ _5809_/Y _5637_/A _5828_/C _7215_/Q vddd vssd sg13cmos5l_o21ai_1
Xfanout89 _3990_/A _3733_/Y vddd vssd sg13cmos5l_buf_1
X_6789_ _6789_/Y hold767/X _6788_/B _6788_/Y vddd vssd sg13cmos5l_o21ai_1
XFILLER_30_2452 vddd vssd sg13cmos5l_decap_8
XFILLER_13_77 vddd vssd sg13cmos5l_decap_8
XFILLER_30_1762 vddd vssd sg13cmos5l_decap_8
Xhold481 sram_addr[8] _5997_/X vddd vssd sg13cmos5l_dlygate4sd3_1
XFILLER_28_2392 vddd vssd sg13cmos5l_decap_8
Xhold492 _4949_/A hold967/X vddd vssd sg13cmos5l_dlygate4sd3_1
XFILLER_24_1566 vddd vssd sg13cmos5l_decap_8
Xhold1170 _3522_/A _7258_/Q vddd vssd sg13cmos5l_dlygate4sd3_1
Xhold1192 _6684_/A _7034_/Q vddd vssd sg13cmos5l_dlygate4sd3_1
Xhold1181 _7211_/D _6516_/X vddd vssd sg13cmos5l_dlygate4sd3_1
Xclkbuf_leaf_36_SCK_regs _7217_/CLK clkload5/A vddd vssd sg13cmos5l_buf_8
XFILLER_5_473 vddd vssd sg13cmos5l_decap_8
XFILLER_9_2228 vddd vssd sg13cmos5l_decap_4
X_4140_ _4140_/Y _7149_/Q _6399_/A _4053_/B vddd vssd sg13cmos5l_a21oi_1
XFILLER_29_1499 vddd vssd sg13cmos5l_decap_8
X_4071_ _4073_/C _4430_/B _6315_/A _4071_/C vddd vssd sg13cmos5l_nor3_1
XFILLER_23_1087 vddd vssd sg13cmos5l_decap_8
XFILLER_17_591 vddd vssd sg13cmos5l_decap_8
X_4973_ _4974_/B _6400_/A _4276_/A _4976_/D vddd vssd sg13cmos5l_a21oi_1
X_6712_ _6712_/Y _6712_/A _6717_/S vddd vssd sg13cmos5l_nor2_1
XFILLER_18_2572 vddd vssd sg13cmos5l_decap_8
X_3924_ _3925_/C _7207_/Q _6503_/A _4123_/A vddd vssd sg13cmos5l_a21oi_1
XFILLER_14_2436 vddd vssd sg13cmos5l_decap_8
X_6643_ _6643_/Y _6643_/A _6650_/S vddd vssd sg13cmos5l_nor2_1
Xclkload9 clkload9/Y clkload9/A vddd vssd sg13cmos5l_inv_4
X_3855_ _3855_/Y _4257_/B sram_odata[4] _3756_/Y wire13/X _4292_/B vddd vssd sg13cmos5l_a221oi_1
X_6574_ _6574_/X _6574_/A0 _6703_/A0 _6575_/S vddd vssd sg13cmos5l_mux2_1
X_3786_ _3786_/Y _3786_/A _4173_/B vddd vssd sg13cmos5l_nand2_1
X_5525_ _5525_/Y _7334_/Q _5540_/B vddd vssd sg13cmos5l_nor2b_1
X_5456_ _5456_/Y _5451_/Y _5452_/X _5455_/Y vddd vssd sg13cmos5l_o21ai_1
X_4407_ _4407_/Y _4407_/A _4407_/B vddd vssd sg13cmos5l_nand2_1
Xfanout202 _6686_/A _6676_/A vddd vssd sg13cmos5l_buf_1
Xfanout213 _6837_/A _6838_/A vddd vssd sg13cmos5l_buf_1
X_5387_ _5387_/Y _5387_/A _5387_/B _5387_/C vddd vssd sg13cmos5l_nor3_1
Xfanout224 _6960_/A _6961_/A vddd vssd sg13cmos5l_buf_1
XFILLER_25_2543 vddd vssd sg13cmos5l_decap_8
X_7126_ _7126_/Q _7127_/CLK _7126_/D fanout398/X vddd vssd sg13cmos5l_dfrbpq_1
X_4338_ _4338_/Y _4319_/B _4337_/Y hold583/X vddd vssd sg13cmos5l_o21ai_1
Xfanout246 _4670_/A _4638_/A vddd vssd sg13cmos5l_buf_1
Xfanout235 _4257_/B _6302_/A vddd vssd sg13cmos5l_buf_1
X_7057_ _7057_/Q _7069_/CLK _7057_/D _6820_/B_N vddd vssd sg13cmos5l_dfrbpq_1
Xfanout279 _5983_/A _7234_/Q vddd vssd sg13cmos5l_buf_1
X_4269_ _7377_/D _6695_/A _5027_/A _4271_/B vddd vssd sg13cmos5l_mux2_1
Xfanout257 _4740_/B _4786_/B vddd vssd sg13cmos5l_buf_1
Xfanout268 _6128_/A2 _6189_/B vddd vssd sg13cmos5l_buf_1
X_6008_ _6008_/Y _3791_/B _5058_/C _5062_/A vddd vssd sg13cmos5l_a21oi_1
XFILLER_3_2383 vddd vssd sg13cmos5l_decap_4
XFILLER_24_21 vddd vssd sg13cmos5l_decap_8
XFILLER_32_2503 vddd vssd sg13cmos5l_decap_8
XFILLER_32_1824 vddd vssd sg13cmos5l_decap_8
XFILLER_24_98 vddd vssd sg13cmos5l_decap_8
XFILLER_13_1201 vddd vssd sg13cmos5l_decap_8
XFILLER_10_288 vddd vssd sg13cmos5l_decap_4
XFILLER_26_1606 vddd vssd sg13cmos5l_decap_4
XFILLER_4_2103 vddd vssd sg13cmos5l_decap_8
Xtiedowns\[34\] dbus_in_right[2] vddd vssd sg13cmos5l_antennanp
XFILLER_24_2053 vddd vssd sg13cmos5l_decap_8
XFILLER_24_1330 vddd vssd sg13cmos5l_decap_8
XFILLER_1_14 vddd vssd sg13cmos5l_decap_8
XFILLER_8_2283 vddd vssd sg13cmos5l_decap_4
XFILLER_24_1363 vddd vssd sg13cmos5l_decap_4
XFILLER_19_856 vddd vssd sg13cmos5l_decap_8
XFILLER_1_69 vddd vssd sg13cmos5l_decap_4
XFILLER_4_1446 vddd vssd sg13cmos5l_decap_4
XFILLER_14_561 vddd vssd sg13cmos5l_decap_8
XFILLER_14_1009 vddd vssd sg13cmos5l_decap_8
X_3640_ _3640_/Y _7081_/Q _7080_/Q vddd vssd sg13cmos5l_nor2b_1
XFILLER_11_1908 vddd vssd sg13cmos5l_decap_4
XFILLER_31_1367 vddd vssd sg13cmos5l_decap_4
X_3571_ _5581_/A _3571_/A vddd vssd sg13cmos5l_inv_1
X_6290_ _6290_/Y _6290_/A _6290_/B vddd vssd sg13cmos5l_nand2_1
X_5310_ _5310_/Y _5307_/Y _5309_/Y _5305_/Y vddd vssd sg13cmos5l_o21ai_1
X_5241_ _5243_/C _5241_/A _5241_/B _5241_/C _5241_/D vddd vssd sg13cmos5l_nand4_1
X_5172_ _5172_/X _6087_/B _5172_/B _5172_/C vddd vssd sg13cmos5l_or3_1
XFILLER_9_2069 vddd vssd sg13cmos5l_decap_4
X_4123_ _4123_/Y _4123_/A _4123_/B _4123_/C _4123_/D vddd vssd sg13cmos5l_nor4_1
X_4054_ _4054_/Y _5316_/A _3966_/Y _4052_/Y _4053_/Y _3817_/Y vddd vssd sg13cmos5l_a221oi_1
XFILLER_20_2451 vddd vssd sg13cmos5l_decap_8
XFILLER_20_1750 vddd vssd sg13cmos5l_decap_8
XFILLER_24_336 vddd vssd sg13cmos5l_decap_8
XFILLER_0_1855 vddd vssd sg13cmos5l_decap_8
X_4956_ _4957_/A _4930_/A _4948_/B _4945_/B _4955_/Y vddd vssd sg13cmos5l_a22oi_1
X_4887_ _4903_/B _4900_/A _4886_/Y _4864_/Y vddd vssd sg13cmos5l_o21ai_1
X_3907_ _3907_/Y _5972_/B _3911_/B _6609_/B vddd vssd sg13cmos5l_nor3_1
X_6626_ _6626_/X _6626_/A0 _6703_/A0 _6627_/B vddd vssd sg13cmos5l_mux2_1
X_3838_ _3838_/Y _3838_/A _3838_/B _3838_/C vddd vssd sg13cmos5l_nand3_1
XFILLER_31_2580 vddd vssd sg13cmos5l_decap_8
X_6557_ _6557_/Y _6564_/A _6562_/S vddd vssd sg13cmos5l_nor2_1
X_3769_ _3772_/B _7050_/Q _4231_/C1 _3768_/X _3718_/Y vddd vssd sg13cmos5l_a22oi_1
XFILLER_3_218 vddd vssd sg13cmos5l_decap_4
X_5508_ _5508_/Y _5508_/A _5508_/B _5508_/C vddd vssd sg13cmos5l_nand3_1
XFILLER_10_23 vddd vssd sg13cmos5l_decap_8
X_6488_ _6488_/Y _6488_/A1 _6487_/B _6487_/Y vddd vssd sg13cmos5l_a21oi_1
X_5439_ _5439_/Y _7331_/Q _5444_/B vddd vssd sg13cmos5l_nor2_1
XFILLER_27_1948 vddd vssd sg13cmos5l_decap_8
XFILLER_9_2570 vddd vssd sg13cmos5l_decap_8
XFILLER_25_2351 vddd vssd sg13cmos5l_decap_8
XFILLER_19_21 vddd vssd sg13cmos5l_decap_8
X_7109_ _7109_/Q _7127_/CLK _7109_/D _6955_/B_N vddd vssd sg13cmos5l_dfrbpq_1
XFILLER_5_2467 vddd vssd sg13cmos5l_decap_8
XFILLER_9_1891 vddd vssd sg13cmos5l_decap_8
XFILLER_19_98 vddd vssd sg13cmos5l_decap_4
XFILLER_5_1788 vddd vssd sg13cmos5l_decap_8
XFILLER_27_196 vddd vssd sg13cmos5l_decap_8
XFILLER_19_2144 vddd vssd sg13cmos5l_decap_4
XFILLER_19_1498 vddd vssd sg13cmos5l_decap_8
XFILLER_15_1318 vddd vssd sg13cmos5l_decap_8
XFILLER_32_2377 vddd vssd sg13cmos5l_decap_8
XFILLER_32_1654 vddd vssd sg13cmos5l_decap_4
XFILLER_13_1020 vddd vssd sg13cmos5l_decap_4
XFILLER_26_2104 vddd vssd sg13cmos5l_decap_8
XFILLER_10_1985 vddd vssd sg13cmos5l_decap_8
XFILLER_25_7 vddd vssd sg13cmos5l_decap_4
XFILLER_20_1046 vddd vssd sg13cmos5l_decap_8
X_4810_ _7327_/D _4633_/A _4810_/A2 _4809_/Y vddd vssd sg13cmos5l_o21ai_1
X_5790_ _5790_/X _5902_/A _7211_/Q vddd vssd sg13cmos5l_or2_1
XFILLER_15_2542 vddd vssd sg13cmos5l_decap_8
X_4741_ _4741_/Y _4740_/B _3601_/Y _4740_/Y vddd vssd sg13cmos5l_a21oi_1
X_4672_ _4672_/Y _4666_/Y _4667_/Y _4671_/Y _4498_/Y vddd vssd sg13cmos5l_a22oi_1
X_3623_ _3623_/Y _3623_/A vddd vssd sg13cmos5l_inv_1
X_6411_ _6411_/X _6404_/A _6411_/A1 _6411_/S vddd vssd sg13cmos5l_mux2_1
XFILLER_11_1716 vddd vssd sg13cmos5l_decap_8
X_7391_ _7391_/Q _7396_/CLK _7391_/D _6903_/Y vddd vssd sg13cmos5l_dfrbpq_1
X_3554_ _5338_/C _3554_/A vddd vssd sg13cmos5l_inv_1
X_6342_ _6342_/Y _6324_/A _6347_/B hold662/X vddd vssd sg13cmos5l_o21ai_1
X_3485_ _4316_/A _4336_/B vddd vssd sg13cmos5l_inv_1
X_6273_ _6274_/B _6273_/A _6273_/B vddd vssd sg13cmos5l_nor2_1
Xoutbuffers\[65\] idac2_value[2] _7041_/Q vddd vssd sg13cmos5l_buf_16
X_5224_ _5225_/D _5219_/A _5219_/B _5217_/A vddd vssd sg13cmos5l_o21ai_1
XFILLER_9_1165 vddd vssd sg13cmos5l_decap_8
X_5155_ _5210_/B _7271_/Q _7270_/Q vddd vssd sg13cmos5l_nand2b_1
XFILLER_22_2546 vddd vssd sg13cmos5l_decap_8
X_5086_ _5088_/C _7263_/Q _7262_/Q _5250_/B vddd vssd sg13cmos5l_nor3_1
X_4106_ _4106_/Y _5163_/B _6563_/A _3901_/A vddd vssd sg13cmos5l_a21oi_1
X_4037_ _4037_/Y _4034_/Y _4035_/Y _4036_/Y vddd vssd sg13cmos5l_o21ai_1
XFILLER_25_612 vddd vssd sg13cmos5l_decap_8
XFILLER_25_645 vddd vssd sg13cmos5l_decap_8
XFILLER_24_133 vddd vssd sg13cmos5l_decap_8
XFILLER_16_2328 vddd vssd sg13cmos5l_decap_8
X_5988_ _5988_/X hold936/X _3750_/C _5994_/S vddd vssd sg13cmos5l_mux2_1
XFILLER_13_818 vddd vssd sg13cmos5l_decap_4
X_4939_ _7307_/D _4939_/A vddd vssd sg13cmos5l_inv_1
XANTENNA_40 _7338_/CLK vddd vssd sg13cmos5l_antennanp
XFILLER_14_2041 vddd vssd sg13cmos5l_decap_4
X_6609_ _6614_/S _6615_/A _6609_/B _6759_/C vddd vssd sg13cmos5l_nor3_1
XANTENNA_51 _5030_/A vddd vssd sg13cmos5l_antennanp
XFILLER_14_2085 vddd vssd sg13cmos5l_decap_8
XFILLER_21_77 vddd vssd sg13cmos5l_decap_8
XFILLER_27_2446 vddd vssd sg13cmos5l_decap_8
XFILLER_25_2181 vddd vssd sg13cmos5l_decap_8
XFILLER_5_1541 vddd vssd sg13cmos5l_decap_8
XFILLER_29_995 vddd vssd sg13cmos5l_decap_8
XFILLER_16_601 vddd vssd sg13cmos5l_decap_8
XFILLER_15_166 vddd vssd sg13cmos5l_decap_8
XFILLER_30_136 vddd vssd sg13cmos5l_decap_8
XFILLER_15_1159 vddd vssd sg13cmos5l_decap_8
XFILLER_7_35 vddd vssd sg13cmos5l_decap_8
XFILLER_12_884 vddd vssd sg13cmos5l_decap_8
XFILLER_11_394 vddd vssd sg13cmos5l_decap_8
XFILLER_32_1495 vddd vssd sg13cmos5l_decap_8
XFILLER_10_2461 vddd vssd sg13cmos5l_decap_8
XFILLER_28_1509 vddd vssd sg13cmos5l_decap_4
XFILLER_10_1760 vddd vssd sg13cmos5l_decap_8
XFILLER_3_571 vddd vssd sg13cmos5l_decap_4
X_6960_ _6960_/Y _6960_/A _6960_/B_N vddd vssd sg13cmos5l_nor2b_1
X_5911_ _5911_/Y _5911_/A _5911_/B _5913_/B _5911_/D vddd vssd sg13cmos5l_nand4_1
X_6891_ _6891_/Y _6910_/A _6910_/B_N vddd vssd sg13cmos5l_nor2b_1
XFILLER_1_1950 vddd vssd sg13cmos5l_decap_8
X_5842_ _5842_/Y _3546_/A _5854_/B _5840_/Y vddd vssd sg13cmos5l_o21ai_1
X_5773_ _5774_/A _7210_/Q _7211_/Q vddd vssd sg13cmos5l_nor2_1
Xoutbuffers\[9\] proj_1v2_ena _7026_/Q vddd vssd sg13cmos5l_buf_16
XFILLER_21_158 vddd vssd sg13cmos5l_decap_8
X_4724_ _4724_/Y _4511_/A _4723_/Y _4769_/A1 vddd vssd sg13cmos5l_a21oi_1
X_4655_ _4656_/B _4435_/A _3605_/Y _4773_/B1 _4651_/B vddd vssd sg13cmos5l_a22oi_1
XFILLER_15_1682 vddd vssd sg13cmos5l_decap_8
XFILLER_11_2258 vddd vssd sg13cmos5l_decap_8
X_4586_ _4587_/B _4608_/A1 _3608_/Y _4794_/B1 _4582_/B vddd vssd sg13cmos5l_a22oi_1
X_3606_ _3606_/Y _3606_/A vddd vssd sg13cmos5l_inv_1
Xhold800 _7124_/D _6354_/X vddd vssd sg13cmos5l_dlygate4sd3_1
X_7374_ _7374_/Q clkload9/A _7374_/D _6887_/Y vddd vssd sg13cmos5l_dfrbpq_1
Xhold811 _7368_/D _4295_/Y vddd vssd sg13cmos5l_dlygate4sd3_1
X_3537_ _5953_/A _3537_/A vddd vssd sg13cmos5l_inv_1
X_6325_ _6325_/Y hold864/X _6324_/B _6324_/Y vddd vssd sg13cmos5l_o21ai_1
Xhold822 hold822/X _7081_/Q vddd vssd sg13cmos5l_dlygate4sd3_1
Xhold833 hold833/X _7085_/Q vddd vssd sg13cmos5l_dlygate4sd3_1
Xhold855 hold855/X _4961_/Y vddd vssd sg13cmos5l_dlygate4sd3_1
Xhold844 _7086_/D _6767_/X vddd vssd sg13cmos5l_dlygate4sd3_1
Xhold866 _5942_/A _6968_/Q vddd vssd sg13cmos5l_dlygate4sd3_1
Xhold888 _6391_/A _7144_/Q vddd vssd sg13cmos5l_dlygate4sd3_1
Xhold877 hold877/X _6350_/Y vddd vssd sg13cmos5l_dlygate4sd3_1
X_3468_ _3468_/Y _3468_/A vddd vssd sg13cmos5l_inv_1
X_6256_ _6256_/Y _6120_/A _5277_/A _6255_/Y vddd vssd sg13cmos5l_o21ai_1
Xhold899 _7348_/D _4410_/Y vddd vssd sg13cmos5l_dlygate4sd3_1
Xhold1500 hold500/A _7015_/Q vddd vssd sg13cmos5l_dlygate4sd3_1
XFILLER_26_2490 vddd vssd sg13cmos5l_decap_8
X_5207_ wire31/A _5207_/A _5207_/B _5207_/C _5207_/D vddd vssd sg13cmos5l_nand4_1
X_6187_ _6188_/B _3518_/Y _7292_/Q _6185_/Y _6186_/Y _5247_/B vddd vssd sg13cmos5l_a221oi_1
XFILLER_6_2540 vddd vssd sg13cmos5l_decap_8
XFILLER_29_214 vddd vssd sg13cmos5l_decap_8
Xhold1522 hold495/A _7005_/Q vddd vssd sg13cmos5l_dlygate4sd3_1
X_5138_ _5141_/C _6073_/A _6065_/B _5138_/C vddd vssd sg13cmos5l_nor3_1
Xhold1511 hold935/A _7299_/Q vddd vssd sg13cmos5l_dlygate4sd3_1
X_5069_ _6194_/C _7273_/Q _7272_/Q vddd vssd sg13cmos5l_nor2b_1
XFILLER_0_2183 vddd vssd sg13cmos5l_decap_8
XFILLER_26_998 vddd vssd sg13cmos5l_decap_8
XFILLER_16_77 vddd vssd sg13cmos5l_decap_8
XFILLER_16_2125 vddd vssd sg13cmos5l_decap_8
XFILLER_9_608 vddd vssd sg13cmos5l_decap_8
XFILLER_32_21 vddd vssd sg13cmos5l_decap_8
XFILLER_16_2158 vddd vssd sg13cmos5l_decap_8
XFILLER_16_1446 vddd vssd sg13cmos5l_decap_8
XFILLER_32_98 vddd vssd sg13cmos5l_decap_8
XFILLER_29_1829 vddd vssd sg13cmos5l_decap_4
XFILLER_5_2050 vddd vssd sg13cmos5l_decap_8
XFILLER_21_1141 vddd vssd sg13cmos5l_decap_8
XFILLER_12_2512 vddd vssd sg13cmos5l_decap_8
XFILLER_16_1980 vddd vssd sg13cmos5l_decap_8
XFILLER_12_692 vddd vssd sg13cmos5l_decap_4
XFILLER_12_1822 vddd vssd sg13cmos5l_decap_8
XFILLER_32_1270 vddd vssd sg13cmos5l_decap_8
X_4440_ _4440_/X _4439_/Y _3493_/A _4440_/S vddd vssd sg13cmos5l_mux2_1
XFILLER_7_184 vddd vssd sg13cmos5l_decap_8
XFILLER_12_2589 vddd vssd sg13cmos5l_decap_8
X_6110_ _6110_/Y _6241_/A _5187_/D _6112_/B vddd vssd sg13cmos5l_a21oi_1
X_4371_ _4390_/A _4545_/A _7126_/Q vddd vssd sg13cmos5l_xnor2_1
X_7090_ _7090_/Q _7100_/CLK _7090_/D fanout413/X vddd vssd sg13cmos5l_dfrbpq_1
X_6041_ _6041_/Y _6041_/A _6041_/B vddd vssd sg13cmos5l_nor2_1
XFILLER_6_1157 vddd vssd sg13cmos5l_decap_8
XFILLER_14_0 vddd vssd sg13cmos5l_decap_8
XFILLER_26_217 vddd vssd sg13cmos5l_decap_8
Xoutbuffers\[28\] voltgen_sink1[1] _7062_/Q vddd vssd sg13cmos5l_buf_16
X_6943_ _6943_/Y _6943_/A _6943_/B_N vddd vssd sg13cmos5l_nor2b_1
X_6874_ _6874_/Y _6910_/A _6892_/B_N vddd vssd sg13cmos5l_nor2b_1
XFILLER_17_2434 vddd vssd sg13cmos5l_decap_8
XFILLER_17_1711 vddd vssd sg13cmos5l_decap_8
X_5825_ _5827_/A _5882_/A _5822_/Y _5824_/Y vddd vssd sg13cmos5l_a21oi_1
XFILLER_22_489 vddd vssd sg13cmos5l_decap_4
Xtiedowns\[0\] sram_odata[0] vddd vssd sg13cmos5l_antennanp
X_5756_ _5762_/C _5769_/B _5769_/A vddd vssd sg13cmos5l_nand2b_1
X_5687_ _5689_/A _5897_/A _7196_/Q _7197_/Q vddd vssd sg13cmos5l_nor3_1
X_4707_ _4714_/C _4737_/A _4707_/B vddd vssd sg13cmos5l_nor2_1
XFILLER_11_2022 vddd vssd sg13cmos5l_decap_8
XFILLER_30_1944 vddd vssd sg13cmos5l_decap_4
X_4638_ _4638_/Y _4638_/A _4800_/A vddd vssd sg13cmos5l_nor2_1
Xhold630 hold630/X _4304_/Y vddd vssd sg13cmos5l_dlygate4sd3_1
X_7357_ _7357_/Q _7378_/CLK _7357_/D _6870_/Y vddd vssd sg13cmos5l_dfrbpq_1
X_4569_ _4569_/Y _4542_/B _4577_/B _4594_/A1 vddd vssd sg13cmos5l_o21ai_1
Xhold641 _7370_/D _4284_/Y vddd vssd sg13cmos5l_dlygate4sd3_1
Xhold652 _4848_/A _3506_/Y vddd vssd sg13cmos5l_dlygate4sd3_1
Xhold663 _7118_/D _6342_/Y vddd vssd sg13cmos5l_dlygate4sd3_1
XFILLER_28_2574 vddd vssd sg13cmos5l_decap_8
XFILLER_28_1840 vddd vssd sg13cmos5l_decap_8
Xhold685 _3505_/A _7322_/Q vddd vssd sg13cmos5l_dlygate4sd3_1
X_7288_ _7288_/Q _7292_/CLK _7288_/D _6829_/B_N vddd vssd sg13cmos5l_dfrbpq_1
X_6308_ _6308_/Y hold805/X _6311_/B _6307_/Y vddd vssd sg13cmos5l_o21ai_1
Xhold674 _7255_/D _6594_/X vddd vssd sg13cmos5l_dlygate4sd3_1
Xhold696 hold696/X _6362_/Y vddd vssd sg13cmos5l_dlygate4sd3_1
XFILLER_28_1873 vddd vssd sg13cmos5l_decap_8
XFILLER_24_1704 vddd vssd sg13cmos5l_decap_8
X_6239_ _6239_/Y _6239_/A1 _6237_/Y _6213_/Y vddd vssd sg13cmos5l_a21oi_1
XFILLER_6_2370 vddd vssd sg13cmos5l_decap_8
Xhold1330 _3517_/A _7309_/Q vddd vssd sg13cmos5l_dlygate4sd3_1
Xhold1352 _7366_/D _4300_/X vddd vssd sg13cmos5l_dlygate4sd3_1
Xhold1341 _6649_/A0 _7289_/Q vddd vssd sg13cmos5l_dlygate4sd3_1
Xhold1385 _6479_/A1 _5651_/B vddd vssd sg13cmos5l_dlygate4sd3_1
XFILLER_27_21 vddd vssd sg13cmos5l_decap_8
Xhold1363 _4917_/A1 _5813_/A vddd vssd sg13cmos5l_dlygate4sd3_1
Xhold1374 _7202_/D _6500_/X vddd vssd sg13cmos5l_dlygate4sd3_1
Xhold1396 hold1396/X _7142_/Q vddd vssd sg13cmos5l_dlygate4sd3_1
XFILLER_27_98 vddd vssd sg13cmos5l_decap_8
XFILLER_14_902 vddd vssd sg13cmos5l_decap_8
XFILLER_18_1519 vddd vssd sg13cmos5l_decap_4
XFILLER_13_456 vddd vssd sg13cmos5l_decap_4
Xtiedowns\[64\] mask_rev_in[20] vddd vssd sg13cmos5l_antennanp
XFILLER_4_14 vddd vssd sg13cmos5l_decap_8
XFILLER_27_2040 vddd vssd sg13cmos5l_decap_4
XFILLER_27_1383 vddd vssd sg13cmos5l_decap_8
XFILLER_7_2167 vddd vssd sg13cmos5l_decap_8
XFILLER_23_1225 vddd vssd sg13cmos5l_decap_4
X_3940_ _3940_/Y _7183_/Q _6459_/A _6450_/A vddd vssd sg13cmos5l_a21oi_1
Xoutbuffers\[118\] dbus_out[21] _5916_/Y vddd vssd sg13cmos5l_buf_16
XFILLER_32_754 vddd vssd sg13cmos5l_decap_8
X_3871_ _3872_/D _7279_/Q wire99/X _3868_/Y vddd vssd sg13cmos5l_a21oi_1
X_5610_ _5623_/A _5621_/B _5610_/B vddd vssd sg13cmos5l_nor2_1
XFILLER_14_1917 vddd vssd sg13cmos5l_decap_8
X_6590_ _6590_/Y _6590_/A _6594_/S vddd vssd sg13cmos5l_nor2_1
X_5541_ _5541_/Y _5372_/A _5539_/Y _5540_/Y vddd vssd sg13cmos5l_a21oi_1
XFILLER_9_972 vddd vssd sg13cmos5l_decap_8
X_7211_ _7211_/Q _7217_/CLK _7211_/D fanout372/X vddd vssd sg13cmos5l_dfrbpq_1
X_5472_ _5476_/B _5649_/A1 _7167_/Q _5471_/Y vddd vssd sg13cmos5l_o21ai_1
X_4423_ _4482_/B _4435_/A _4460_/A vddd vssd sg13cmos5l_nor2b_1
X_7142_ _7142_/Q _7143_/CLK _7142_/D fanout362/X vddd vssd sg13cmos5l_dfrbpq_1
X_4354_ _4354_/Y _4351_/Y _4352_/Y _4353_/Y vddd vssd sg13cmos5l_o21ai_1
Xfanout417 fanout417/X fanout418/X vddd vssd sg13cmos5l_buf_1
Xfanout406 _6949_/B_N _6952_/B_N vddd vssd sg13cmos5l_buf_1
X_7073_ _7073_/Q _7108_/CLK _7073_/D fanout399/X vddd vssd sg13cmos5l_dfrbpq_1
Xfanout428 _5532_/A _5727_/A vddd vssd sg13cmos5l_buf_1
Xfanout439 _6233_/A io_in[3] vddd vssd sg13cmos5l_buf_1
X_6024_ _6025_/B _4019_/Y _6023_/D _6023_/Y vddd vssd sg13cmos5l_o21ai_1
X_4285_ _4285_/Y _4308_/A _4298_/A _4285_/C _4301_/A vddd vssd sg13cmos5l_nor4_1
XFILLER_23_2460 vddd vssd sg13cmos5l_decap_8
Xclkbuf_leaf_6_SCK_regs _7180_/CLK clkload4/A vddd vssd sg13cmos5l_buf_8
XFILLER_27_504 vddd vssd sg13cmos5l_decap_8
XFILLER_3_2576 vddd vssd sg13cmos5l_decap_8
XFILLER_3_2587 vddd vssd sg13cmos5l_decap_8
X_6926_ _6926_/Y _6943_/A _6943_/B_N vddd vssd sg13cmos5l_nor2b_1
XFILLER_23_743 vddd vssd sg13cmos5l_decap_8
Xfanout24 _4811_/B _4488_/Y vddd vssd sg13cmos5l_buf_1
X_6857_ _6857_/Y _6857_/A _6860_/B_N vddd vssd sg13cmos5l_nor2b_1
Xfanout35 _4696_/A fanout39/X vddd vssd sg13cmos5l_buf_1
Xfanout46 _6311_/B _6788_/B vddd vssd sg13cmos5l_buf_1
Xfanout79 _4085_/B _3787_/X vddd vssd sg13cmos5l_buf_1
XFILLER_17_1541 vddd vssd sg13cmos5l_decap_8
Xfanout57 _6480_/A _3929_/Y vddd vssd sg13cmos5l_buf_1
X_6788_ _6788_/Y _6788_/A _6788_/B vddd vssd sg13cmos5l_nand2_1
X_5808_ _5808_/Y _5897_/A _7212_/Q _7213_/Q vddd vssd sg13cmos5l_nor3_1
XFILLER_10_404 vddd vssd sg13cmos5l_decap_8
Xfanout68 _6650_/S _6651_/S vddd vssd sg13cmos5l_buf_1
XFILLER_30_2431 vddd vssd sg13cmos5l_decap_8
XFILLER_13_2139 vddd vssd sg13cmos5l_decap_8
X_5739_ _5739_/X _5739_/A _5739_/B vddd vssd sg13cmos5l_and2_1
XFILLER_13_56 vddd vssd sg13cmos5l_decap_8
XFILLER_28_2371 vddd vssd sg13cmos5l_decap_8
Xhold482 _4863_/A hold482/A vddd vssd sg13cmos5l_dlygate4sd3_1
Xhold493 sram_addr[6] _5993_/X vddd vssd sg13cmos5l_dlygate4sd3_1
XFILLER_28_1670 vddd vssd sg13cmos5l_decap_4
XFILLER_8_2476 vddd vssd sg13cmos5l_decap_8
XFILLER_28_1692 vddd vssd sg13cmos5l_decap_8
XFILLER_24_1523 vddd vssd sg13cmos5l_decap_8
XFILLER_8_1786 vddd vssd sg13cmos5l_decap_4
Xhold1160 _6619_/A1 _5077_/B vddd vssd sg13cmos5l_dlygate4sd3_1
Xhold1193 _6685_/B1 _6684_/Y vddd vssd sg13cmos5l_dlygate4sd3_1
Xhold1171 _6600_/A1 _4981_/B vddd vssd sg13cmos5l_dlygate4sd3_1
Xhold1182 _6434_/A1 _7167_/Q vddd vssd sg13cmos5l_dlygate4sd3_1
XFILLER_14_776 vddd vssd sg13cmos5l_decap_8
XFILLER_13_1972 vddd vssd sg13cmos5l_decap_8
XFILLER_9_1517 vddd vssd sg13cmos5l_decap_4
X_4070_ _4073_/B _3599_/Y _3803_/B _4068_/Y _4069_/Y _3990_/B vddd vssd sg13cmos5l_a221oi_1
XFILLER_3_1105 vddd vssd sg13cmos5l_decap_4
XFILLER_7_1274 vddd vssd sg13cmos5l_decap_8
X_4972_ _4975_/A _5024_/A _4976_/D vddd vssd sg13cmos5l_nor2_1
X_6711_ _6717_/S _6711_/A _6733_/B vddd vssd sg13cmos5l_nor2_1
XFILLER_18_2551 vddd vssd sg13cmos5l_decap_8
X_3923_ _4122_/B _6503_/A vddd vssd sg13cmos5l_inv_1
XFILLER_20_724 vddd vssd sg13cmos5l_decap_8
X_3854_ wire13/A _3997_/A _3854_/B vddd vssd sg13cmos5l_nand2_1
X_6642_ _6651_/S _6642_/A _6667_/B vddd vssd sg13cmos5l_and2_1
X_6573_ _6573_/Y _6573_/A1 _6575_/S _6572_/Y vddd vssd sg13cmos5l_o21ai_1
X_3785_ _3785_/Y _3783_/Y _3784_/Y hold595/X vddd vssd sg13cmos5l_o21ai_1
Xoutbuffers\[95\] io_out[10] _6259_/X vddd vssd sg13cmos5l_buf_16
X_5524_ _5539_/C _7172_/Q _7173_/Q vddd vssd sg13cmos5l_nand2_1
XFILLER_12_2183 vddd vssd sg13cmos5l_decap_8
X_5455_ _5455_/Y _5372_/A _5453_/Y _5454_/Y vddd vssd sg13cmos5l_a21oi_1
X_4406_ _4406_/X _4403_/A _4403_/C _4403_/B vddd vssd sg13cmos5l_a21o_1
XFILLER_12_1493 vddd vssd sg13cmos5l_decap_8
XFILLER_25_2522 vddd vssd sg13cmos5l_decap_8
X_7125_ _7125_/Q _7125_/CLK _7125_/D fanout395/X vddd vssd sg13cmos5l_dfrbpq_1
Xfanout214 _6838_/A _6906_/A vddd vssd sg13cmos5l_buf_1
X_5386_ _5387_/C _5372_/A _7153_/Q _5385_/Y vddd vssd sg13cmos5l_a21oi_1
Xfanout203 _6470_/A _6520_/A vddd vssd sg13cmos5l_buf_1
Xfanout247 _4638_/A _7334_/Q vddd vssd sg13cmos5l_buf_1
Xfanout225 _6961_/A _6857_/A vddd vssd sg13cmos5l_buf_1
X_4337_ _4337_/Y _4333_/B _4344_/B _4318_/B vddd vssd sg13cmos5l_a21oi_1
Xfanout236 _6302_/A hold1001/X vddd vssd sg13cmos5l_buf_1
XFILLER_25_2599 vddd vssd sg13cmos5l_decap_8
X_7056_ _7056_/Q _7060_/CLK _7056_/D _6820_/B_N vddd vssd sg13cmos5l_dfrbpq_1
Xfanout269 _6189_/B _6258_/C1 vddd vssd sg13cmos5l_buf_1
X_4268_ _7378_/D _5027_/A _5028_/A _4271_/B vddd vssd sg13cmos5l_mux2_1
Xfanout258 _4786_/B _4815_/B vddd vssd sg13cmos5l_buf_1
XFILLER_25_1865 vddd vssd sg13cmos5l_decap_8
X_6007_ _6007_/Y _5060_/C _6005_/Y _6006_/Y vddd vssd sg13cmos5l_o21ai_1
XFILLER_28_835 vddd vssd sg13cmos5l_decap_8
X_4199_ _4199_/Y _5963_/A _6556_/A _6548_/A vddd vssd sg13cmos5l_a21oi_1
X_6909_ _6909_/Y _6909_/A _6909_/B_N vddd vssd sg13cmos5l_nor2b_1
XFILLER_32_2559 vddd vssd sg13cmos5l_decap_8
XFILLER_32_1803 vddd vssd sg13cmos5l_decap_8
XFILLER_24_77 vddd vssd sg13cmos5l_decap_8
XFILLER_7_706 vddd vssd sg13cmos5l_decap_8
XFILLER_24_2021 vddd vssd sg13cmos5l_decap_8
Xtiedowns\[27\] dbus_in_left[7] vddd vssd sg13cmos5l_antennanp
XFILLER_24_1386 vddd vssd sg13cmos5l_decap_8
XFILLER_19_835 vddd vssd sg13cmos5l_decap_8
XFILLER_1_48 vddd vssd sg13cmos5l_decap_8
X_3570_ _5552_/B _3570_/A vddd vssd sg13cmos5l_inv_1
XFILLER_6_750 vddd vssd sg13cmos5l_decap_8
X_5240_ _5241_/D _5240_/A _5240_/B _5274_/A vddd vssd sg13cmos5l_or3_1
XFILLER_9_2048 vddd vssd sg13cmos5l_decap_8
XFILLER_29_1264 vddd vssd sg13cmos5l_decap_8
X_5171_ _5172_/C _5171_/A _5171_/B _5171_/C vddd vssd sg13cmos5l_nand3_1
XFILLER_9_1325 vddd vssd sg13cmos5l_decap_8
X_4122_ _4123_/D _5753_/B _4122_/B vddd vssd sg13cmos5l_nor2_1
X_4053_ _4053_/Y _5338_/C _4053_/B vddd vssd sg13cmos5l_nand2_1
XFILLER_0_2535 vddd vssd sg13cmos5l_decap_8
XFILLER_24_304 vddd vssd sg13cmos5l_decap_8
XFILLER_0_1834 vddd vssd sg13cmos5l_decap_8
XFILLER_4_1992 vddd vssd sg13cmos5l_decap_4
Xoutbuffers\[10\] proj_3v3_ena _7025_/Q vddd vssd sg13cmos5l_buf_16
X_4955_ _4955_/Y _4955_/A _4955_/B vddd vssd sg13cmos5l_nor2_1
X_3906_ _6548_/A _3948_/A _3911_/B vddd vssd sg13cmos5l_nor2_1
XFILLER_32_392 vddd vssd sg13cmos5l_decap_8
XFILLER_20_510 vddd vssd sg13cmos5l_decap_8
XFILLER_18_2381 vddd vssd sg13cmos5l_decap_4
X_4886_ _4886_/Y _4932_/A _7137_/Q _4871_/Y _4884_/Y _4885_/Y vddd vssd sg13cmos5l_a221oi_1
X_6625_ _6625_/X _6625_/A0 _6625_/A1 _6627_/B vddd vssd sg13cmos5l_mux2_1
X_3837_ _3838_/C _7126_/Q _4156_/A _4242_/A2 vddd vssd sg13cmos5l_a21oi_1
XFILLER_14_1511 vddd vssd sg13cmos5l_decap_8
X_3768_ _3768_/X dbus_in_left[6] dbus_in_right[6] vddd vssd sg13cmos5l_or2_1
X_6556_ _6562_/S _6556_/A _6667_/B vddd vssd sg13cmos5l_nand2_1
XFILLER_10_1408 vddd vssd sg13cmos5l_decap_8
X_5507_ _5508_/C _5507_/A _5507_/B vddd vssd sg13cmos5l_nand2_1
X_6487_ _6487_/Y _6501_/A _6487_/B vddd vssd sg13cmos5l_nor2_1
X_3699_ _3954_/A _3749_/B _3738_/B vddd vssd sg13cmos5l_nand2b_1
XFILLER_12_1290 vddd vssd sg13cmos5l_decap_4
XFILLER_10_79 vddd vssd sg13cmos5l_decap_8
X_5438_ _5453_/C _7160_/Q _7161_/Q vddd vssd sg13cmos5l_nand2_1
XFILLER_0_937 vddd vssd sg13cmos5l_decap_4
X_5369_ _5369_/Y _5369_/A _5369_/B _5369_/C vddd vssd sg13cmos5l_nand3_1
X_7108_ _7108_/Q _7108_/CLK _7108_/D _6955_/B_N vddd vssd sg13cmos5l_dfrbpq_1
XFILLER_5_2435 vddd vssd sg13cmos5l_decap_8
XFILLER_25_2396 vddd vssd sg13cmos5l_decap_8
X_7039_ _7039_/Q _7066_/CLK _7039_/D _6838_/B_N vddd vssd sg13cmos5l_dfrbpq_1
XFILLER_19_77 vddd vssd sg13cmos5l_decap_8
XFILLER_5_1767 vddd vssd sg13cmos5l_decap_8
XFILLER_28_698 vddd vssd sg13cmos5l_decap_8
XFILLER_27_175 vddd vssd sg13cmos5l_decap_8
XFILLER_19_2123 vddd vssd sg13cmos5l_decap_8
XFILLER_32_2356 vddd vssd sg13cmos5l_decap_8
XFILLER_32_1633 vddd vssd sg13cmos5l_decap_8
XFILLER_7_503 vddd vssd sg13cmos5l_decap_8
Xclkbuf_3_3_0_clk_regs clkbuf_3_3_0_clk_regs/X clkbuf_0_clk_regs/X vddd vssd sg13cmos5l_buf_8
XFILLER_18_7 vddd vssd sg13cmos5l_decap_8
XFILLER_19_698 vddd vssd sg13cmos5l_decap_8
Xclkbuf_leaf_20_SCK_regs _7275_/CLK clkload7/A vddd vssd sg13cmos5l_buf_8
Xoutbuffers\[100\] dbus_out[3] _5403_/Y vddd vssd sg13cmos5l_buf_16
XFILLER_15_2521 vddd vssd sg13cmos5l_decap_8
X_4740_ _4740_/Y _4740_/A _4740_/B vddd vssd sg13cmos5l_nor2_1
X_4671_ _4671_/Y _4671_/A _4671_/B vddd vssd sg13cmos5l_nand2_1
X_3622_ _3622_/Y _3622_/A vddd vssd sg13cmos5l_inv_1
XFILLER_15_2598 vddd vssd sg13cmos5l_decap_8
X_7390_ SDO _7390_/CLK _7390_/D _6800_/Y vddd vssd sg13cmos5l_dfrbpq_1
X_6410_ _6410_/X _6715_/A _6410_/A1 _6411_/S vddd vssd sg13cmos5l_mux2_1
X_6341_ _6341_/Y _6341_/A _6347_/B vddd vssd sg13cmos5l_nand2_1
X_3553_ _5332_/B _3553_/A vddd vssd sg13cmos5l_inv_1
X_3484_ _3484_/Y _4310_/A vddd vssd sg13cmos5l_inv_1
X_6272_ _6273_/B _3820_/X _6270_/A _4996_/C vddd vssd sg13cmos5l_o21ai_1
X_5223_ _5226_/B _7291_/Q _5223_/B _6151_/B _5223_/D vddd vssd sg13cmos5l_nor4_1
XFILLER_9_1111 vddd vssd sg13cmos5l_decap_8
X_5154_ _5169_/C _7244_/Q _7245_/Q _5213_/B vddd vssd sg13cmos5l_nor3_1
Xoutbuffers\[58\] voltgen_value[2] _7050_/Q vddd vssd sg13cmos5l_buf_16
XFILLER_22_2525 vddd vssd sg13cmos5l_decap_8
XFILLER_5_1008 vddd vssd sg13cmos5l_decap_4
X_4105_ _4105_/Y _4017_/B _4103_/Y _4104_/Y vddd vssd sg13cmos5l_o21ai_1
XFILLER_22_1835 vddd vssd sg13cmos5l_decap_8
X_5085_ _5250_/B _7260_/Q _5085_/B vddd vssd sg13cmos5l_nand2_1
X_4036_ _4036_/Y _5701_/B _6489_/A _6480_/A vddd vssd sg13cmos5l_a21oi_1
XFILLER_25_624 vddd vssd sg13cmos5l_decap_8
XFILLER_0_2354 vddd vssd sg13cmos5l_decap_8
XFILLER_24_112 vddd vssd sg13cmos5l_decap_8
XFILLER_20_1581 vddd vssd sg13cmos5l_decap_4
XFILLER_20_1570 vddd vssd sg13cmos5l_decap_8
XFILLER_16_2318 vddd vssd sg13cmos5l_decap_4
X_5987_ _5987_/X hold895/X _3750_/D _5994_/S vddd vssd sg13cmos5l_mux2_1
XFILLER_24_189 vddd vssd sg13cmos5l_decap_8
XFILLER_21_830 vddd vssd sg13cmos5l_decap_8
X_4938_ _4938_/Y _4863_/A _4958_/B _4945_/B _4937_/Y vddd vssd sg13cmos5l_a22oi_1
XFILLER_16_1628 vddd vssd sg13cmos5l_decap_8
XANTENNA_41 _7338_/CLK vddd vssd sg13cmos5l_antennanp
X_4869_ _4871_/B _4951_/A _7135_/Q vddd vssd sg13cmos5l_nor2_1
XANTENNA_30 _6773_/C vddd vssd sg13cmos5l_antennanp
X_6608_ _6608_/X _6608_/A0 _6743_/A _6608_/S vddd vssd sg13cmos5l_mux2_1
XANTENNA_52 _5329_/A vddd vssd sg13cmos5l_antennanp
XFILLER_21_56 vddd vssd sg13cmos5l_decap_8
X_6539_ _7223_/D _6546_/A _6539_/A1 _6539_/S vddd vssd sg13cmos5l_mux2_1
XFILLER_27_2425 vddd vssd sg13cmos5l_decap_8
XFILLER_27_1713 vddd vssd sg13cmos5l_decap_8
XFILLER_7_2519 vddd vssd sg13cmos5l_decap_8
XFILLER_21_2046 vddd vssd sg13cmos5l_decap_8
XFILLER_29_974 vddd vssd sg13cmos5l_decap_8
XFILLER_1_2129 vddd vssd sg13cmos5l_decap_4
XFILLER_21_1378 vddd vssd sg13cmos5l_decap_8
XFILLER_16_657 vddd vssd sg13cmos5l_decap_8
XFILLER_15_178 vddd vssd sg13cmos5l_decap_8
XFILLER_30_115 vddd vssd sg13cmos5l_decap_8
XFILLER_19_1274 vddd vssd sg13cmos5l_decap_8
XFILLER_12_863 vddd vssd sg13cmos5l_decap_8
XFILLER_7_14 vddd vssd sg13cmos5l_decap_8
XFILLER_32_1452 vddd vssd sg13cmos5l_decap_4
XFILLER_7_355 vddd vssd sg13cmos5l_decap_8
XFILLER_10_2440 vddd vssd sg13cmos5l_decap_8
XFILLER_19_451 vddd vssd sg13cmos5l_decap_8
X_5910_ _5911_/D _6233_/A _5910_/B _5910_/C _5910_/D vddd vssd sg13cmos5l_nand4_1
X_6890_ _6890_/Y _6910_/A _6892_/B_N vddd vssd sg13cmos5l_nor2b_1
XFILLER_22_605 vddd vssd sg13cmos5l_decap_8
X_5841_ _5841_/Y _5899_/A _5841_/B _5854_/A vddd vssd sg13cmos5l_nor3_1
X_5772_ _5772_/Y _5916_/A1 _5743_/Y _5771_/Y vddd vssd sg13cmos5l_a21oi_1
X_4723_ _4723_/Y _4696_/A _4718_/Y _4722_/Y vddd vssd sg13cmos5l_o21ai_1
XFILLER_15_2384 vddd vssd sg13cmos5l_decap_8
XFILLER_11_2226 vddd vssd sg13cmos5l_decap_8
X_4654_ _4657_/B _4774_/B _4654_/B vddd vssd sg13cmos5l_nor2_1
XFILLER_15_1661 vddd vssd sg13cmos5l_decap_8
X_3605_ _3605_/Y _7106_/Q vddd vssd sg13cmos5l_inv_1
X_4585_ _4588_/B _4807_/A _4585_/B vddd vssd sg13cmos5l_nor2_1
Xhold801 _4855_/B _7318_/Q vddd vssd sg13cmos5l_dlygate4sd3_1
X_7373_ _7373_/Q clkload9/A _7373_/D _6886_/Y vddd vssd sg13cmos5l_dfrbpq_1
Xhold812 _3510_/A _7316_/Q vddd vssd sg13cmos5l_dlygate4sd3_1
XFILLER_11_1525 vddd vssd sg13cmos5l_decap_8
X_3536_ _3536_/Y _3536_/A vddd vssd sg13cmos5l_inv_1
X_6324_ _6324_/Y _6324_/A _6324_/B vddd vssd sg13cmos5l_nand2_1
Xhold845 _3556_/A _7148_/Q vddd vssd sg13cmos5l_dlygate4sd3_1
Xhold823 _7081_/D _6758_/X vddd vssd sg13cmos5l_dlygate4sd3_1
Xhold834 _7085_/D _6766_/X vddd vssd sg13cmos5l_dlygate4sd3_1
Xhold867 _5943_/B _5941_/Y vddd vssd sg13cmos5l_dlygate4sd3_1
Xhold889 hold889/X _6391_/Y vddd vssd sg13cmos5l_dlygate4sd3_1
X_6255_ _6255_/Y _5277_/A _6254_/X _5279_/B vddd vssd sg13cmos5l_a21oi_1
Xhold878 _4279_/B _3659_/C vddd vssd sg13cmos5l_dlygate4sd3_1
Xhold856 _7300_/D _4963_/Y vddd vssd sg13cmos5l_dlygate4sd3_1
X_3467_ _3467_/Y _3467_/A vddd vssd sg13cmos5l_inv_1
X_5206_ _5207_/D _5206_/A _5206_/B _5206_/C _5206_/D vddd vssd sg13cmos5l_nor4_1
Xhold1501 hold498/A _7001_/Q vddd vssd sg13cmos5l_dlygate4sd3_1
X_6186_ _6186_/Y _4194_/X _5243_/B _7292_/Q vddd vssd sg13cmos5l_a21oi_1
Xhold1523 _5928_/A1 _6970_/Q vddd vssd sg13cmos5l_dlygate4sd3_1
Xhold1512 hold957/A _7302_/Q vddd vssd sg13cmos5l_dlygate4sd3_1
X_5137_ _5138_/C _6065_/C _5137_/B vddd vssd sg13cmos5l_nand2_1
XFILLER_26_1790 vddd vssd sg13cmos5l_decap_8
XFILLER_2_2438 vddd vssd sg13cmos5l_decap_8
X_5068_ _5089_/A _7238_/Q _7239_/Q _5257_/B vddd vssd sg13cmos5l_nor3_1
X_4019_ _4019_/Y dbus_in_left[10] dbus_in_right[10] vddd vssd sg13cmos5l_nor2_1
XFILLER_22_1676 vddd vssd sg13cmos5l_decap_8
XFILLER_26_977 vddd vssd sg13cmos5l_decap_8
XFILLER_16_56 vddd vssd sg13cmos5l_decap_8
XFILLER_13_638 vddd vssd sg13cmos5l_decap_4
XFILLER_16_1436 vddd vssd sg13cmos5l_decap_4
XFILLER_32_77 vddd vssd sg13cmos5l_decap_8
XFILLER_21_693 vddd vssd sg13cmos5l_decap_8
XFILLER_29_1808 vddd vssd sg13cmos5l_decap_8
XFILLER_10_1035 vddd vssd sg13cmos5l_decap_8
XFILLER_4_369 vddd vssd sg13cmos5l_decap_8
XFILLER_0_553 vddd vssd sg13cmos5l_decap_8
XFILLER_23_1429 vddd vssd sg13cmos5l_decap_4
XFILLER_7_1659 vddd vssd sg13cmos5l_decap_8
XFILLER_21_1120 vddd vssd sg13cmos5l_decap_8
XFILLER_5_1350 vddd vssd sg13cmos5l_decap_8
XFILLER_21_1164 vddd vssd sg13cmos5l_decap_8
XFILLER_17_999 vddd vssd sg13cmos5l_decap_8
XFILLER_16_454 vddd vssd sg13cmos5l_decap_8
XFILLER_16_487 vddd vssd sg13cmos5l_decap_8
XFILLER_12_2568 vddd vssd sg13cmos5l_decap_8
X_4370_ _4387_/A _7336_/Q _7124_/Q vddd vssd sg13cmos5l_xnor2_1
XFILLER_4_881 vddd vssd sg13cmos5l_decap_8
X_6040_ _6040_/Y _6038_/Y _6039_/X _6022_/Y vddd vssd sg13cmos5l_o21ai_1
XFILLER_6_1114 vddd vssd sg13cmos5l_decap_4
XFILLER_27_708 vddd vssd sg13cmos5l_decap_4
X_6942_ _6942_/Y _6949_/A _6952_/B_N vddd vssd sg13cmos5l_nor2b_1
X_6873_ _6873_/Y _6909_/A _6892_/B_N vddd vssd sg13cmos5l_nor2b_1
XFILLER_23_947 vddd vssd sg13cmos5l_decap_8
X_5824_ _5824_/Y _3548_/A _5807_/Y _5810_/Y _5821_/Y _5822_/Y vddd vssd sg13cmos5l_a221oi_1
X_5755_ _5755_/Y _5753_/Y _5754_/Y _5766_/C vddd vssd sg13cmos5l_o21ai_1
X_5686_ _5711_/C _7196_/Q _5695_/B vddd vssd sg13cmos5l_nand2_1
X_4706_ _4706_/Y _4814_/A1 _3602_/Y _4773_/B1 _4705_/X vddd vssd sg13cmos5l_a22oi_1
XFILLER_30_1923 vddd vssd sg13cmos5l_decap_8
X_4637_ _4637_/X _4612_/B _4636_/Y _4745_/B1 vddd vssd sg13cmos5l_a21o_1
Xhold620 _4344_/A _7354_/Q vddd vssd sg13cmos5l_dlygate4sd3_1
X_7356_ _7356_/Q _7378_/CLK _7356_/D _6869_/Y vddd vssd sg13cmos5l_dfrbpq_1
Xhold642 _6774_/A _7090_/Q vddd vssd sg13cmos5l_dlygate4sd3_1
X_4568_ _4577_/B _4599_/A _4568_/B vddd vssd sg13cmos5l_nor2_1
Xhold631 _7364_/D _4305_/Y vddd vssd sg13cmos5l_dlygate4sd3_1
Xhold653 _7321_/D _4850_/Y vddd vssd sg13cmos5l_dlygate4sd3_1
XFILLER_28_2553 vddd vssd sg13cmos5l_decap_8
Xhold675 _6778_/A _7092_/Q vddd vssd sg13cmos5l_dlygate4sd3_1
X_7287_ _7287_/Q _7287_/CLK _7287_/D fanout386/X vddd vssd sg13cmos5l_dfrbpq_1
Xhold686 _4845_/A _3505_/Y vddd vssd sg13cmos5l_dlygate4sd3_1
Xhold697 _4829_/A _7396_/Q vddd vssd sg13cmos5l_dlygate4sd3_1
Xhold664 _6756_/A _7080_/Q vddd vssd sg13cmos5l_dlygate4sd3_1
X_4499_ _4499_/Y _4499_/A vddd vssd sg13cmos5l_inv_1
X_6307_ _6307_/Y _6324_/A _6311_/B vddd vssd sg13cmos5l_nand2_1
X_3519_ _3519_/Y _7120_/Q vddd vssd sg13cmos5l_inv_1
X_6238_ _6238_/Y io_in[2] _6235_/B _6236_/Y vddd vssd sg13cmos5l_o21ai_1
XFILLER_28_1885 vddd vssd sg13cmos5l_decap_4
X_6169_ _6169_/Y _4577_/A _4979_/A _6189_/B vddd vssd sg13cmos5l_a21oi_1
XFILLER_8_1957 vddd vssd sg13cmos5l_decap_8
Xhold1320 _6694_/A0 _7040_/Q vddd vssd sg13cmos5l_dlygate4sd3_1
Xhold1331 _4921_/A1 _3517_/Y vddd vssd sg13cmos5l_dlygate4sd3_1
Xhold1342 _7289_/D _6649_/X vddd vssd sg13cmos5l_dlygate4sd3_1
Xhold1375 hold1375/X _7276_/Q vddd vssd sg13cmos5l_dlygate4sd3_1
Xhold1386 _7191_/D _6479_/X vddd vssd sg13cmos5l_dlygate4sd3_1
Xhold1364 _3512_/A _7314_/Q vddd vssd sg13cmos5l_dlygate4sd3_1
Xhold1353 hold683/A _7398_/Q vddd vssd sg13cmos5l_dlygate4sd3_1
Xhold1397 _6388_/A0 _5316_/A vddd vssd sg13cmos5l_dlygate4sd3_1
XFILLER_27_77 vddd vssd sg13cmos5l_decap_8
XFILLER_26_785 vddd vssd sg13cmos5l_decap_8
XFILLER_13_435 vddd vssd sg13cmos5l_decap_8
XFILLER_5_689 vddd vssd sg13cmos5l_decap_8
Xtiedowns\[57\] mask_rev_in[13] vddd vssd sg13cmos5l_antennanp
XFILLER_27_1340 vddd vssd sg13cmos5l_decap_8
XFILLER_23_1204 vddd vssd sg13cmos5l_decap_8
XFILLER_0_394 vddd vssd sg13cmos5l_decap_8
XFILLER_7_1489 vddd vssd sg13cmos5l_decap_8
XFILLER_16_251 vddd vssd sg13cmos5l_decap_8
XFILLER_32_733 vddd vssd sg13cmos5l_decap_8
X_3870_ _6629_/A _3896_/A _3937_/A vddd vssd sg13cmos5l_nand2_1
XFILLER_20_928 vddd vssd sg13cmos5l_decap_8
X_5540_ _5540_/Y _5540_/A _5540_/B _5540_/C vddd vssd sg13cmos5l_nor3_1
XFILLER_16_2490 vddd vssd sg13cmos5l_decap_8
XFILLER_30_1219 vddd vssd sg13cmos5l_decap_4
X_5471_ _5471_/Y _6041_/A _7167_/Q _5481_/C vddd vssd sg13cmos5l_a21oi_1
X_7210_ _7210_/Q _7218_/CLK _7210_/D fanout371/X vddd vssd sg13cmos5l_dfrbpq_1
X_4422_ _4422_/Y _4403_/A _4421_/A _4421_/Y vddd vssd sg13cmos5l_a21oi_1
XFILLER_12_1664 vddd vssd sg13cmos5l_decap_8
X_7141_ _7141_/Q _7187_/CLK _7141_/D fanout362/X vddd vssd sg13cmos5l_dfrbpq_1
X_4353_ _4353_/Y _7084_/Q _4416_/A _4397_/A _7083_/Q vddd vssd sg13cmos5l_a22oi_1
Xfanout418 fanout418/X porb vddd vssd sg13cmos5l_buf_1
Xfanout407 _6960_/B_N _6961_/B_N vddd vssd sg13cmos5l_buf_1
X_7072_ _7072_/Q _7108_/CLK _7072_/D fanout398/X vddd vssd sg13cmos5l_dfrbpq_1
X_4284_ _4284_/Y _6693_/A1 _4283_/B hold640/X vddd vssd sg13cmos5l_a21oi_1
Xfanout429 _5727_/A _5902_/A vddd vssd sg13cmos5l_buf_1
X_6023_ _6023_/Y _6130_/A _6043_/B _6023_/C _6023_/D vddd vssd sg13cmos5l_nand4_1
Xoutbuffers\[40\] bandgap_trim[1] _6288_/B vddd vssd sg13cmos5l_buf_16
XFILLER_3_2522 vddd vssd sg13cmos5l_decap_8
XFILLER_27_549 vddd vssd sg13cmos5l_decap_8
X_6925_ _6925_/Y _6960_/A _6960_/B_N vddd vssd sg13cmos5l_nor2b_1
XFILLER_3_1887 vddd vssd sg13cmos5l_decap_8
XFILLER_22_210 vddd vssd sg13cmos5l_decap_8
XFILLER_22_243 vddd vssd sg13cmos5l_decap_8
Xfanout36 _4767_/A1 fanout39/X vddd vssd sg13cmos5l_buf_1
X_6856_ _6856_/Y _6857_/A _6860_/B_N vddd vssd sg13cmos5l_nor2b_1
Xfanout47 _6790_/B _6788_/B vddd vssd sg13cmos5l_buf_1
X_6787_ _7098_/D _6333_/A _6788_/B hold660/X vddd vssd sg13cmos5l_a21oi_1
XFILLER_13_2129 vddd vssd sg13cmos5l_decap_4
X_3999_ _3999_/Y _4083_/A _4258_/B _7017_/D vddd vssd sg13cmos5l_o21ai_1
X_5807_ _5807_/Y _5828_/C _5822_/C vddd vssd sg13cmos5l_nor2_1
Xfanout69 _6370_/B _6376_/B vddd vssd sg13cmos5l_buf_1
XFILLER_30_2410 vddd vssd sg13cmos5l_decap_8
XFILLER_17_1575 vddd vssd sg13cmos5l_decap_8
X_5738_ _5738_/Y _5738_/A _5737_/Y vddd vssd sg13cmos5l_nor2b_1
XFILLER_13_35 vddd vssd sg13cmos5l_decap_8
XFILLER_30_2487 vddd vssd sg13cmos5l_decap_8
X_5669_ _5674_/D _7194_/Q _5669_/B vddd vssd sg13cmos5l_nand2_1
XFILLER_11_1130 vddd vssd sg13cmos5l_decap_8
XFILLER_28_2350 vddd vssd sg13cmos5l_decap_8
X_7339_ _7339_/Q _7341_/CLK _7339_/D _6852_/Y vddd vssd sg13cmos5l_dfrbpq_1
XFILLER_8_2400 vddd vssd sg13cmos5l_decap_8
Xhold494 _4559_/B hold494/A vddd vssd sg13cmos5l_dlygate4sd3_1
Xhold483 sram_addr[9] _5999_/X vddd vssd sg13cmos5l_dlygate4sd3_1
XFILLER_8_2444 vddd vssd sg13cmos5l_decap_8
XFILLER_8_1732 vddd vssd sg13cmos5l_decap_8
XFILLER_2_2032 vddd vssd sg13cmos5l_decap_8
Xhold1150 _6580_/A1 _5200_/B vddd vssd sg13cmos5l_dlygate4sd3_1
Xhold1161 _7269_/D _6619_/Y vddd vssd sg13cmos5l_dlygate4sd3_1
Xhold1194 _3542_/A _7141_/Q vddd vssd sg13cmos5l_dlygate4sd3_1
XFILLER_18_527 vddd vssd sg13cmos5l_decap_8
Xhold1172 _3580_/A _7197_/Q vddd vssd sg13cmos5l_dlygate4sd3_1
Xhold1183 _7167_/D _6434_/X vddd vssd sg13cmos5l_dlygate4sd3_1
XFILLER_29_2114 vddd vssd sg13cmos5l_decap_8
XFILLER_6_965 vddd vssd sg13cmos5l_decap_8
XFILLER_29_1435 vddd vssd sg13cmos5l_decap_8
XFILLER_9_1529 vddd vssd sg13cmos5l_decap_4
X_4971_ _4971_/Y _4971_/A _4971_/B vddd vssd sg13cmos5l_nand2_1
X_6710_ _7051_/D _6710_/A1 _6745_/S _6710_/B1 vddd vssd sg13cmos5l_a21oi_1
XFILLER_18_2530 vddd vssd sg13cmos5l_decap_8
X_3922_ _6503_/A _3922_/A _4071_/C vddd vssd sg13cmos5l_nor2_1
X_6641_ _6641_/X _6641_/A0 _6546_/A _6641_/S vddd vssd sg13cmos5l_mux2_1
X_3853_ _3854_/B mask_rev_in[28] _3852_/A _3852_/Y vddd vssd sg13cmos5l_a21oi_1
XFILLER_20_758 vddd vssd sg13cmos5l_decap_8
X_6572_ _6572_/Y _6655_/A _6575_/S vddd vssd sg13cmos5l_nand2_1
X_3784_ _3784_/Y _3786_/A _4258_/B _7017_/D vddd vssd sg13cmos5l_o21ai_1
X_5523_ _5540_/C _7172_/Q _7173_/Q vddd vssd sg13cmos5l_nand2b_1
X_5454_ _5454_/Y _5454_/A _7163_/Q _5454_/C vddd vssd sg13cmos5l_nor3_1
Xoutbuffers\[88\] io_out[3] _6084_/Y vddd vssd sg13cmos5l_buf_16
XFILLER_12_1483 vddd vssd sg13cmos5l_decap_4
X_4405_ _4405_/Y _4420_/A _4405_/B vddd vssd sg13cmos5l_nor2_1
X_5385_ _5385_/Y _7155_/Q _5398_/D vddd vssd sg13cmos5l_nand2b_1
XFILLER_25_2501 vddd vssd sg13cmos5l_decap_8
X_4336_ _4336_/Y _4336_/A _4336_/B _4336_/C vddd vssd sg13cmos5l_nand3_1
X_7124_ _7124_/Q _7259_/CLK _7124_/D fanout396/X vddd vssd sg13cmos5l_dfrbpq_1
Xfanout204 _6520_/A _6676_/A vddd vssd sg13cmos5l_buf_1
XFILLER_25_1811 vddd vssd sg13cmos5l_decap_8
Xfanout237 _4473_/A _4506_/A1 vddd vssd sg13cmos5l_buf_1
Xfanout215 _6906_/A _6908_/A vddd vssd sg13cmos5l_buf_1
Xfanout226 _6857_/A _6845_/A vddd vssd sg13cmos5l_buf_1
XFILLER_25_2578 vddd vssd sg13cmos5l_decap_8
X_7055_ _7055_/Q _7060_/CLK _7055_/D _6820_/B_N vddd vssd sg13cmos5l_dfrbpq_1
X_4267_ _7379_/D _5028_/A _5029_/A _4271_/B vddd vssd sg13cmos5l_mux2_1
Xfanout248 _4740_/A _4758_/A vddd vssd sg13cmos5l_buf_1
Xfanout259 _4815_/B _4592_/B vddd vssd sg13cmos5l_buf_1
XFILLER_21_1719 vddd vssd sg13cmos5l_decap_8
X_6006_ _6006_/Y _6112_/A _5060_/C _5058_/C vddd vssd sg13cmos5l_a21oi_1
X_4198_ _4198_/Y _3719_/Y _6122_/A _4197_/Y vddd vssd sg13cmos5l_o21ai_1
XFILLER_19_2305 vddd vssd sg13cmos5l_decap_4
XFILLER_3_1662 vddd vssd sg13cmos5l_decap_8
XFILLER_3_1684 vddd vssd sg13cmos5l_decap_8
XFILLER_19_1626 vddd vssd sg13cmos5l_decap_8
X_6908_ _6908_/Y _6908_/A _6908_/B_N vddd vssd sg13cmos5l_nor2b_1
XFILLER_24_56 vddd vssd sg13cmos5l_decap_8
X_6839_ _6839_/Y _6949_/A _6949_/B_N vddd vssd sg13cmos5l_nor2b_1
XFILLER_19_1659 vddd vssd sg13cmos5l_decap_8
XFILLER_11_725 vddd vssd sg13cmos5l_decap_8
XFILLER_32_2538 vddd vssd sg13cmos5l_decap_8
XFILLER_32_1859 vddd vssd sg13cmos5l_decap_8
XFILLER_13_1258 vddd vssd sg13cmos5l_decap_8
XFILLER_3_924 vddd vssd sg13cmos5l_decap_8
XFILLER_24_2000 vddd vssd sg13cmos5l_decap_4
XFILLER_8_2252 vddd vssd sg13cmos5l_decap_8
XFILLER_4_2116 vddd vssd sg13cmos5l_decap_8
XFILLER_8_1595 vddd vssd sg13cmos5l_decap_4
XFILLER_2_1183 vddd vssd sg13cmos5l_decap_8
XFILLER_18_1136 vddd vssd sg13cmos5l_decap_8
XFILLER_18_1158 vddd vssd sg13cmos5l_decap_8
XFILLER_6_784 vddd vssd sg13cmos5l_decap_8
XFILLER_29_1210 vddd vssd sg13cmos5l_decap_8
XFILLER_9_1304 vddd vssd sg13cmos5l_decap_8
XFILLER_9_2027 vddd vssd sg13cmos5l_decap_8
X_5170_ _5171_/C _7288_/Q _5247_/B _5170_/C _5170_/D vddd vssd sg13cmos5l_nor4_1
X_4121_ _4123_/C _5786_/B _6510_/A vddd vssd sg13cmos5l_and2_1
X_4052_ _4052_/Y _4049_/Y _4050_/Y _4051_/Y vddd vssd sg13cmos5l_o21ai_1
XFILLER_0_2514 vddd vssd sg13cmos5l_decap_8
XFILLER_7_1083 vddd vssd sg13cmos5l_decap_8
XFILLER_20_2486 vddd vssd sg13cmos5l_decap_8
XFILLER_20_1785 vddd vssd sg13cmos5l_decap_4
XFILLER_17_390 vddd vssd sg13cmos5l_decap_8
X_4954_ _4955_/B _4930_/A _4945_/A _4930_/B vddd vssd sg13cmos5l_a21oi_1
XFILLER_0_1879 vddd vssd sg13cmos5l_decap_4
XFILLER_18_2360 vddd vssd sg13cmos5l_decap_8
XFILLER_14_2202 vddd vssd sg13cmos5l_decap_4
X_3905_ _3905_/Y _3898_/Y _3901_/Y _3904_/X _3791_/A _6556_/A vddd vssd sg13cmos5l_a221oi_1
XFILLER_32_371 vddd vssd sg13cmos5l_decap_8
XFILLER_20_533 vddd vssd sg13cmos5l_decap_8
X_4885_ _4885_/Y _4885_/A _4885_/B vddd vssd sg13cmos5l_nor2_1
XFILLER_14_2235 vddd vssd sg13cmos5l_decap_8
X_6624_ _7272_/D _6710_/A1 _6627_/B hold920/X vddd vssd sg13cmos5l_a21oi_1
X_3836_ _3838_/B _7134_/Q _4155_/B vddd vssd sg13cmos5l_or2_1
X_3767_ _6112_/A dbus_in_left[6] dbus_in_right[6] vddd vssd sg13cmos5l_nor2_1
X_6555_ _6555_/X _6546_/A hold764/X _6555_/S vddd vssd sg13cmos5l_mux2_1
XFILLER_31_1870 vddd vssd sg13cmos5l_decap_8
X_5506_ _5508_/B _5594_/A _5513_/B _5507_/B vddd vssd sg13cmos5l_nand3_1
X_3698_ _3698_/Y _3749_/B _3737_/B vddd vssd sg13cmos5l_nor2_1
X_6486_ _6486_/Y hold905/X _6487_/B _6485_/Y vddd vssd sg13cmos5l_a21oi_1
X_5437_ _5454_/C _7160_/Q _7161_/Q vddd vssd sg13cmos5l_nand2b_1
XFILLER_10_58 vddd vssd sg13cmos5l_decap_8
XFILLER_0_916 vddd vssd sg13cmos5l_decap_8
X_5368_ _5369_/C _5368_/A _5368_/B vddd vssd sg13cmos5l_nand2_1
X_5299_ _5299_/Y _6018_/A _5304_/A vddd vssd sg13cmos5l_nor2b_1
X_7107_ _7107_/Q _7127_/CLK _7107_/D _6955_/B_N vddd vssd sg13cmos5l_dfrbpq_1
X_4319_ _4320_/C _4319_/A _4319_/B vddd vssd sg13cmos5l_and2_1
X_7038_ _7038_/Q _7060_/CLK _7038_/D _6871_/B_N vddd vssd sg13cmos5l_dfrbpq_1
XFILLER_19_56 vddd vssd sg13cmos5l_decap_8
XFILLER_5_1702 vddd vssd sg13cmos5l_decap_8
XFILLER_3_2182 vddd vssd sg13cmos5l_decap_4
XFILLER_27_154 vddd vssd sg13cmos5l_decap_8
XFILLER_19_2102 vddd vssd sg13cmos5l_decap_8
XFILLER_32_2335 vddd vssd sg13cmos5l_decap_8
XFILLER_32_1612 vddd vssd sg13cmos5l_decap_8
XFILLER_4_0 vddd vssd sg13cmos5l_decap_8
XFILLER_8_2060 vddd vssd sg13cmos5l_decap_8
XFILLER_4_1245 vddd vssd sg13cmos5l_decap_4
XFILLER_19_677 vddd vssd sg13cmos5l_decap_8
XFILLER_15_2500 vddd vssd sg13cmos5l_decap_8
XFILLER_15_894 vddd vssd sg13cmos5l_decap_8
XFILLER_30_853 vddd vssd sg13cmos5l_decap_8
XFILLER_19_1990 vddd vssd sg13cmos5l_decap_8
XFILLER_15_2577 vddd vssd sg13cmos5l_decap_8
X_4670_ _4671_/B _4670_/A _4670_/B _4670_/C vddd vssd sg13cmos5l_nand3_1
XFILLER_14_393 vddd vssd sg13cmos5l_decap_8
X_3621_ _6287_/A _3621_/A vddd vssd sg13cmos5l_inv_1
XFILLER_15_1898 vddd vssd sg13cmos5l_decap_8
X_6340_ _7117_/D _6743_/A _6343_/B hold672/X vddd vssd sg13cmos5l_o21ai_1
X_3552_ _3552_/Y _5683_/A vddd vssd sg13cmos5l_inv_1
XFILLER_6_581 vddd vssd sg13cmos5l_decap_8
X_6271_ _6273_/A _3791_/B _4997_/B _6270_/Y vddd vssd sg13cmos5l_a21oi_1
X_3483_ _3483_/Y _6837_/A vddd vssd sg13cmos5l_inv_1
XFILLER_29_1051 vddd vssd sg13cmos5l_decap_8
X_5222_ _5226_/A _5222_/A _5222_/B _5222_/C _5222_/D vddd vssd sg13cmos5l_nor4_1
XFILLER_29_1084 vddd vssd sg13cmos5l_decap_8
XFILLER_22_2504 vddd vssd sg13cmos5l_decap_8
X_5153_ _5213_/B _7247_/Q _7246_/Q vddd vssd sg13cmos5l_nand2b_1
X_4104_ _4104_/Y _5199_/B _4017_/B _6563_/A vddd vssd sg13cmos5l_a21oi_1
X_5084_ _6023_/D _5228_/A _5266_/B _5110_/C vddd vssd sg13cmos5l_nand3_1
X_4035_ _4035_/Y _5736_/A _6496_/A _3927_/Y vddd vssd sg13cmos5l_o21ai_1
XFILLER_20_2272 vddd vssd sg13cmos5l_decap_8
XFILLER_4_1790 vddd vssd sg13cmos5l_decap_8
XFILLER_0_1632 vddd vssd sg13cmos5l_decap_8
XFILLER_24_168 vddd vssd sg13cmos5l_decap_8
X_5986_ _5986_/Y _3552_/Y _5957_/Y _5985_/Y vddd vssd sg13cmos5l_a21oi_1
X_4937_ _4937_/Y _4863_/A _4941_/A _4935_/Y vddd vssd sg13cmos5l_a21oi_1
XFILLER_16_1607 vddd vssd sg13cmos5l_decap_8
XANTENNA_20 porb vddd vssd sg13cmos5l_antennanp
XFILLER_21_853 vddd vssd sg13cmos5l_decap_8
X_4868_ _4885_/B _4932_/A _7137_/Q vddd vssd sg13cmos5l_nor2_1
XANTENNA_31 _6784_/A vddd vssd sg13cmos5l_antennanp
X_3819_ _3819_/Y dbus_in_left[4] dbus_in_right[4] vddd vssd sg13cmos5l_nor2_1
X_6607_ _6607_/X _6607_/A0 _6599_/A _6608_/S vddd vssd sg13cmos5l_mux2_1
XANTENNA_53 _6018_/A vddd vssd sg13cmos5l_antennanp
XANTENNA_42 _3948_/A vddd vssd sg13cmos5l_antennanp
XFILLER_21_35 vddd vssd sg13cmos5l_decap_8
X_4799_ _4799_/Y _4799_/A _4799_/B _4799_/C vddd vssd sg13cmos5l_nand3_1
X_6538_ _7222_/D _6544_/A _6538_/A1 _6539_/S vddd vssd sg13cmos5l_mux2_1
XFILLER_27_2404 vddd vssd sg13cmos5l_decap_8
X_6469_ _7184_/D _6482_/A1 _6473_/S hold908/X vddd vssd sg13cmos5l_o21ai_1
XFILLER_0_757 vddd vssd sg13cmos5l_decap_8
XFILLER_0_779 vddd vssd sg13cmos5l_decap_4
XFILLER_1_2119 vddd vssd sg13cmos5l_decap_4
XFILLER_29_953 vddd vssd sg13cmos5l_decap_8
XFILLER_21_1346 vddd vssd sg13cmos5l_decap_8
XFILLER_16_636 vddd vssd sg13cmos5l_decap_8
XFILLER_12_842 vddd vssd sg13cmos5l_decap_8
XFILLER_8_824 vddd vssd sg13cmos5l_decap_8
XFILLER_10_2496 vddd vssd sg13cmos5l_decap_8
XFILLER_30_7 vddd vssd sg13cmos5l_decap_8
XFILLER_6_1318 vddd vssd sg13cmos5l_decap_8
XFILLER_19_496 vddd vssd sg13cmos5l_decap_8
XFILLER_4_1097 vddd vssd sg13cmos5l_decap_8
X_5840_ _5840_/Y _5853_/C _5839_/Y _5854_/A vddd vssd sg13cmos5l_o21ai_1
XFILLER_21_105 vddd vssd sg13cmos5l_decap_8
X_5771_ _5771_/Y _6239_/A1 _5769_/Y _5770_/Y _5768_/Y _5743_/Y vddd vssd sg13cmos5l_a221oi_1
XFILLER_15_2330 vddd vssd sg13cmos5l_decap_4
X_4722_ _4722_/Y _4689_/B _4712_/B _4696_/A vddd vssd sg13cmos5l_o21ai_1
XFILLER_15_2374 vddd vssd sg13cmos5l_decap_8
X_4653_ _4654_/B _4461_/Y _4640_/Y _4649_/Y _4652_/Y vddd vssd sg13cmos5l_a22oi_1
X_4584_ _4585_/B _4805_/B1 _4572_/Y _4580_/Y _4583_/Y vddd vssd sg13cmos5l_a22oi_1
X_3604_ _3604_/Y _3604_/A vddd vssd sg13cmos5l_inv_1
Xhold802 hold802/X _3509_/Y vddd vssd sg13cmos5l_dlygate4sd3_1
X_7372_ _7372_/Q _7372_/CLK _7372_/D _6885_/Y vddd vssd sg13cmos5l_dfrbpq_1
Xhold835 _6637_/A _7280_/Q vddd vssd sg13cmos5l_dlygate4sd3_1
X_6323_ _7109_/D hold838/X _6324_/B _6322_/Y vddd vssd sg13cmos5l_o21ai_1
X_3535_ _3535_/Y _7286_/Q vddd vssd sg13cmos5l_inv_1
Xhold824 hold824/X _7394_/Q vddd vssd sg13cmos5l_dlygate4sd3_1
Xhold813 hold813/X _3510_/Y vddd vssd sg13cmos5l_dlygate4sd3_1
Xhold846 hold846/X _5355_/A vddd vssd sg13cmos5l_dlygate4sd3_1
Xoutbuffers\[70\] idac1_value[2] _7036_/Q vddd vssd sg13cmos5l_buf_16
Xhold857 hold857/X _7075_/Q vddd vssd sg13cmos5l_dlygate4sd3_1
X_3466_ _3466_/Y _4751_/A vddd vssd sg13cmos5l_inv_1
Xhold868 _6968_/D _5943_/Y vddd vssd sg13cmos5l_dlygate4sd3_1
X_6254_ _6254_/X _6276_/A _6253_/Y _6254_/S vddd vssd sg13cmos5l_mux2_1
Xhold879 _4273_/C _3634_/Y vddd vssd sg13cmos5l_dlygate4sd3_1
X_5205_ _5206_/D _6139_/A _5205_/B _5205_/C vddd vssd sg13cmos5l_nand3_1
X_6185_ _6185_/Y _5242_/C _6183_/Y _6184_/Y vddd vssd sg13cmos5l_o21ai_1
Xhold1502 hold499/A _7008_/Q vddd vssd sg13cmos5l_dlygate4sd3_1
Xhold1513 hold1513/X _7305_/Q vddd vssd sg13cmos5l_dlygate4sd3_1
X_5136_ _5139_/D _5213_/A _5136_/B vddd vssd sg13cmos5l_nand2b_1
X_5067_ _5257_/B _5163_/B _7236_/Q vddd vssd sg13cmos5l_nand2b_1
XFILLER_2_1738 vddd vssd sg13cmos5l_decap_4
X_4018_ _4018_/Y _7238_/Q _6563_/A _4016_/Y _4017_/Y vddd vssd sg13cmos5l_a22oi_1
XFILLER_26_956 vddd vssd sg13cmos5l_decap_8
XFILLER_16_35 vddd vssd sg13cmos5l_decap_8
XFILLER_0_1451 vddd vssd sg13cmos5l_decap_8
X_5969_ _5969_/Y _5967_/Y _5968_/Y _5980_/C vddd vssd sg13cmos5l_o21ai_1
XFILLER_32_56 vddd vssd sg13cmos5l_decap_8
XFILLER_4_304 vddd vssd sg13cmos5l_decap_8
XFILLER_0_510 vddd vssd sg13cmos5l_decap_8
XFILLER_7_2306 vddd vssd sg13cmos5l_decap_8
XFILLER_27_1577 vddd vssd sg13cmos5l_decap_8
XFILLER_7_1638 vddd vssd sg13cmos5l_decap_8
XFILLER_16_433 vddd vssd sg13cmos5l_decap_8
XFILLER_32_915 vddd vssd sg13cmos5l_decap_8
XFILLER_31_447 vddd vssd sg13cmos5l_decap_4
XFILLER_12_661 vddd vssd sg13cmos5l_decap_8
XFILLER_12_2547 vddd vssd sg13cmos5l_decap_8
XFILLER_8_687 vddd vssd sg13cmos5l_decap_8
X_6941_ _6941_/Y _6952_/A _6949_/B_N vddd vssd sg13cmos5l_nor2b_1
X_6872_ _6872_/Y _6909_/A _6892_/B_N vddd vssd sg13cmos5l_nor2b_1
X_5823_ _5823_/Y _5398_/A _5818_/A _5812_/Y _6233_/A vddd vssd sg13cmos5l_a22oi_1
XFILLER_17_2469 vddd vssd sg13cmos5l_decap_8
XFILLER_17_1746 vddd vssd sg13cmos5l_decap_8
X_5754_ _5754_/Y _5816_/A _5769_/B _5752_/Y vddd vssd sg13cmos5l_o21ai_1
X_4705_ _4705_/X _6798_/A _7003_/D vddd vssd sg13cmos5l_xor2_1
X_5685_ _5685_/Y _7196_/Q _7197_/Q _5701_/B _5708_/B vddd vssd sg13cmos5l_nor4_1
XFILLER_15_1492 vddd vssd sg13cmos5l_decap_4
XFILLER_8_91 vddd vssd sg13cmos5l_decap_8
X_4636_ _4636_/Y _6063_/A _4448_/B _4373_/A vddd vssd sg13cmos5l_o21ai_1
Xhold610 _7320_/D _4854_/Y vddd vssd sg13cmos5l_dlygate4sd3_1
X_7355_ _7355_/Q _7355_/CLK _7355_/D _6868_/Y vddd vssd sg13cmos5l_dfrbpq_1
Xhold621 hold621/X _3661_/Y vddd vssd sg13cmos5l_dlygate4sd3_1
XFILLER_28_2532 vddd vssd sg13cmos5l_decap_8
X_4567_ _4567_/X _4545_/A _4811_/B _4566_/Y vddd vssd sg13cmos5l_a21o_1
Xhold643 hold643/X _6774_/Y vddd vssd sg13cmos5l_dlygate4sd3_1
X_6306_ _6306_/Y hold816/X _6311_/B _6305_/Y vddd vssd sg13cmos5l_o21ai_1
Xhold654 hold654/X _7254_/Q vddd vssd sg13cmos5l_dlygate4sd3_1
Xhold632 _6760_/A _7082_/Q vddd vssd sg13cmos5l_dlygate4sd3_1
Xhold676 hold676/X _6778_/Y vddd vssd sg13cmos5l_dlygate4sd3_1
Xhold687 _7322_/D _4847_/Y vddd vssd sg13cmos5l_dlygate4sd3_1
X_4498_ _4498_/Y _4498_/A _4785_/A vddd vssd sg13cmos5l_nand2_1
X_7286_ _7286_/Q _7292_/CLK _7286_/D fanout386/X vddd vssd sg13cmos5l_dfrbpq_1
Xhold665 hold665/X _6756_/Y vddd vssd sg13cmos5l_dlygate4sd3_1
X_3518_ _3518_/Y _3518_/A vddd vssd sg13cmos5l_inv_1
XFILLER_24_2429 vddd vssd sg13cmos5l_decap_8
X_6237_ _6237_/Y _7230_/Q _7231_/Q _6237_/C vddd vssd sg13cmos5l_nor3_1
Xhold698 _5290_/A _5289_/Y vddd vssd sg13cmos5l_dlygate4sd3_1
XFILLER_8_1936 vddd vssd sg13cmos5l_decap_8
X_6168_ _6168_/Y _6168_/A _6168_/B vddd vssd sg13cmos5l_nand2_1
Xhold1343 hold1343/X _7175_/Q vddd vssd sg13cmos5l_dlygate4sd3_1
Xhold1332 _3615_/A _7035_/Q vddd vssd sg13cmos5l_dlygate4sd3_1
Xhold1321 _7040_/D _6694_/X vddd vssd sg13cmos5l_dlygate4sd3_1
X_5119_ _5120_/D _5119_/A _6048_/B _5119_/C _5119_/D vddd vssd sg13cmos5l_nand4_1
Xhold1310 _7171_/D _6442_/Y vddd vssd sg13cmos5l_dlygate4sd3_1
Xhold1376 _6630_/A _5228_/A vddd vssd sg13cmos5l_dlygate4sd3_1
Xhold1354 _3516_/A _7310_/Q vddd vssd sg13cmos5l_dlygate4sd3_1
Xhold1365 _4911_/A1 _3512_/Y vddd vssd sg13cmos5l_dlygate4sd3_1
X_6099_ _6099_/Y _5169_/C _6097_/Y _6098_/Y vddd vssd sg13cmos5l_o21ai_1
XFILLER_6_1682 vddd vssd sg13cmos5l_decap_8
XFILLER_27_56 vddd vssd sg13cmos5l_decap_8
XFILLER_22_1496 vddd vssd sg13cmos5l_decap_4
Xhold1398 hold1398/X _7162_/Q vddd vssd sg13cmos5l_dlygate4sd3_1
Xhold1387 hold1387/X _7157_/Q vddd vssd sg13cmos5l_dlygate4sd3_1
XFILLER_0_1281 vddd vssd sg13cmos5l_decap_8
XFILLER_11_2591 vddd vssd sg13cmos5l_decap_8
XFILLER_5_668 vddd vssd sg13cmos5l_decap_8
XFILLER_4_49 vddd vssd sg13cmos5l_decap_8
XFILLER_1_830 vddd vssd sg13cmos5l_decap_4
XFILLER_5_1181 vddd vssd sg13cmos5l_decap_8
XFILLER_32_712 vddd vssd sg13cmos5l_decap_8
XFILLER_31_233 vddd vssd sg13cmos5l_decap_8
XFILLER_32_789 vddd vssd sg13cmos5l_decap_8
XFILLER_31_266 vddd vssd sg13cmos5l_decap_8
X_5470_ _5470_/Y _5470_/A _5470_/B _5470_/C _5470_/D vddd vssd sg13cmos5l_nor4_1
XFILLER_12_2344 vddd vssd sg13cmos5l_decap_8
XFILLER_32_1080 vddd vssd sg13cmos5l_decap_8
X_4421_ _4421_/Y _4421_/A _4436_/A vddd vssd sg13cmos5l_nor2_1
X_7140_ _7140_/Q _7143_/CLK _7140_/D fanout362/X vddd vssd sg13cmos5l_dfrbpq_1
X_4352_ _4352_/Y _7082_/Q _4421_/A vddd vssd sg13cmos5l_nor2_1
Xfanout408 _6961_/B_N _6952_/B_N vddd vssd sg13cmos5l_buf_1
X_7071_ _7071_/Q _7143_/CLK _7071_/D fanout362/X vddd vssd sg13cmos5l_dfrbpq_1
Xfanout419 _3544_/A _6216_/A1 vddd vssd sg13cmos5l_buf_1
X_4283_ _4283_/Y _4302_/B _4283_/B vddd vssd sg13cmos5l_nor2_1
XFILLER_3_2501 vddd vssd sg13cmos5l_decap_8
X_6022_ _6022_/Y _7331_/Q _6128_/A2 _6021_/Y vddd vssd sg13cmos5l_o21ai_1
XFILLER_23_2495 vddd vssd sg13cmos5l_decap_8
XFILLER_3_2567 vddd vssd sg13cmos5l_decap_4
Xoutbuffers\[33\] bandgap_sink1[1] _7057_/Q vddd vssd sg13cmos5l_buf_16
X_6924_ _6924_/Y _6960_/A _6960_/B_N vddd vssd sg13cmos5l_nor2b_1
XFILLER_23_701 vddd vssd sg13cmos5l_decap_8
Xfanout37 _4819_/A fanout39/X vddd vssd sg13cmos5l_buf_1
X_6855_ _6855_/Y _6961_/A _6961_/B_N vddd vssd sg13cmos5l_nor2b_1
X_6786_ _6786_/Y _6786_/A _6788_/B vddd vssd sg13cmos5l_nor2_1
X_3998_ _3998_/Y _4257_/B sram_odata[3] _3756_/Y wire6/X _4292_/B vddd vssd sg13cmos5l_a221oi_1
X_5806_ _5822_/C _7215_/Q _7214_/Q vddd vssd sg13cmos5l_nand2b_1
Xfanout48 _6788_/B _6304_/Y vddd vssd sg13cmos5l_buf_1
XFILLER_13_14 vddd vssd sg13cmos5l_decap_8
XFILLER_13_1418 vddd vssd sg13cmos5l_decap_4
X_5737_ _5737_/Y _5737_/A _7200_/Q _7201_/Q _5739_/A vddd vssd sg13cmos5l_nand4_1
XFILLER_30_2466 vddd vssd sg13cmos5l_decap_8
X_5668_ _5671_/B _5816_/A _7195_/Q _5667_/Y vddd vssd sg13cmos5l_o21ai_1
XFILLER_30_1776 vddd vssd sg13cmos5l_decap_4
X_5599_ _5599_/Y _7182_/Q _7183_/Q _5599_/C vddd vssd sg13cmos5l_nor3_1
X_4619_ _4621_/B _4670_/A _4670_/B _4614_/A vddd vssd sg13cmos5l_o21ai_1
X_7338_ _7338_/Q _7338_/CLK _7338_/D _6851_/Y vddd vssd sg13cmos5l_dfrbpq_1
XFILLER_8_7 vddd vssd sg13cmos5l_decap_8
X_7269_ _7269_/Q _7275_/CLK _7269_/D fanout392/X vddd vssd sg13cmos5l_dfrbpq_1
Xhold495 _4650_/A hold495/A vddd vssd sg13cmos5l_dlygate4sd3_1
Xhold484 _4959_/A hold882/X vddd vssd sg13cmos5l_dlygate4sd3_1
XFILLER_24_1503 vddd vssd sg13cmos5l_decap_8
XFILLER_8_2467 vddd vssd sg13cmos5l_decap_4
Xhold1140 _4412_/B _4411_/Y vddd vssd sg13cmos5l_dlygate4sd3_1
Xhold1151 _7245_/D _6580_/Y vddd vssd sg13cmos5l_dlygate4sd3_1
Xhold1184 _3574_/A _7185_/Q vddd vssd sg13cmos5l_dlygate4sd3_1
Xhold1162 _6612_/A0 _7265_/Q vddd vssd sg13cmos5l_dlygate4sd3_1
Xhold1173 _6493_/A1 _5695_/B vddd vssd sg13cmos5l_dlygate4sd3_1
XFILLER_2_1332 vddd vssd sg13cmos5l_decap_8
XFILLER_2_1310 vddd vssd sg13cmos5l_decap_8
XFILLER_6_1490 vddd vssd sg13cmos5l_decap_4
Xhold1195 _6387_/A1 _5306_/B vddd vssd sg13cmos5l_dlygate4sd3_1
XFILLER_2_1376 vddd vssd sg13cmos5l_decap_8
XFILLER_31_2219 vddd vssd sg13cmos5l_decap_4
XFILLER_6_944 vddd vssd sg13cmos5l_decap_8
XFILLER_9_1508 vddd vssd sg13cmos5l_decap_4
Xclkbuf_leaf_14_SCK_regs _7191_/CLK clkload4/A vddd vssd sg13cmos5l_buf_8
X_4970_ _4971_/B _4970_/A _4970_/B vddd vssd sg13cmos5l_nor2_1
X_3921_ _6496_/A _3921_/A _3967_/B vddd vssd sg13cmos5l_nand2_1
XFILLER_32_553 vddd vssd sg13cmos5l_decap_8
X_6640_ _6640_/X hold991/X _6544_/A _6641_/S vddd vssd sg13cmos5l_mux2_1
XFILLER_18_2586 vddd vssd sg13cmos5l_decap_8
X_3852_ _3852_/Y _3852_/A _3852_/B _3852_/C vddd vssd sg13cmos5l_nor3_1
X_6571_ _7240_/D _6710_/A1 _6575_/S hold952/X vddd vssd sg13cmos5l_a21oi_1
X_5522_ _5535_/A _5540_/A _5522_/B vddd vssd sg13cmos5l_nor2_1
XFILLER_14_1738 vddd vssd sg13cmos5l_decap_8
X_3783_ _3783_/Y _4257_/B sram_odata[6] _3753_/X wire21/X _4292_/B vddd vssd sg13cmos5l_a221oi_1
XFILLER_9_760 vddd vssd sg13cmos5l_decap_8
X_5453_ _5453_/Y _5454_/A _7163_/Q _5453_/C vddd vssd sg13cmos5l_nor3_1
XFILLER_12_1451 vddd vssd sg13cmos5l_decap_8
XFILLER_12_1462 vddd vssd sg13cmos5l_decap_8
X_4404_ _4404_/Y _4404_/A _4407_/A vddd vssd sg13cmos5l_xnor2_1
X_5384_ _5398_/D _5401_/A _5393_/B vddd vssd sg13cmos5l_nand2_1
Xfanout205 _6676_/A _6625_/A1 vddd vssd sg13cmos5l_buf_1
X_4335_ _4335_/Y _4320_/C _4334_/Y hold788/X vddd vssd sg13cmos5l_o21ai_1
X_7123_ _7123_/Q _7259_/CLK _7123_/D fanout396/X vddd vssd sg13cmos5l_dfrbpq_1
XFILLER_25_2557 vddd vssd sg13cmos5l_decap_8
Xfanout238 _4530_/A _4388_/A vddd vssd sg13cmos5l_buf_1
Xfanout227 _6943_/A _6919_/A vddd vssd sg13cmos5l_buf_1
Xfanout216 _6908_/A _6827_/A vddd vssd sg13cmos5l_buf_1
XFILLER_25_1834 vddd vssd sg13cmos5l_decap_8
X_7054_ _7054_/Q _7060_/CLK _7054_/D _6820_/B_N vddd vssd sg13cmos5l_dfrbpq_1
Xfanout249 _4776_/A _5393_/A vddd vssd sg13cmos5l_buf_1
X_4266_ _7380_/D _5029_/A _5030_/A _4271_/B vddd vssd sg13cmos5l_mux2_1
X_6005_ _6005_/Y _6156_/A _5045_/X _6004_/Y vddd vssd sg13cmos5l_a21oi_1
X_4197_ _4197_/Y _3901_/A _6048_/A _6556_/A vddd vssd sg13cmos5l_a21oi_1
XFILLER_23_542 vddd vssd sg13cmos5l_decap_8
X_6907_ _6907_/Y _6908_/A _6907_/B_N vddd vssd sg13cmos5l_nor2b_1
XFILLER_32_2517 vddd vssd sg13cmos5l_decap_8
XFILLER_24_35 vddd vssd sg13cmos5l_decap_8
XFILLER_17_2063 vddd vssd sg13cmos5l_decap_4
XFILLER_17_2041 vddd vssd sg13cmos5l_decap_4
X_6838_ _6838_/Y _6838_/A _6838_/B_N vddd vssd sg13cmos5l_nor2b_1
XFILLER_32_1838 vddd vssd sg13cmos5l_decap_8
X_6769_ _7087_/D hold795/X _6771_/B _6768_/Y vddd vssd sg13cmos5l_o21ai_1
XFILLER_3_903 vddd vssd sg13cmos5l_decap_8
XFILLER_8_2220 vddd vssd sg13cmos5l_decap_8
XFILLER_8_2297 vddd vssd sg13cmos5l_decap_4
XFILLER_1_28 vddd vssd sg13cmos5l_decap_8
XFILLER_8_1563 vddd vssd sg13cmos5l_decap_8
XFILLER_20_1208 vddd vssd sg13cmos5l_decap_8
XFILLER_2_1151 vddd vssd sg13cmos5l_decap_8
XFILLER_13_2483 vddd vssd sg13cmos5l_decap_8
XFILLER_9_2006 vddd vssd sg13cmos5l_decap_8
XFILLER_29_1288 vddd vssd sg13cmos5l_decap_8
X_4120_ _4123_/B _5815_/B _6517_/A _4118_/Y _4119_/Y vddd vssd sg13cmos5l_a22oi_1
XFILLER_7_1040 vddd vssd sg13cmos5l_decap_8
X_4051_ _4051_/Y _5363_/B _6399_/A _4053_/B vddd vssd sg13cmos5l_a21oi_1
XFILLER_24_2590 vddd vssd sg13cmos5l_decap_8
XFILLER_20_2465 vddd vssd sg13cmos5l_decap_8
X_6902__472 _7390_/CLK clkload9/A vddd vssd sg13cmos5l_inv_1
X_4953_ _7303_/D _4951_/A _4948_/B _4952_/Y vddd vssd sg13cmos5l_a21o_1
XFILLER_32_350 vddd vssd sg13cmos5l_decap_8
X_3904_ _3904_/X dbus_in_left[3] dbus_in_right[3] vddd vssd sg13cmos5l_or2_1
X_6623_ _6623_/Y _6623_/A _6627_/B vddd vssd sg13cmos5l_nor2_1
XFILLER_20_523 vddd vssd sg13cmos5l_decap_4
X_4884_ _4884_/Y _4873_/Y _4883_/Y _4898_/A vddd vssd sg13cmos5l_o21ai_1
XFILLER_14_2214 vddd vssd sg13cmos5l_decap_8
X_3835_ _3838_/A _7038_/Q _6683_/A _3834_/Y vddd vssd sg13cmos5l_o21ai_1
X_3766_ _3766_/Y _6361_/A _3934_/A vddd vssd sg13cmos5l_nand2_1
X_6554_ _6554_/Y _6554_/A1 _6555_/S _6553_/Y vddd vssd sg13cmos5l_a21oi_1
XFILLER_14_1557 vddd vssd sg13cmos5l_decap_8
XFILLER_31_2594 vddd vssd sg13cmos5l_decap_8
X_5505_ _5508_/A _5505_/A _5505_/B _5505_/C vddd vssd sg13cmos5l_nand3_1
X_6485_ _6485_/Y _6553_/A _6487_/B vddd vssd sg13cmos5l_nor2_1
X_5436_ _5449_/A _5454_/A _5436_/B vddd vssd sg13cmos5l_nor2_1
XFILLER_10_37 vddd vssd sg13cmos5l_decap_8
X_3697_ _3737_/B _3750_/A _3750_/B vddd vssd sg13cmos5l_nand2b_1
X_5367_ _5369_/B _5594_/A _5374_/B _5368_/B vddd vssd sg13cmos5l_nand3_1
XFILLER_25_2365 vddd vssd sg13cmos5l_decap_8
X_7106_ _7106_/Q _7108_/CLK _7106_/D fanout399/X vddd vssd sg13cmos5l_dfrbpq_1
X_5298_ _5316_/C _7140_/Q _7141_/Q vddd vssd sg13cmos5l_nand2_1
X_4318_ _4319_/B _4333_/B _4318_/B vddd vssd sg13cmos5l_and2_1
XFILLER_9_2584 vddd vssd sg13cmos5l_decap_8
X_7037_ _7037_/Q _7066_/CLK _7037_/D _6871_/B_N vddd vssd sg13cmos5l_dfrbpq_1
XFILLER_25_1642 vddd vssd sg13cmos5l_decap_8
XFILLER_19_35 vddd vssd sg13cmos5l_decap_8
X_4249_ _4250_/D _7090_/Q _6773_/A _6773_/B vddd vssd sg13cmos5l_nor3_1
XFILLER_21_1528 vddd vssd sg13cmos5l_decap_8
XFILLER_27_133 vddd vssd sg13cmos5l_decap_8
XFILLER_32_2314 vddd vssd sg13cmos5l_decap_8
XFILLER_11_556 vddd vssd sg13cmos5l_decap_8
XFILLER_17_1192 vddd vssd sg13cmos5l_decap_4
XFILLER_10_2601 vddd vssd sg13cmos5l_decap_4
XFILLER_26_2118 vddd vssd sg13cmos5l_decap_8
XFILLER_10_1999 vddd vssd sg13cmos5l_decap_8
Xtiedowns\[32\] dbus_in_right[0] vddd vssd sg13cmos5l_antennanp
XFILLER_24_1152 vddd vssd sg13cmos5l_decap_8
XFILLER_4_1224 vddd vssd sg13cmos5l_decap_8
XFILLER_15_2556 vddd vssd sg13cmos5l_decap_8
X_3620_ _3620_/Y _3620_/A vddd vssd sg13cmos5l_inv_1
XFILLER_15_1877 vddd vssd sg13cmos5l_decap_8
X_3551_ _3551_/Y _5398_/A vddd vssd sg13cmos5l_inv_1
X_6270_ _6270_/Y _6270_/A _6270_/B vddd vssd sg13cmos5l_nand2_1
X_3482_ _4301_/A _4279_/B vddd vssd sg13cmos5l_inv_1
XFILLER_29_1030 vddd vssd sg13cmos5l_decap_8
X_5221_ _5222_/D _5221_/A _5221_/B vddd vssd sg13cmos5l_nor2_1
X_5152_ _5169_/B _7248_/Q _7249_/Q _5221_/B vddd vssd sg13cmos5l_nor3_1
X_4103_ _4103_/Y _5200_/B _3895_/X _4101_/X _4102_/Y vddd vssd sg13cmos5l_a22oi_1
XFILLER_9_1179 vddd vssd sg13cmos5l_decap_8
X_5083_ _5246_/B _5228_/A _5266_/B vddd vssd sg13cmos5l_nand2_1
XFILLER_2_93 vddd vssd sg13cmos5l_decap_8
XFILLER_0_2323 vddd vssd sg13cmos5l_decap_8
XFILLER_4_2481 vddd vssd sg13cmos5l_decap_8
X_4034_ _4034_/Y _7206_/Q _6503_/A _4032_/Y _4033_/Y _4123_/A vddd vssd sg13cmos5l_a221oi_1
XFILLER_20_2295 vddd vssd sg13cmos5l_decap_8
XFILLER_0_1611 vddd vssd sg13cmos5l_decap_8
XFILLER_24_147 vddd vssd sg13cmos5l_decap_8
X_5985_ _5985_/Y _5828_/A _5983_/Y _5984_/Y _5982_/Y _5957_/Y vddd vssd sg13cmos5l_a221oi_1
XFILLER_0_1677 vddd vssd sg13cmos5l_decap_8
X_4936_ _4945_/B _5999_/S _4958_/B vddd vssd sg13cmos5l_nor2_1
XANTENNA_10 _3822_/Y vddd vssd sg13cmos5l_antennanp
X_4867_ _4885_/A _4949_/A _7136_/Q vddd vssd sg13cmos5l_nand2_1
XANTENNA_32 _6784_/A vddd vssd sg13cmos5l_antennanp
XANTENNA_21 wire1/X vddd vssd sg13cmos5l_antennanp
XANTENNA_43 _7051_/Q vddd vssd sg13cmos5l_antennanp
X_3818_ _6733_/A _6361_/A _3921_/A vddd vssd sg13cmos5l_nand2_1
X_6606_ _6606_/Y _6606_/A1 _6608_/S _6605_/Y vddd vssd sg13cmos5l_o21ai_1
XANTENNA_54 _7132_/Q vddd vssd sg13cmos5l_antennanp
XFILLER_31_2391 vddd vssd sg13cmos5l_decap_8
XFILLER_21_14 vddd vssd sg13cmos5l_decap_8
XFILLER_14_2099 vddd vssd sg13cmos5l_decap_8
X_6537_ _7221_/D _6537_/A1 _6539_/S _6536_/Y vddd vssd sg13cmos5l_a21oi_1
X_4798_ _4799_/C _4498_/A _4798_/B vddd vssd sg13cmos5l_nand2b_1
X_3749_ _3967_/A _4002_/A _3749_/B vddd vssd sg13cmos5l_nor2_1
X_6468_ _6468_/Y _6468_/A _6473_/S vddd vssd sg13cmos5l_nand2_1
X_5419_ _5419_/X _5532_/A _7159_/Q vddd vssd sg13cmos5l_or2_1
X_6399_ _6404_/B _6399_/A _6725_/B vddd vssd sg13cmos5l_nand2_1
XFILLER_0_736 vddd vssd sg13cmos5l_decap_8
XFILLER_5_2201 vddd vssd sg13cmos5l_decap_4
XFILLER_29_932 vddd vssd sg13cmos5l_decap_8
XFILLER_21_2026 vddd vssd sg13cmos5l_decap_8
XFILLER_16_615 vddd vssd sg13cmos5l_decap_8
XFILLER_28_497 vddd vssd sg13cmos5l_decap_8
XFILLER_12_821 vddd vssd sg13cmos5l_decap_8
XFILLER_8_803 vddd vssd sg13cmos5l_decap_8
XFILLER_8_836 vddd vssd sg13cmos5l_decap_8
XFILLER_12_898 vddd vssd sg13cmos5l_decap_8
XFILLER_7_49 vddd vssd sg13cmos5l_decap_8
XFILLER_10_2475 vddd vssd sg13cmos5l_decap_8
XFILLER_10_1774 vddd vssd sg13cmos5l_decap_4
XFILLER_11_91 vddd vssd sg13cmos5l_decap_4
XFILLER_26_1214 vddd vssd sg13cmos5l_decap_8
XFILLER_23_7 vddd vssd sg13cmos5l_decap_8
XFILLER_4_1010 vddd vssd sg13cmos5l_decap_8
XFILLER_21_2582 vddd vssd sg13cmos5l_decap_8
XFILLER_4_1054 vddd vssd sg13cmos5l_decap_4
X_5770_ _5770_/Y _5679_/A _5766_/Y _5769_/Y vddd vssd sg13cmos5l_a21oi_1
X_4721_ _4721_/Y _4720_/Y _4721_/B vddd vssd sg13cmos5l_nand2b_1
X_4652_ _4652_/Y _4652_/A _4652_/B vddd vssd sg13cmos5l_nor2_1
X_3603_ _3603_/Y _3603_/A vddd vssd sg13cmos5l_inv_1
X_4583_ _4583_/Y _4652_/A _4583_/B vddd vssd sg13cmos5l_nor2_1
X_7371_ _7371_/Q _7372_/CLK _7371_/D _6884_/Y vddd vssd sg13cmos5l_dfrbpq_1
Xhold803 _7318_/D _4859_/Y vddd vssd sg13cmos5l_dlygate4sd3_1
Xhold836 hold836/X _6637_/Y vddd vssd sg13cmos5l_dlygate4sd3_1
X_6322_ _6322_/Y _6743_/A _6324_/B vddd vssd sg13cmos5l_nand2_1
X_3534_ _5200_/B _3534_/A vddd vssd sg13cmos5l_inv_1
Xhold814 _7316_/D _4907_/Y vddd vssd sg13cmos5l_dlygate4sd3_1
Xhold825 _5288_/A _5287_/Y vddd vssd sg13cmos5l_dlygate4sd3_1
X_3465_ _3465_/Y _4674_/A vddd vssd sg13cmos5l_inv_1
Xhold858 _7075_/D _6745_/X vddd vssd sg13cmos5l_dlygate4sd3_1
X_6253_ _6253_/Y _3904_/X _5279_/A _6251_/Y _6252_/Y vddd vssd sg13cmos5l_a22oi_1
Xhold847 _4285_/C hold847/A vddd vssd sg13cmos5l_dlygate4sd3_1
Xhold869 _4315_/C _7352_/Q vddd vssd sg13cmos5l_dlygate4sd3_1
Xoutbuffers\[63\] idac2_value[0] _7039_/Q vddd vssd sg13cmos5l_buf_16
X_5204_ _5205_/C _6138_/B _6144_/B _5204_/C _5204_/D vddd vssd sg13cmos5l_nor4_1
X_6184_ _6184_/Y _6144_/A _5242_/C _5243_/B vddd vssd sg13cmos5l_a21oi_1
Xhold1503 hold501/A _7012_/Q vddd vssd sg13cmos5l_dlygate4sd3_1
Xhold1514 hold882/A _7301_/Q vddd vssd sg13cmos5l_dlygate4sd3_1
XFILLER_6_2554 vddd vssd sg13cmos5l_decap_8
XFILLER_6_2587 vddd vssd sg13cmos5l_decap_8
X_5135_ _5135_/Y _5213_/A _5136_/B vddd vssd sg13cmos5l_nor2b_1
XFILLER_22_2368 vddd vssd sg13cmos5l_decap_8
XFILLER_22_1623 vddd vssd sg13cmos5l_decap_8
X_5066_ _6023_/C _7281_/Q _7280_/Q vddd vssd sg13cmos5l_nor2b_1
X_4017_ _4017_/Y _7242_/Q _4017_/B vddd vssd sg13cmos5l_nand2b_1
XFILLER_16_14 vddd vssd sg13cmos5l_decap_8
XFILLER_0_2153 vddd vssd sg13cmos5l_decap_8
X_5968_ _5968_/Y _3546_/A _5972_/B _5966_/Y vddd vssd sg13cmos5l_o21ai_1
X_4919_ _7310_/D _4919_/A1 _4918_/C _4918_/Y vddd vssd sg13cmos5l_o21ai_1
XFILLER_32_35 vddd vssd sg13cmos5l_decap_8
X_5899_ _5907_/C _5899_/A _5899_/B vddd vssd sg13cmos5l_nor2_1
XFILLER_0_544 vddd vssd sg13cmos5l_decap_4
XFILLER_0_577 vddd vssd sg13cmos5l_decap_8
XFILLER_5_2064 vddd vssd sg13cmos5l_decap_8
Xclkbuf_leaf_39_SCK_regs _7364_/CLK clkbuf_3_0_0_SCK_regs/X vddd vssd sg13cmos5l_buf_8
XFILLER_12_2526 vddd vssd sg13cmos5l_decap_8
XFILLER_16_1994 vddd vssd sg13cmos5l_decap_8
XFILLER_32_1284 vddd vssd sg13cmos5l_decap_8
XFILLER_7_198 vddd vssd sg13cmos5l_decap_8
XFILLER_10_1560 vddd vssd sg13cmos5l_decap_8
XFILLER_23_2600 vddd vssd sg13cmos5l_decap_8
XFILLER_26_1044 vddd vssd sg13cmos5l_decap_8
X_6940_ _6940_/Y _6952_/A _6949_/B_N vddd vssd sg13cmos5l_nor2b_1
X_6871_ _6871_/Y _6881_/A _6871_/B_N vddd vssd sg13cmos5l_nor2b_1
X_5822_ _5822_/Y _7212_/Q _7213_/Q _5822_/C vddd vssd sg13cmos5l_nor3_1
XFILLER_17_2448 vddd vssd sg13cmos5l_decap_8
XFILLER_17_1725 vddd vssd sg13cmos5l_decap_4
X_5753_ _5753_/Y _5753_/A _5753_/B _5769_/A vddd vssd sg13cmos5l_nor3_1
Xoutbuffers\[7\] proj_ibias_ena[0] _7027_/Q vddd vssd sg13cmos5l_buf_16
X_4704_ _4704_/Y _4681_/A _4703_/Y _4704_/B1 vddd vssd sg13cmos5l_o21ai_1
X_5684_ _5684_/Y _5680_/Y _5682_/Y _5683_/Y _5682_/B vddd vssd sg13cmos5l_a22oi_1
X_4635_ _4635_/X _4614_/A _4488_/Y _4634_/Y vddd vssd sg13cmos5l_a21o_1
XFILLER_15_1471 vddd vssd sg13cmos5l_decap_8
XFILLER_8_70 vddd vssd sg13cmos5l_decap_8
XFILLER_11_2036 vddd vssd sg13cmos5l_decap_4
X_4566_ _4566_/Y _4633_/A _4566_/B _4566_/C vddd vssd sg13cmos5l_nor3_1
Xhold600 _4323_/A _7361_/Q vddd vssd sg13cmos5l_dlygate4sd3_1
Xhold611 _6345_/A _7120_/Q vddd vssd sg13cmos5l_dlygate4sd3_1
X_7354_ _7354_/Q _7398_/CLK _7354_/D _6867_/Y vddd vssd sg13cmos5l_dfrbpq_1
XFILLER_28_2511 vddd vssd sg13cmos5l_decap_8
Xhold644 _7090_/D _6775_/Y vddd vssd sg13cmos5l_dlygate4sd3_1
X_3517_ _3517_/Y _3517_/A vddd vssd sg13cmos5l_inv_1
X_6305_ _6305_/Y _6627_/A _6311_/B vddd vssd sg13cmos5l_nand2_1
Xhold633 hold633/X _6760_/Y vddd vssd sg13cmos5l_dlygate4sd3_1
Xhold622 _7355_/D _4341_/Y vddd vssd sg13cmos5l_dlygate4sd3_1
Xhold666 hold666/X _7225_/Q vddd vssd sg13cmos5l_dlygate4sd3_1
Xhold677 _7092_/D _6779_/Y vddd vssd sg13cmos5l_dlygate4sd3_1
X_7285_ _7285_/Q _7285_/CLK _7285_/D fanout386/X vddd vssd sg13cmos5l_dfrbpq_1
X_4497_ _4785_/A _4459_/Y _4782_/A _4806_/A1 vddd vssd sg13cmos5l_o21ai_1
Xhold688 hold688/X _7253_/Q vddd vssd sg13cmos5l_dlygate4sd3_1
Xhold655 _7254_/D _6593_/X vddd vssd sg13cmos5l_dlygate4sd3_1
XFILLER_28_2588 vddd vssd sg13cmos5l_decap_8
XFILLER_28_1854 vddd vssd sg13cmos5l_decap_8
XFILLER_24_2408 vddd vssd sg13cmos5l_decap_8
X_6236_ _6236_/Y _6231_/Y _6232_/X _6235_/X vddd vssd sg13cmos5l_o21ai_1
Xhold699 _6343_/A _7119_/Q vddd vssd sg13cmos5l_dlygate4sd3_1
XFILLER_24_1718 vddd vssd sg13cmos5l_decap_8
Xhold1300 hold1300/X _7219_/Q vddd vssd sg13cmos5l_dlygate4sd3_1
X_6167_ _6168_/B _7291_/Q _6165_/Y _6166_/Y vddd vssd sg13cmos5l_o21ai_1
Xhold1322 _6689_/A0 _7037_/Q vddd vssd sg13cmos5l_dlygate4sd3_1
Xhold1333 _6687_/A1 _3615_/Y vddd vssd sg13cmos5l_dlygate4sd3_1
XFILLER_22_2143 vddd vssd sg13cmos5l_decap_4
Xhold1311 _3622_/A _7230_/Q vddd vssd sg13cmos5l_dlygate4sd3_1
X_5118_ _5119_/D _5126_/B _5118_/B vddd vssd sg13cmos5l_nand2_1
Xhold1377 _6700_/A _7044_/Q vddd vssd sg13cmos5l_dlygate4sd3_1
Xhold1344 _6449_/A1 _5543_/B vddd vssd sg13cmos5l_dlygate4sd3_1
XFILLER_27_35 vddd vssd sg13cmos5l_decap_8
XFILLER_22_1442 vddd vssd sg13cmos5l_decap_8
Xhold1355 _4919_/A1 _5784_/A vddd vssd sg13cmos5l_dlygate4sd3_1
XFILLER_2_2248 vddd vssd sg13cmos5l_decap_8
X_6098_ _6098_/Y _4023_/X _5169_/C _5169_/D vddd vssd sg13cmos5l_a21oi_1
Xhold1366 hold1366/X _7192_/Q vddd vssd sg13cmos5l_dlygate4sd3_1
Xhold1399 _3562_/A _5454_/A vddd vssd sg13cmos5l_dlygate4sd3_1
Xhold1388 _6415_/A1 _5416_/B vddd vssd sg13cmos5l_dlygate4sd3_1
X_5049_ _6013_/A _5234_/B _5115_/A vddd vssd sg13cmos5l_and2_1
XFILLER_25_297 vddd vssd sg13cmos5l_decap_4
XFILLER_5_647 vddd vssd sg13cmos5l_decap_8
XFILLER_11_2570 vddd vssd sg13cmos5l_decap_8
XFILLER_29_1618 vddd vssd sg13cmos5l_decap_8
XFILLER_4_28 vddd vssd sg13cmos5l_decap_8
XFILLER_11_1880 vddd vssd sg13cmos5l_decap_8
XFILLER_0_363 vddd vssd sg13cmos5l_decap_8
XFILLER_7_1436 vddd vssd sg13cmos5l_decap_8
XFILLER_0_385 vddd vssd sg13cmos5l_decap_4
XFILLER_29_570 vddd vssd sg13cmos5l_decap_8
XFILLER_31_212 vddd vssd sg13cmos5l_decap_8
XFILLER_32_768 vddd vssd sg13cmos5l_decap_8
XFILLER_9_997 vddd vssd sg13cmos5l_decap_8
XFILLER_9_986 vddd vssd sg13cmos5l_decap_8
XFILLER_12_1611 vddd vssd sg13cmos5l_decap_4
X_4420_ _4420_/Y _4420_/A _4420_/B vddd vssd sg13cmos5l_nor2_1
XFILLER_4_680 vddd vssd sg13cmos5l_decap_8
X_4351_ _4351_/Y _7083_/Q _4397_/A vddd vssd sg13cmos5l_nor2_1
Xfanout409 _6952_/B_N fanout417/X vddd vssd sg13cmos5l_buf_1
X_7070_ _7070_/Q _7143_/CLK _7070_/D fanout362/X vddd vssd sg13cmos5l_dfrbpq_1
X_4282_ _4283_/B _4282_/A _4301_/A _4282_/C vddd vssd sg13cmos5l_and3_1
X_6021_ _6021_/Y _3504_/Y _6128_/A2 _5241_/A vddd vssd sg13cmos5l_a21oi_1
XFILLER_27_518 vddd vssd sg13cmos5l_decap_8
XFILLER_23_2474 vddd vssd sg13cmos5l_decap_8
XFILLER_3_2546 vddd vssd sg13cmos5l_decap_8
XFILLER_12_0 vddd vssd sg13cmos5l_decap_8
XFILLER_23_1762 vddd vssd sg13cmos5l_decap_4
Xoutbuffers\[26\] voltgen_sink2[2] _7066_/Q vddd vssd sg13cmos5l_buf_16
X_6923_ _6923_/Y _6960_/A _6960_/B_N vddd vssd sg13cmos5l_nor2b_1
XFILLER_17_2201 vddd vssd sg13cmos5l_decap_8
X_6854_ _6854_/Y _6949_/A _6949_/B_N vddd vssd sg13cmos5l_nor2b_1
Xfanout38 _4818_/A fanout39/X vddd vssd sg13cmos5l_buf_1
Xfanout27 _4499_/A _4498_/Y vddd vssd sg13cmos5l_buf_1
X_6785_ _6785_/Y hold731/X _6784_/B _6784_/Y vddd vssd sg13cmos5l_o21ai_1
X_3997_ wire6/A _3997_/A _3997_/B vddd vssd sg13cmos5l_nand2_1
X_5805_ _5828_/C _7212_/Q _5815_/B vddd vssd sg13cmos5l_nand2_1
Xfanout49 _4958_/B _4923_/Y vddd vssd sg13cmos5l_buf_1
XFILLER_10_418 vddd vssd sg13cmos5l_decap_4
X_5736_ _5738_/A _5736_/A _7203_/Q _5736_/C vddd vssd sg13cmos5l_nor3_1
XFILLER_30_2445 vddd vssd sg13cmos5l_decap_8
X_5667_ _5667_/Y _6189_/A _7195_/Q _5659_/Y vddd vssd sg13cmos5l_a21oi_1
X_4618_ _4623_/A _4599_/B _4599_/C _3530_/Y vddd vssd sg13cmos5l_a21oi_1
X_5598_ _5598_/Y _5674_/A _5596_/C _5596_/Y vddd vssd sg13cmos5l_o21ai_1
XFILLER_11_1165 vddd vssd sg13cmos5l_decap_8
X_7337_ _7337_/Q _7337_/CLK _7337_/D _6850_/Y vddd vssd sg13cmos5l_dfrbpq_1
X_4549_ _4551_/B _4599_/A _4599_/B _4545_/A vddd vssd sg13cmos5l_o21ai_1
X_7268_ _7268_/Q _7275_/CLK _7268_/D fanout392/X vddd vssd sg13cmos5l_dfrbpq_1
Xhold496 _7006_/D _3464_/Y vddd vssd sg13cmos5l_dlygate4sd3_1
Xhold474 _4930_/A hold957/X vddd vssd sg13cmos5l_dlygate4sd3_1
Xhold485 sram_addr[3] _5990_/X vddd vssd sg13cmos5l_dlygate4sd3_1
XFILLER_28_2385 vddd vssd sg13cmos5l_decap_8
X_6219_ _6220_/C _6219_/A _6226_/B vddd vssd sg13cmos5l_nand2_1
XFILLER_24_1537 vddd vssd sg13cmos5l_decap_8
X_7199_ _7199_/Q _7199_/CLK _7199_/D fanout371/X vddd vssd sg13cmos5l_dfrbpq_1
Xhold1130 _7274_/D _6626_/X vddd vssd sg13cmos5l_dlygate4sd3_1
XFILLER_24_1559 vddd vssd sg13cmos5l_decap_8
Xhold1141 _4413_/B _4412_/Y vddd vssd sg13cmos5l_dlygate4sd3_1
Xhold1152 _6670_/A0 _7024_/Q vddd vssd sg13cmos5l_dlygate4sd3_1
Xhold1185 _6471_/A1 _5615_/B vddd vssd sg13cmos5l_dlygate4sd3_1
Xhold1163 _7265_/D _6612_/X vddd vssd sg13cmos5l_dlygate4sd3_1
Xhold1174 _3587_/A _7217_/Q vddd vssd sg13cmos5l_dlygate4sd3_1
XFILLER_6_1480 vddd vssd sg13cmos5l_decap_4
Xhold1196 _6411_/A1 _7155_/Q vddd vssd sg13cmos5l_dlygate4sd3_1
XFILLER_10_930 vddd vssd sg13cmos5l_decap_8
XFILLER_10_974 vddd vssd sg13cmos5l_decap_8
XFILLER_13_1997 vddd vssd sg13cmos5l_decap_8
Xtiedowns\[62\] mask_rev_in[18] vddd vssd sg13cmos5l_antennanp
XFILLER_6_978 vddd vssd sg13cmos5l_decap_4
X_3920_ _4123_/A _6773_/B _3957_/B vddd vssd sg13cmos5l_nor2_1
XFILLER_32_521 vddd vssd sg13cmos5l_decap_8
Xoutbuffers\[116\] dbus_out[19] _5860_/Y vddd vssd sg13cmos5l_buf_16
XFILLER_17_584 vddd vssd sg13cmos5l_decap_8
XFILLER_18_2565 vddd vssd sg13cmos5l_decap_8
X_3851_ _3852_/C mask_rev_in[20] _3908_/A _4251_/B vddd vssd sg13cmos5l_nor3_1
XFILLER_20_738 vddd vssd sg13cmos5l_decap_8
X_3782_ wire22/A _3779_/Y _3780_/Y _3748_/Y vddd vssd sg13cmos5l_o21ai_1
X_6570_ _6570_/Y _6570_/A _6575_/S vddd vssd sg13cmos5l_nor2_1
X_5521_ _5522_/B _5521_/A _5521_/B vddd vssd sg13cmos5l_nor2_1
XFILLER_30_1018 vddd vssd sg13cmos5l_decap_4
X_5452_ _5452_/X _5626_/A _5452_/B vddd vssd sg13cmos5l_and2_1
XFILLER_8_293 vddd vssd sg13cmos5l_decap_8
X_4403_ _4407_/A _4403_/A _4403_/B _4403_/C vddd vssd sg13cmos5l_nand3_1
X_5383_ _5387_/B _5393_/B _5383_/B vddd vssd sg13cmos5l_nor2_1
X_4334_ _4334_/Y _4319_/A _4344_/B _4319_/B vddd vssd sg13cmos5l_a21oi_1
X_7122_ _7122_/Q _7125_/CLK _7122_/D fanout395/X vddd vssd sg13cmos5l_dfrbpq_1
Xfanout228 _6963_/A _6919_/A vddd vssd sg13cmos5l_buf_1
XFILLER_25_2536 vddd vssd sg13cmos5l_decap_8
X_7053_ _7053_/Q _7060_/CLK _7053_/D fanout357/X vddd vssd sg13cmos5l_dfrbpq_1
Xfanout206 _6632_/A _6655_/A vddd vssd sg13cmos5l_buf_1
Xfanout217 _6827_/A _6828_/A vddd vssd sg13cmos5l_buf_1
XFILLER_5_93 vddd vssd sg13cmos5l_decap_8
X_6004_ _6004_/Y _6048_/A _5058_/A _6002_/Y _6003_/Y _5045_/X vddd vssd sg13cmos5l_a221oi_1
Xfanout239 _4388_/A hold1445/X vddd vssd sg13cmos5l_buf_1
X_4265_ _4265_/X _5030_/A _6330_/A _4271_/B vddd vssd sg13cmos5l_mux2_1
X_4196_ _4196_/X dbus_in_left[8] dbus_in_right[8] vddd vssd sg13cmos5l_or2_1
XFILLER_3_2343 vddd vssd sg13cmos5l_decap_4
XFILLER_3_1620 vddd vssd sg13cmos5l_decap_8
XFILLER_23_1592 vddd vssd sg13cmos5l_decap_8
XFILLER_24_14 vddd vssd sg13cmos5l_decap_8
XFILLER_23_521 vddd vssd sg13cmos5l_decap_8
X_6906_ _6906_/Y _6906_/A _6906_/B_N vddd vssd sg13cmos5l_nor2b_1
XFILLER_23_565 vddd vssd sg13cmos5l_decap_4
X_6837_ _6837_/Y _6837_/A _6877_/B_N vddd vssd sg13cmos5l_nor2b_1
XFILLER_11_705 vddd vssd sg13cmos5l_decap_8
XFILLER_23_598 vddd vssd sg13cmos5l_decap_8
XFILLER_17_2086 vddd vssd sg13cmos5l_decap_4
XFILLER_32_1817 vddd vssd sg13cmos5l_decap_8
X_6768_ _6768_/Y _6768_/A _6771_/B vddd vssd sg13cmos5l_nand2_1
X_6699_ _6707_/S _6699_/A _6699_/B vddd vssd sg13cmos5l_nand2_1
X_5719_ _5719_/Y _3545_/Y _5733_/A _5739_/B _3544_/Y _3581_/Y vddd vssd sg13cmos5l_a221oi_1
XFILLER_28_1481 vddd vssd sg13cmos5l_decap_8
XFILLER_24_2046 vddd vssd sg13cmos5l_decap_8
XFILLER_8_1553 vddd vssd sg13cmos5l_decap_4
XFILLER_8_2276 vddd vssd sg13cmos5l_decap_8
XFILLER_24_1323 vddd vssd sg13cmos5l_decap_8
XFILLER_19_805 vddd vssd sg13cmos5l_decap_8
XFILLER_4_1417 vddd vssd sg13cmos5l_decap_8
XFILLER_19_849 vddd vssd sg13cmos5l_decap_8
XFILLER_18_1105 vddd vssd sg13cmos5l_decap_8
XFILLER_14_554 vddd vssd sg13cmos5l_decap_8
XFILLER_13_2462 vddd vssd sg13cmos5l_decap_8
XFILLER_10_760 vddd vssd sg13cmos5l_decap_8
XFILLER_14_91 vddd vssd sg13cmos5l_decap_8
XFILLER_6_764 vddd vssd sg13cmos5l_decap_8
XFILLER_5_296 vddd vssd sg13cmos5l_decap_8
XFILLER_2_981 vddd vssd sg13cmos5l_decap_8
X_4050_ _4050_/Y _7154_/Q _4139_/B _3961_/Y vddd vssd sg13cmos5l_o21ai_1
XFILLER_20_2444 vddd vssd sg13cmos5l_decap_8
XFILLER_4_1940 vddd vssd sg13cmos5l_decap_8
XFILLER_0_2549 vddd vssd sg13cmos5l_decap_8
XFILLER_20_1743 vddd vssd sg13cmos5l_decap_8
XFILLER_18_871 vddd vssd sg13cmos5l_decap_4
XFILLER_24_329 vddd vssd sg13cmos5l_decap_8
X_4952_ _4952_/Y _4952_/A _4965_/B _4952_/C vddd vssd sg13cmos5l_nor3_1
XFILLER_0_1848 vddd vssd sg13cmos5l_decap_8
X_3903_ _6203_/A dbus_in_left[3] dbus_in_right[3] vddd vssd sg13cmos5l_nor2_1
X_4883_ _4883_/Y _4875_/Y _4878_/B _4882_/Y vddd vssd sg13cmos5l_a21oi_1
X_6622_ _6627_/B _6622_/A _6622_/B _6759_/C vddd vssd sg13cmos5l_nor3_1
X_3834_ _3834_/Y _3825_/Y wire58/X _3833_/Y vddd vssd sg13cmos5l_o21ai_1
XFILLER_18_1672 vddd vssd sg13cmos5l_decap_8
XFILLER_31_2573 vddd vssd sg13cmos5l_decap_8
X_6553_ _6553_/Y _6553_/A _6555_/S vddd vssd sg13cmos5l_nor2_1
X_3765_ _6699_/A _6361_/A _3934_/A vddd vssd sg13cmos5l_and2_1
Xoutbuffers\[93\] io_out[8] _6188_/X vddd vssd sg13cmos5l_buf_16
X_6484_ _7193_/D _6484_/A1 _6487_/B _6483_/Y vddd vssd sg13cmos5l_a21oi_1
X_5504_ _5505_/C _5513_/B _5507_/B _5492_/Y vddd vssd sg13cmos5l_a21oi_1
X_3696_ _3738_/B _3750_/A _3750_/B vddd vssd sg13cmos5l_nor2b_1
X_5435_ _5436_/B _5435_/A _5435_/B vddd vssd sg13cmos5l_nor2_1
XFILLER_10_16 vddd vssd sg13cmos5l_decap_8
XFILLER_9_2563 vddd vssd sg13cmos5l_decap_8
X_5366_ _5369_/A _5363_/B _5354_/Y _5365_/Y vddd vssd sg13cmos5l_o21ai_1
X_5297_ _5304_/B _7140_/Q _7141_/Q vddd vssd sg13cmos5l_nand2b_1
X_7105_ _7105_/Q _7105_/CLK _7105_/D _6846_/B_N vddd vssd sg13cmos5l_dfrbpq_1
X_4317_ _4318_/B _4317_/A _4317_/B vddd vssd sg13cmos5l_nor2_1
X_7036_ _7036_/Q _7379_/CLK _7036_/D _6871_/B_N vddd vssd sg13cmos5l_dfrbpq_1
XFILLER_19_14 vddd vssd sg13cmos5l_decap_8
X_4248_ _4250_/C _7082_/Q _6773_/A _6759_/B vddd vssd sg13cmos5l_nor3_1
XFILLER_9_1873 vddd vssd sg13cmos5l_decap_4
XFILLER_27_112 vddd vssd sg13cmos5l_decap_8
X_4179_ _4179_/Y _7292_/Q _6652_/A _4178_/Y vddd vssd sg13cmos5l_a21oi_1
XFILLER_28_679 vddd vssd sg13cmos5l_decap_8
XFILLER_27_189 vddd vssd sg13cmos5l_decap_8
XFILLER_19_2137 vddd vssd sg13cmos5l_decap_8
XFILLER_24_852 vddd vssd sg13cmos5l_decap_8
XFILLER_32_1647 vddd vssd sg13cmos5l_decap_8
XFILLER_13_1013 vddd vssd sg13cmos5l_decap_8
XFILLER_32_1669 vddd vssd sg13cmos5l_decap_4
XFILLER_10_1978 vddd vssd sg13cmos5l_decap_8
Xtiedowns\[25\] dbus_in_left[5] vddd vssd sg13cmos5l_antennanp
XFILLER_18_167 vddd vssd sg13cmos5l_decap_8
XFILLER_15_2535 vddd vssd sg13cmos5l_decap_8
XFILLER_19_1970 vddd vssd sg13cmos5l_decap_8
X_3550_ _5676_/A _5372_/A vddd vssd sg13cmos5l_inv_1
XFILLER_6_572 vddd vssd sg13cmos5l_decap_4
X_5220_ _5225_/C _5220_/A _5220_/B vddd vssd sg13cmos5l_nor2_1
X_3481_ _5285_/A _4826_/A vddd vssd sg13cmos5l_inv_1
X_5151_ _5221_/B _7251_/Q _7250_/Q vddd vssd sg13cmos5l_nand2b_1
XFILLER_26_1952 vddd vssd sg13cmos5l_decap_4
X_5082_ _5089_/D _7267_/Q _7266_/Q _5256_/B vddd vssd sg13cmos5l_nor3_1
X_4102_ _4102_/Y _7249_/Q _3889_/B _3895_/X vddd vssd sg13cmos5l_a21oi_1
XFILLER_9_1158 vddd vssd sg13cmos5l_decap_8
XFILLER_22_2539 vddd vssd sg13cmos5l_decap_8
X_4033_ _4033_/Y _5786_/C _6510_/A _6503_/A vddd vssd sg13cmos5l_a21oi_1
XFILLER_2_72 vddd vssd sg13cmos5l_decap_8
XFILLER_4_2460 vddd vssd sg13cmos5l_decap_8
XFILLER_25_638 vddd vssd sg13cmos5l_decap_8
XFILLER_24_126 vddd vssd sg13cmos5l_decap_8
X_5984_ _5984_/Y _5679_/A _5980_/Y _5983_/Y vddd vssd sg13cmos5l_a21oi_1
XFILLER_21_811 vddd vssd sg13cmos5l_decap_8
X_4935_ _4935_/Y _4863_/A _4945_/A _4941_/A vddd vssd sg13cmos5l_a21oi_1
X_4866_ _4900_/A _4866_/A _4866_/B _4866_/C vddd vssd sg13cmos5l_nand3_1
XANTENNA_11 _3838_/Y vddd vssd sg13cmos5l_antennanp
XANTENNA_22 wire14/X vddd vssd sg13cmos5l_antennanp
Xtiedowns\[9\] _5428_/A vddd vssd sg13cmos5l_antennanp
XANTENNA_55 _7044_/Q vddd vssd sg13cmos5l_antennanp
XANTENNA_44 _7072_/Q vddd vssd sg13cmos5l_antennanp
X_3817_ _3817_/Y _3978_/A _6773_/B vddd vssd sg13cmos5l_nor2_1
X_6605_ _6605_/Y _6605_/A _6608_/S vddd vssd sg13cmos5l_nand2_1
XFILLER_18_1491 vddd vssd sg13cmos5l_decap_8
X_4797_ _4799_/B _4780_/B _4796_/Y _4459_/Y vddd vssd sg13cmos5l_o21ai_1
XANTENNA_33 _6784_/A vddd vssd sg13cmos5l_antennanp
XFILLER_31_2370 vddd vssd sg13cmos5l_decap_8
X_6536_ _6536_/Y _6632_/A _6539_/S vddd vssd sg13cmos5l_nor2_1
X_3748_ _3748_/Y _3961_/A _3781_/B vddd vssd sg13cmos5l_nand2_1
X_6467_ _6473_/S _6467_/A _6660_/B vddd vssd sg13cmos5l_nand2_1
X_3679_ _3869_/A _3689_/B _3689_/A vddd vssd sg13cmos5l_nand2b_1
XFILLER_12_1090 vddd vssd sg13cmos5l_decap_8
XFILLER_27_2439 vddd vssd sg13cmos5l_decap_8
X_6398_ _6398_/Y _6398_/A1 _6397_/B _6397_/Y vddd vssd sg13cmos5l_a21oi_1
X_5418_ _5418_/Y _5416_/Y _5417_/Y _5413_/Y vddd vssd sg13cmos5l_a21oi_1
X_5349_ _5349_/Y _5604_/A1 _5345_/X _5348_/Y _5344_/Y vddd vssd sg13cmos5l_a22oi_1
XFILLER_5_1512 vddd vssd sg13cmos5l_decap_8
X_7019_ _7019_/Q _7188_/CLK _7019_/D fanout373/X vddd vssd sg13cmos5l_dfrbpq_1
XFILLER_29_988 vddd vssd sg13cmos5l_decap_8
XFILLER_5_1589 vddd vssd sg13cmos5l_decap_4
XFILLER_12_800 vddd vssd sg13cmos5l_decap_8
XFILLER_30_129 vddd vssd sg13cmos5l_decap_8
XFILLER_19_1288 vddd vssd sg13cmos5l_decap_8
XFILLER_15_1119 vddd vssd sg13cmos5l_decap_8
XFILLER_7_28 vddd vssd sg13cmos5l_decap_8
XFILLER_12_877 vddd vssd sg13cmos5l_decap_8
XFILLER_14_2590 vddd vssd sg13cmos5l_decap_8
XFILLER_32_1488 vddd vssd sg13cmos5l_decap_8
XFILLER_10_2454 vddd vssd sg13cmos5l_decap_8
XFILLER_10_1731 vddd vssd sg13cmos5l_decap_8
XFILLER_11_70 vddd vssd sg13cmos5l_decap_8
XFILLER_3_597 vddd vssd sg13cmos5l_decap_8
XFILLER_21_2561 vddd vssd sg13cmos5l_decap_8
XFILLER_19_421 vddd vssd sg13cmos5l_decap_8
XFILLER_16_7 vddd vssd sg13cmos5l_decap_8
XFILLER_1_1943 vddd vssd sg13cmos5l_decap_8
XFILLER_15_693 vddd vssd sg13cmos5l_decap_8
X_4720_ _4720_/Y _4628_/A _4705_/X _4511_/Y vddd vssd sg13cmos5l_o21ai_1
X_4651_ _4652_/B _4651_/A _4651_/B vddd vssd sg13cmos5l_nor2_1
XFILLER_15_1675 vddd vssd sg13cmos5l_decap_8
X_3602_ _3602_/Y _3602_/A vddd vssd sg13cmos5l_inv_1
X_4582_ _4583_/B _4789_/A _4582_/B vddd vssd sg13cmos5l_nor2_1
X_7370_ _7370_/Q _7372_/CLK _7370_/D _6883_/Y vddd vssd sg13cmos5l_dfrbpq_1
XFILLER_11_1539 vddd vssd sg13cmos5l_decap_4
X_6321_ _7108_/D hold819/X _6330_/B _6320_/Y vddd vssd sg13cmos5l_o21ai_1
Xhold837 _3608_/A _7109_/Q vddd vssd sg13cmos5l_dlygate4sd3_1
X_3533_ _5199_/B _3533_/A vddd vssd sg13cmos5l_inv_1
Xhold826 _6436_/A _7168_/Q vddd vssd sg13cmos5l_dlygate4sd3_1
Xhold804 _3601_/A _7102_/Q vddd vssd sg13cmos5l_dlygate4sd3_1
Xhold815 _3600_/A _7101_/Q vddd vssd sg13cmos5l_dlygate4sd3_1
X_3464_ _3464_/Y _4650_/A vddd vssd sg13cmos5l_inv_1
X_6252_ _6252_/Y _3819_/Y _5274_/Y _5279_/A vddd vssd sg13cmos5l_a21oi_1
Xhold859 hold859/X _7096_/Q vddd vssd sg13cmos5l_dlygate4sd3_1
Xhold848 _4286_/B _4285_/Y vddd vssd sg13cmos5l_dlygate4sd3_1
X_5203_ _5204_/D _5264_/B _5210_/B vddd vssd sg13cmos5l_nor2_1
X_6183_ _6183_/Y _6012_/A _5242_/A _6182_/Y vddd vssd sg13cmos5l_a21oi_1
X_5134_ _5137_/B _7259_/Q _7258_/Q _5212_/A vddd vssd sg13cmos5l_or3_1
XFILLER_6_2533 vddd vssd sg13cmos5l_decap_8
Xoutbuffers\[56\] voltgen_value[0] _7048_/Q vddd vssd sg13cmos5l_buf_16
XFILLER_29_207 vddd vssd sg13cmos5l_decap_8
XFILLER_26_2483 vddd vssd sg13cmos5l_decap_8
Xhold1504 hold504/A _7003_/Q vddd vssd sg13cmos5l_dlygate4sd3_1
Xhold1515 hold1515/X _7307_/Q vddd vssd sg13cmos5l_dlygate4sd3_1
XFILLER_6_1810 vddd vssd sg13cmos5l_decap_8
Xclkbuf_3_2_0_clk_regs clkbuf_3_2_0_clk_regs/X clkbuf_0_clk_regs/X vddd vssd sg13cmos5l_buf_8
X_5065_ _5090_/C _5115_/A _5253_/B vddd vssd sg13cmos5l_and2_1
Xclkbuf_leaf_9_SCK_regs _7060_/CLK clkload3/A vddd vssd sg13cmos5l_buf_8
XFILLER_0_2132 vddd vssd sg13cmos5l_decap_8
X_4016_ _4016_/Y _4013_/Y _4014_/Y _4015_/Y vddd vssd sg13cmos5l_o21ai_1
XFILLER_20_2082 vddd vssd sg13cmos5l_decap_8
XFILLER_0_2176 vddd vssd sg13cmos5l_decap_8
X_5967_ _5967_/Y _6221_/A _5967_/B _5983_/A vddd vssd sg13cmos5l_nor3_1
XFILLER_16_2118 vddd vssd sg13cmos5l_decap_8
XFILLER_0_1475 vddd vssd sg13cmos5l_decap_8
X_4918_ _4918_/Y _4920_/A sram_odata[1] _4918_/C vddd vssd sg13cmos5l_nand3_1
XFILLER_32_14 vddd vssd sg13cmos5l_decap_8
XFILLER_21_652 vddd vssd sg13cmos5l_decap_8
X_5898_ _5908_/B _5973_/A _5909_/B vddd vssd sg13cmos5l_nand2b_1
X_4849_ _4849_/Y sram_odata[3] _4856_/A2 _4848_/Y _4841_/B _4839_/B vddd vssd sg13cmos5l_a221oi_1
XFILLER_10_1005 vddd vssd sg13cmos5l_decap_4
X_6519_ _7212_/D _6519_/A1 _6524_/S _6518_/Y vddd vssd sg13cmos5l_a21oi_1
XFILLER_10_1049 vddd vssd sg13cmos5l_decap_4
XFILLER_27_1502 vddd vssd sg13cmos5l_decap_4
XFILLER_7_1607 vddd vssd sg13cmos5l_decap_8
XFILLER_5_2043 vddd vssd sg13cmos5l_decap_8
XFILLER_21_1134 vddd vssd sg13cmos5l_decap_8
XFILLER_29_785 vddd vssd sg13cmos5l_decap_4
XFILLER_19_1041 vddd vssd sg13cmos5l_decap_8
XFILLER_12_2505 vddd vssd sg13cmos5l_decap_8
XFILLER_32_1263 vddd vssd sg13cmos5l_decap_8
XFILLER_12_1815 vddd vssd sg13cmos5l_decap_8
XFILLER_22_91 vddd vssd sg13cmos5l_decap_8
XFILLER_4_895 vddd vssd sg13cmos5l_decap_8
XFILLER_21_1690 vddd vssd sg13cmos5l_decap_4
X_6870_ _6870_/Y _6881_/A _6892_/B_N vddd vssd sg13cmos5l_nor2b_1
XFILLER_17_2427 vddd vssd sg13cmos5l_decap_8
X_5821_ _5821_/Y _5818_/A _5820_/Y _5818_/Y vddd vssd sg13cmos5l_a21oi_1
XFILLER_17_1704 vddd vssd sg13cmos5l_decap_8
X_5752_ _5752_/Y _5765_/C _5751_/Y _5769_/A vddd vssd sg13cmos5l_o21ai_1
X_4703_ _4703_/Y _4769_/A1 _4685_/Y _4699_/X _4702_/Y vddd vssd sg13cmos5l_a22oi_1
X_5683_ _5683_/Y _5683_/A _5683_/B _7193_/Q vddd vssd sg13cmos5l_nor3_1
XFILLER_15_2162 vddd vssd sg13cmos5l_decap_8
XFILLER_30_1937 vddd vssd sg13cmos5l_decap_8
X_4634_ _4634_/Y _4680_/A _4630_/Y _4633_/X vddd vssd sg13cmos5l_a21oi_1
X_4565_ _4566_/C _4609_/A _4565_/B vddd vssd sg13cmos5l_nor2_1
Xhold601 hold601/X _4322_/Y vddd vssd sg13cmos5l_dlygate4sd3_1
Xhold612 hold612/X _6345_/Y vddd vssd sg13cmos5l_dlygate4sd3_1
X_7353_ _7353_/Q _7399_/CLK _7353_/D _6866_/Y vddd vssd sg13cmos5l_dfrbpq_1
X_3516_ _5784_/A _3516_/A vddd vssd sg13cmos5l_inv_1
Xhold623 _4835_/A _7325_/Q vddd vssd sg13cmos5l_dlygate4sd3_1
Xhold645 _6347_/A _7121_/Q vddd vssd sg13cmos5l_dlygate4sd3_1
Xhold634 _3647_/B _7323_/Q vddd vssd sg13cmos5l_dlygate4sd3_1
X_6304_ _6304_/Y _6304_/A _6759_/C vddd vssd sg13cmos5l_nor2_1
XFILLER_28_2567 vddd vssd sg13cmos5l_decap_8
X_4496_ _4496_/Y _4616_/A _4495_/Y _4493_/X vddd vssd sg13cmos5l_o21ai_1
Xhold678 _6381_/A _7139_/Q vddd vssd sg13cmos5l_dlygate4sd3_1
Xhold667 _7225_/D _6543_/X vddd vssd sg13cmos5l_dlygate4sd3_1
X_7284_ _7284_/Q _7287_/CLK _7284_/D _6829_/B_N vddd vssd sg13cmos5l_dfrbpq_1
Xhold656 _4839_/A _7324_/Q vddd vssd sg13cmos5l_dlygate4sd3_1
XFILLER_28_1833 vddd vssd sg13cmos5l_decap_8
X_6235_ _6235_/X _6235_/A _6235_/B vddd vssd sg13cmos5l_and2_1
Xhold689 _7253_/D _6592_/X vddd vssd sg13cmos5l_dlygate4sd3_1
XFILLER_22_2100 vddd vssd sg13cmos5l_decap_8
X_6166_ _6166_/Y _3510_/Y _7291_/Q _5247_/B vddd vssd sg13cmos5l_a21oi_1
Xhold1323 _7037_/D _6689_/X vddd vssd sg13cmos5l_dlygate4sd3_1
Xhold1334 _3576_/A _7193_/Q vddd vssd sg13cmos5l_dlygate4sd3_1
Xhold1312 _6554_/A1 _3622_/Y vddd vssd sg13cmos5l_dlygate4sd3_1
Xhold1301 _6532_/A1 _5857_/B vddd vssd sg13cmos5l_dlygate4sd3_1
X_5117_ _5269_/B _5117_/A _5163_/B vddd vssd sg13cmos5l_nand2_1
X_6097_ _6097_/Y _3904_/X _5169_/B _6095_/Y _6096_/Y vddd vssd sg13cmos5l_a22oi_1
Xhold1345 _7175_/D _6449_/X vddd vssd sg13cmos5l_dlygate4sd3_1
XFILLER_27_14 vddd vssd sg13cmos5l_decap_8
Xhold1356 _6665_/A1 _7021_/Q vddd vssd sg13cmos5l_dlygate4sd3_1
X_5048_ _5115_/A _7242_/Q _7243_/Q vddd vssd sg13cmos5l_nor2_1
XFILLER_6_1673 vddd vssd sg13cmos5l_decap_4
Xhold1367 _6481_/A _5683_/B vddd vssd sg13cmos5l_dlygate4sd3_1
Xhold1378 _6701_/B1 _6700_/Y vddd vssd sg13cmos5l_dlygate4sd3_1
Xhold1389 _6739_/A0 _7071_/Q vddd vssd sg13cmos5l_dlygate4sd3_1
X_6999_ _6999_/Q _7003_/CLK _6999_/D _6946_/Y vddd vssd sg13cmos5l_dfrbpq_1
XFILLER_22_972 vddd vssd sg13cmos5l_decap_4
XFILLER_21_482 vddd vssd sg13cmos5l_decap_4
XFILLER_4_158 vddd vssd sg13cmos5l_decap_8
XFILLER_7_2105 vddd vssd sg13cmos5l_decap_8
XFILLER_0_342 vddd vssd sg13cmos5l_decap_8
XFILLER_32_747 vddd vssd sg13cmos5l_decap_8
XFILLER_13_972 vddd vssd sg13cmos5l_decap_4
XFILLER_9_932 vddd vssd sg13cmos5l_decap_4
XFILLER_8_442 vddd vssd sg13cmos5l_decap_8
XFILLER_8_497 vddd vssd sg13cmos5l_decap_8
X_4350_ _4350_/Y _7088_/Q _4403_/B vddd vssd sg13cmos5l_nand2b_1
XFILLER_28_1129 vddd vssd sg13cmos5l_decap_8
X_4281_ _4281_/Y _6693_/A1 _4280_/B hold606/X vddd vssd sg13cmos5l_o21ai_1
X_6020_ _6020_/X _5090_/B _6019_/Y _6017_/Y vddd vssd sg13cmos5l_a21o_1
XFILLER_23_2453 vddd vssd sg13cmos5l_decap_8
XFILLER_23_1730 vddd vssd sg13cmos5l_decap_8
XFILLER_3_2536 vddd vssd sg13cmos5l_decap_4
XFILLER_7_1982 vddd vssd sg13cmos5l_decap_8
X_6922_ _6922_/Y _6961_/A _6961_/B_N vddd vssd sg13cmos5l_nor2b_1
Xoutbuffers\[19\] voltgen_source[0] _7067_/Q vddd vssd sg13cmos5l_buf_16
X_6853_ _6853_/Y _6958_/A _6958_/B_N vddd vssd sg13cmos5l_nor2b_1
XFILLER_23_736 vddd vssd sg13cmos5l_decap_8
Xfanout28 _4839_/B _4859_/A2 vddd vssd sg13cmos5l_buf_1
X_5804_ _5829_/A _7212_/Q _7213_/Q _5828_/B vddd vssd sg13cmos5l_nor3_1
Xfanout39 fanout39/X _4392_/X vddd vssd sg13cmos5l_buf_1
XFILLER_17_1534 vddd vssd sg13cmos5l_decap_8
X_6784_ _6784_/Y _6784_/A _6784_/B vddd vssd sg13cmos5l_nand2_1
X_3996_ _3997_/B mask_rev_in[27] _3852_/A _3994_/Y _3995_/Y vddd vssd sg13cmos5l_a22oi_1
XFILLER_30_2424 vddd vssd sg13cmos5l_decap_8
X_5735_ _5735_/Y _5674_/A _5734_/C _5734_/Y vddd vssd sg13cmos5l_o21ai_1
X_5666_ _5666_/Y _5660_/Y _5665_/Y _3577_/Y vddd vssd sg13cmos5l_o21ai_1
XFILLER_17_1589 vddd vssd sg13cmos5l_decap_8
XFILLER_13_49 vddd vssd sg13cmos5l_decap_8
X_4617_ _4617_/Y _4613_/Y _4616_/Y _4511_/A vddd vssd sg13cmos5l_o21ai_1
X_5597_ _5597_/Y _5597_/A _7183_/Q _5597_/C vddd vssd sg13cmos5l_nor3_1
XFILLER_11_1144 vddd vssd sg13cmos5l_decap_4
X_7336_ _7336_/Q _7338_/CLK _7336_/D _6849_/Y vddd vssd sg13cmos5l_dfrbpq_1
X_4548_ _4552_/B _4530_/B _4530_/C _3530_/Y vddd vssd sg13cmos5l_a21oi_1
XFILLER_1_106 vddd vssd sg13cmos5l_decap_8
XFILLER_28_2364 vddd vssd sg13cmos5l_decap_8
X_7267_ _7267_/Q _7278_/CLK _7267_/D fanout393/X vddd vssd sg13cmos5l_dfrbpq_1
Xhold475 sram_addr[4] _5991_/X vddd vssd sg13cmos5l_dlygate4sd3_1
X_4479_ _4484_/A _4745_/B1 _4478_/Y _4476_/Y vddd vssd sg13cmos5l_a21oi_1
Xhold486 _4932_/A hold486/A vddd vssd sg13cmos5l_dlygate4sd3_1
XFILLER_28_1663 vddd vssd sg13cmos5l_decap_8
Xhold497 _7003_/D hold497/A vddd vssd sg13cmos5l_dlygate4sd3_1
X_6218_ _6234_/B _6233_/B _6221_/B vddd vssd sg13cmos5l_nor2_1
XFILLER_24_1516 vddd vssd sg13cmos5l_decap_8
X_7198_ _7198_/Q _7295_/CLK _7198_/D fanout371/X vddd vssd sg13cmos5l_dfrbpq_1
Xclkbuf_1_0__f_SCK clkload1/A clkbuf_0_SCK/X vddd vssd sg13cmos5l_buf_8
X_6149_ _6168_/A _6149_/A1 _6063_/B _6148_/Y vddd vssd sg13cmos5l_o21ai_1
Xhold1120 _6568_/A1 _7239_/Q vddd vssd sg13cmos5l_dlygate4sd3_1
Xhold1142 _7347_/D _4413_/Y vddd vssd sg13cmos5l_dlygate4sd3_1
Xhold1131 _3569_/A _7178_/Q vddd vssd sg13cmos5l_dlygate4sd3_1
Xhold1164 _6706_/A1 _7049_/Q vddd vssd sg13cmos5l_dlygate4sd3_1
Xhold1153 _7024_/D _6670_/X vddd vssd sg13cmos5l_dlygate4sd3_1
Xhold1175 _6529_/A1 _5841_/B vddd vssd sg13cmos5l_dlygate4sd3_1
XFILLER_22_1262 vddd vssd sg13cmos5l_decap_8
Xhold1186 _6717_/A0 _7055_/Q vddd vssd sg13cmos5l_dlygate4sd3_1
Xhold1197 _7155_/D _6411_/X vddd vssd sg13cmos5l_dlygate4sd3_1
XFILLER_26_596 vddd vssd sg13cmos5l_decap_8
XFILLER_5_434 vddd vssd sg13cmos5l_decap_8
XFILLER_29_2139 vddd vssd sg13cmos5l_decap_4
Xtiedowns\[55\] mask_rev_in[11] vddd vssd sg13cmos5l_antennanp
XFILLER_7_1267 vddd vssd sg13cmos5l_decap_8
XFILLER_18_2544 vddd vssd sg13cmos5l_decap_8
X_3850_ _3852_/B mask_rev_in[12] _4077_/B _3848_/Y _3849_/Y _4168_/B1 vddd vssd sg13cmos5l_a221oi_1
Xoutbuffers\[109\] dbus_out[12] _5658_/Y vddd vssd sg13cmos5l_buf_16
X_3781_ _3997_/A _3887_/B _3781_/B vddd vssd sg13cmos5l_nand2_1
X_5520_ _5521_/B _3544_/A _5543_/C _5540_/B vddd vssd sg13cmos5l_o21ai_1
Xclkbuf_leaf_23_SCK_regs _7294_/CLK clkload8/A vddd vssd sg13cmos5l_buf_8
X_5451_ _5451_/Y _5594_/A _5449_/B _5449_/Y _5443_/Y _5452_/B vddd vssd sg13cmos5l_a221oi_1
X_4402_ _4412_/A _4403_/A _4402_/B vddd vssd sg13cmos5l_nand2_1
X_5382_ _5383_/B _3544_/Y _7152_/Q _5381_/Y vddd vssd sg13cmos5l_a21oi_1
X_4333_ _4333_/Y _4336_/A _4333_/B _4336_/C vddd vssd sg13cmos5l_nand3_1
XFILLER_5_72 vddd vssd sg13cmos5l_decap_8
X_7121_ _7121_/Q _7255_/CLK _7121_/D fanout395/X vddd vssd sg13cmos5l_dfrbpq_1
XFILLER_25_2515 vddd vssd sg13cmos5l_decap_8
X_7052_ _7052_/Q _7060_/CLK _7052_/D _6820_/B_N vddd vssd sg13cmos5l_dfrbpq_1
Xfanout229 _6919_/A _6863_/A vddd vssd sg13cmos5l_buf_1
Xfanout207 _6655_/A _6625_/A1 vddd vssd sg13cmos5l_buf_1
Xfanout218 _6828_/A _6829_/A vddd vssd sg13cmos5l_buf_1
X_4264_ _4271_/B _4264_/A _4296_/B vddd vssd sg13cmos5l_nand2_1
X_6003_ _6003_/Y _4107_/Y _5058_/B _5058_/A vddd vssd sg13cmos5l_a21oi_1
X_4195_ _4195_/Y dbus_in_left[8] dbus_in_right[8] vddd vssd sg13cmos5l_nor2_1
XFILLER_25_1858 vddd vssd sg13cmos5l_decap_8
XFILLER_7_2480 vddd vssd sg13cmos5l_decap_8
XFILLER_7_2491 vddd vssd sg13cmos5l_decap_8
XFILLER_28_828 vddd vssd sg13cmos5l_decap_8
X_6905_ _6905_/Y _6908_/A _6906_/B_N vddd vssd sg13cmos5l_nor2b_1
XFILLER_23_500 vddd vssd sg13cmos5l_decap_8
X_6836_ _6836_/Y _6837_/A _6877_/B_N vddd vssd sg13cmos5l_nor2b_1
X_6767_ _6767_/X hold843/X _6324_/A _6767_/S vddd vssd sg13cmos5l_mux2_1
X_3979_ _3979_/Y _7037_/Q _3828_/Y _3983_/B vddd vssd sg13cmos5l_a21oi_1
X_5718_ _5739_/B _7201_/Q _7200_/Q vddd vssd sg13cmos5l_nor2b_1
X_6698_ _6698_/X _6698_/A0 _5028_/A _6698_/S vddd vssd sg13cmos5l_mux2_1
X_5649_ _5653_/B _5649_/A1 _5651_/B _5648_/Y vddd vssd sg13cmos5l_o21ai_1
X_7319_ _7319_/Q _7395_/CLK _7319_/D _6832_/Y vddd vssd sg13cmos5l_dfrbpq_1
XFILLER_24_2014 vddd vssd sg13cmos5l_decap_8
XFILLER_8_1521 vddd vssd sg13cmos5l_decap_4
XFILLER_19_828 vddd vssd sg13cmos5l_decap_8
XFILLER_27_861 vddd vssd sg13cmos5l_decap_8
XFILLER_22_1092 vddd vssd sg13cmos5l_decap_8
XFILLER_13_2441 vddd vssd sg13cmos5l_decap_8
XFILLER_14_70 vddd vssd sg13cmos5l_decap_8
XFILLER_6_743 vddd vssd sg13cmos5l_decap_8
XFILLER_10_794 vddd vssd sg13cmos5l_decap_4
XFILLER_29_1224 vddd vssd sg13cmos5l_decap_8
XFILLER_29_1257 vddd vssd sg13cmos5l_decap_8
XFILLER_9_1318 vddd vssd sg13cmos5l_decap_8
XFILLER_0_2528 vddd vssd sg13cmos5l_decap_8
XFILLER_0_1827 vddd vssd sg13cmos5l_decap_8
X_4951_ _4952_/C _4951_/A _4955_/A vddd vssd sg13cmos5l_nor2_1
X_3902_ _6556_/A _3922_/A _6609_/B vddd vssd sg13cmos5l_nor2_1
X_4882_ _4882_/Y _4899_/A _4896_/B _4901_/A vddd vssd sg13cmos5l_a21oi_1
X_6621_ _6621_/X _6621_/A0 _6627_/A _6621_/S vddd vssd sg13cmos5l_mux2_1
X_3833_ _3833_/Y _7048_/Q _4231_/C1 _3831_/X _7043_/Q _3828_/Y vddd vssd sg13cmos5l_a221oi_1
XFILLER_18_2374 vddd vssd sg13cmos5l_decap_8
XFILLER_18_1651 vddd vssd sg13cmos5l_decap_8
XFILLER_32_385 vddd vssd sg13cmos5l_decap_8
XFILLER_20_547 vddd vssd sg13cmos5l_decap_8
XFILLER_31_2552 vddd vssd sg13cmos5l_decap_8
X_3764_ _3934_/A _3863_/C _3869_/D vddd vssd sg13cmos5l_nor2_1
X_6552_ _7229_/D _6552_/A1 _6555_/S _6551_/Y vddd vssd sg13cmos5l_a21oi_1
X_6483_ _6483_/Y _6520_/A _6487_/B vddd vssd sg13cmos5l_nor2_1
X_3695_ _3695_/Y _6315_/A _6315_/B vddd vssd sg13cmos5l_nor2_1
X_5503_ _5505_/B _5511_/C _5503_/B vddd vssd sg13cmos5l_nand2b_1
X_5434_ _5435_/B _3544_/A _5457_/C _7163_/Q vddd vssd sg13cmos5l_o21ai_1
Xoutbuffers\[86\] io_out[1] _6040_/Y vddd vssd sg13cmos5l_buf_16
XFILLER_25_2301 vddd vssd sg13cmos5l_decap_4
X_7104_ _7104_/Q _7105_/CLK _7104_/D _6844_/B_N vddd vssd sg13cmos5l_dfrbpq_1
XFILLER_9_2542 vddd vssd sg13cmos5l_decap_8
X_5365_ _5365_/Y _5371_/C _5360_/Y _5368_/B _5374_/B _5364_/Y vddd vssd sg13cmos5l_a221oi_1
XFILLER_29_2492 vddd vssd sg13cmos5l_decap_8
XFILLER_29_1780 vddd vssd sg13cmos5l_decap_8
X_5296_ _5296_/Y _7140_/Q _7141_/Q _5316_/A _5304_/A vddd vssd sg13cmos5l_nor4_1
X_4316_ _4317_/B _4316_/A _4316_/B vddd vssd sg13cmos5l_or2_1
X_7035_ _7035_/Q _7066_/CLK _7035_/D fanout346/X vddd vssd sg13cmos5l_dfrbpq_1
XFILLER_25_2389 vddd vssd sg13cmos5l_decap_8
XFILLER_5_1716 vddd vssd sg13cmos5l_decap_4
X_4247_ _4250_/B _4460_/A _6748_/A _4245_/X _4246_/Y _3733_/Y vddd vssd sg13cmos5l_a221oi_1
X_4178_ _4178_/Y _4178_/A _4178_/B vddd vssd sg13cmos5l_nand2_1
XFILLER_27_168 vddd vssd sg13cmos5l_decap_8
XFILLER_3_1451 vddd vssd sg13cmos5l_decap_8
XFILLER_24_820 vddd vssd sg13cmos5l_decap_8
XFILLER_19_2116 vddd vssd sg13cmos5l_decap_8
XFILLER_19_1415 vddd vssd sg13cmos5l_decap_4
X_6819_ _6819_/Y _6906_/A _6871_/B_N vddd vssd sg13cmos5l_nor2b_1
XFILLER_32_2349 vddd vssd sg13cmos5l_decap_8
XFILLER_32_1626 vddd vssd sg13cmos5l_decap_8
XFILLER_3_746 vddd vssd sg13cmos5l_decap_8
XFILLER_10_1957 vddd vssd sg13cmos5l_decap_8
XFILLER_8_2096 vddd vssd sg13cmos5l_decap_8
Xtiedowns\[18\] _6227_/A1 vddd vssd sg13cmos5l_antennanp
XFILLER_15_2514 vddd vssd sg13cmos5l_decap_8
X_3480_ _3480_/Y _4812_/B vddd vssd sg13cmos5l_inv_1
XFILLER_9_1104 vddd vssd sg13cmos5l_decap_8
XFILLER_29_1065 vddd vssd sg13cmos5l_decap_4
X_5150_ _5169_/A _5240_/A _5240_/B _5220_/B vddd vssd sg13cmos5l_nor3_1
X_5081_ _5256_/B _7265_/Q _7264_/Q vddd vssd sg13cmos5l_nand2b_1
XFILLER_22_2518 vddd vssd sg13cmos5l_decap_8
X_4101_ _4101_/X _4098_/Y _4099_/Y _4100_/Y vddd vssd sg13cmos5l_a21o_1
XFILLER_2_51 vddd vssd sg13cmos5l_decap_8
X_4032_ _4032_/Y _4030_/Y _4032_/B vddd vssd sg13cmos5l_nand2b_1
XFILLER_24_105 vddd vssd sg13cmos5l_decap_8
X_5983_ _5983_/Y _5983_/A _7235_/Q _5983_/C vddd vssd sg13cmos5l_nor3_1
XFILLER_20_1563 vddd vssd sg13cmos5l_decap_8
XFILLER_18_691 vddd vssd sg13cmos5l_decap_8
X_4934_ _4945_/A _7297_/Q _4934_/B _4934_/C vddd vssd sg13cmos5l_nand3_1
XFILLER_21_823 vddd vssd sg13cmos5l_decap_8
XFILLER_32_182 vddd vssd sg13cmos5l_decap_8
X_4865_ _4866_/C _4933_/A _7138_/Q vddd vssd sg13cmos5l_or2_1
XANTENNA_12 _7378_/Q vddd vssd sg13cmos5l_antennanp
XANTENNA_23 wire17/X vddd vssd sg13cmos5l_antennanp
X_3816_ _3822_/B _7030_/Q _4176_/A2 _6660_/A _7022_/Q vddd vssd sg13cmos5l_a22oi_1
X_6604_ _7260_/D _6710_/A1 _6608_/S hold990/X vddd vssd sg13cmos5l_a21oi_1
XFILLER_18_1470 vddd vssd sg13cmos5l_decap_8
XANTENNA_34 _6784_/A vddd vssd sg13cmos5l_antennanp
X_4796_ _4796_/Y _5329_/A _4815_/A _4671_/A vddd vssd sg13cmos5l_o21ai_1
XANTENNA_45 _7335_/Q vddd vssd sg13cmos5l_antennanp
X_3747_ _3757_/A mask_rev_in[23] _4168_/B1 _3744_/Y _3742_/Y _3852_/A vddd vssd sg13cmos5l_a221oi_1
X_6535_ _7220_/D _6535_/A1 _6539_/S _6534_/Y vddd vssd sg13cmos5l_a21oi_1
XFILLER_21_49 vddd vssd sg13cmos5l_decap_8
XFILLER_10_1209 vddd vssd sg13cmos5l_decap_8
X_6466_ _6466_/Y _6466_/A1 _6465_/B _6465_/Y vddd vssd sg13cmos5l_a21oi_1
X_3678_ _3689_/B _4327_/A _7358_/Q _3678_/S vddd vssd sg13cmos5l_mux2_1
XFILLER_27_2418 vddd vssd sg13cmos5l_decap_8
X_6397_ _6397_/Y _6404_/A _6397_/B vddd vssd sg13cmos5l_nor2_1
X_5417_ _5417_/Y _3546_/Y _5408_/B _5415_/Y _7158_/Q vddd vssd sg13cmos5l_a22oi_1
XFILLER_27_1706 vddd vssd sg13cmos5l_decap_8
X_5348_ _5348_/Y _5345_/A _5347_/Y _5345_/B vddd vssd sg13cmos5l_o21ai_1
Xclkbuf_3_7_0_SCK_regs clkload8/A clkbuf_0_SCK_regs/X vddd vssd sg13cmos5l_buf_8
XFILLER_0_727 vddd vssd sg13cmos5l_decap_4
X_7018_ _7018_/Q _7191_/CLK _7018_/D fanout373/X vddd vssd sg13cmos5l_dfrbpq_1
X_5279_ _5280_/D _5279_/A _5279_/B _5279_/C _6248_/A vddd vssd sg13cmos5l_nor4_1
XFILLER_29_967 vddd vssd sg13cmos5l_decap_8
XFILLER_30_108 vddd vssd sg13cmos5l_decap_8
XFILLER_32_2124 vddd vssd sg13cmos5l_decap_8
XFILLER_23_182 vddd vssd sg13cmos5l_decap_8
XFILLER_19_1267 vddd vssd sg13cmos5l_decap_8
XFILLER_11_300 vddd vssd sg13cmos5l_decap_8
XFILLER_12_856 vddd vssd sg13cmos5l_decap_8
XFILLER_32_1401 vddd vssd sg13cmos5l_decap_8
XFILLER_32_1445 vddd vssd sg13cmos5l_decap_8
XFILLER_7_348 vddd vssd sg13cmos5l_decap_8
XFILLER_32_1467 vddd vssd sg13cmos5l_decap_4
XFILLER_3_554 vddd vssd sg13cmos5l_decap_8
XFILLER_2_0 vddd vssd sg13cmos5l_decap_8
XFILLER_21_2540 vddd vssd sg13cmos5l_decap_8
XFILLER_19_400 vddd vssd sg13cmos5l_decap_8
Xfanout390 fanout390/X fanout391/X vddd vssd sg13cmos5l_buf_1
XFILLER_19_444 vddd vssd sg13cmos5l_decap_8
XFILLER_21_119 vddd vssd sg13cmos5l_decap_4
X_4650_ _4651_/B _4650_/A _4650_/B vddd vssd sg13cmos5l_xor2_1
XFILLER_15_1632 vddd vssd sg13cmos5l_decap_8
XFILLER_14_193 vddd vssd sg13cmos5l_decap_8
XFILLER_15_1654 vddd vssd sg13cmos5l_decap_8
X_3601_ _3601_/Y _3601_/A vddd vssd sg13cmos5l_inv_1
XFILLER_11_2219 vddd vssd sg13cmos5l_decap_8
X_4581_ _4582_/B _6796_/A _7009_/D vddd vssd sg13cmos5l_xor2_1
X_6320_ _6320_/Y _6599_/A _6320_/B vddd vssd sg13cmos5l_nand2_1
XFILLER_11_1518 vddd vssd sg13cmos5l_decap_8
Xhold827 hold827/X _6436_/Y vddd vssd sg13cmos5l_dlygate4sd3_1
X_3532_ _5117_/A _3532_/A vddd vssd sg13cmos5l_inv_1
Xhold816 hold816/X _3600_/Y vddd vssd sg13cmos5l_dlygate4sd3_1
Xhold805 hold805/X _3601_/Y vddd vssd sg13cmos5l_dlygate4sd3_1
X_3463_ _3463_/Y _4533_/A vddd vssd sg13cmos5l_inv_1
X_6251_ _6251_/Y _5279_/C _6249_/Y _6250_/Y vddd vssd sg13cmos5l_o21ai_1
Xhold838 hold838/X _3608_/Y vddd vssd sg13cmos5l_dlygate4sd3_1
Xhold849 _7369_/D _4291_/Y vddd vssd sg13cmos5l_dlygate4sd3_1
XFILLER_6_392 vddd vssd sg13cmos5l_decap_8
X_5202_ _5207_/C _5215_/B _5202_/B _7277_/Q vddd vssd sg13cmos5l_nand3b_1
X_6182_ _6182_/Y _3904_/X _5242_/B _6180_/Y _6181_/Y _5242_/A vddd vssd sg13cmos5l_a221oi_1
XFILLER_26_2462 vddd vssd sg13cmos5l_decap_8
X_5133_ _5139_/C _5219_/A _5133_/B vddd vssd sg13cmos5l_nand2b_1
XFILLER_6_2512 vddd vssd sg13cmos5l_decap_8
Xhold1505 hold505/A _7006_/Q vddd vssd sg13cmos5l_dlygate4sd3_1
Xhold1516 hold894/A _7298_/Q vddd vssd sg13cmos5l_dlygate4sd3_1
Xoutbuffers\[49\] bandgap_trim[10] _6298_/Y vddd vssd sg13cmos5l_buf_16
XFILLER_26_1783 vddd vssd sg13cmos5l_decap_8
X_5064_ _5253_/B _7241_/Q _7240_/Q vddd vssd sg13cmos5l_nor2b_1
XFILLER_22_1669 vddd vssd sg13cmos5l_decap_8
XFILLER_22_1658 vddd vssd sg13cmos5l_decap_4
XFILLER_0_2111 vddd vssd sg13cmos5l_decap_8
X_4015_ _4015_/Y _7246_/Q _3895_/X _4017_/B vddd vssd sg13cmos5l_a21oi_1
XFILLER_16_49 vddd vssd sg13cmos5l_decap_8
X_5966_ _5966_/Y _5979_/C _5965_/Y _5983_/A vddd vssd sg13cmos5l_o21ai_1
X_5897_ _5907_/B _5897_/A _5910_/B _5910_/C vddd vssd sg13cmos5l_nor3_1
X_4917_ _7311_/D _4917_/A1 _4918_/C _4916_/Y vddd vssd sg13cmos5l_o21ai_1
XFILLER_16_1429 vddd vssd sg13cmos5l_decap_8
X_4848_ _4848_/Y _4848_/A _4848_/B vddd vssd sg13cmos5l_xnor2_1
XFILLER_21_686 vddd vssd sg13cmos5l_decap_8
XFILLER_14_1131 vddd vssd sg13cmos5l_decap_8
X_4779_ _4779_/Y _4778_/A _4779_/B vddd vssd sg13cmos5l_nand2b_1
X_6518_ _6518_/Y _6518_/A _6524_/S vddd vssd sg13cmos5l_nor2_1
XFILLER_10_1028 vddd vssd sg13cmos5l_decap_8
X_6449_ _6449_/X _6465_/A _6449_/A1 _6449_/S vddd vssd sg13cmos5l_mux2_1
XFILLER_27_2226 vddd vssd sg13cmos5l_decap_8
XFILLER_0_524 vddd vssd sg13cmos5l_decap_8
XFILLER_17_904 vddd vssd sg13cmos5l_decap_8
XFILLER_5_1343 vddd vssd sg13cmos5l_decap_8
XFILLER_28_263 vddd vssd sg13cmos5l_decap_8
XFILLER_1_1218 vddd vssd sg13cmos5l_decap_8
XFILLER_28_296 vddd vssd sg13cmos5l_decap_8
XFILLER_16_447 vddd vssd sg13cmos5l_decap_8
XFILLER_32_929 vddd vssd sg13cmos5l_decap_8
XFILLER_25_970 vddd vssd sg13cmos5l_decap_8
XFILLER_8_602 vddd vssd sg13cmos5l_decap_4
XFILLER_12_675 vddd vssd sg13cmos5l_decap_8
XFILLER_32_1242 vddd vssd sg13cmos5l_decap_8
XFILLER_22_70 vddd vssd sg13cmos5l_decap_8
XFILLER_4_830 vddd vssd sg13cmos5l_decap_8
XFILLER_10_2296 vddd vssd sg13cmos5l_decap_4
XFILLER_23_1923 vddd vssd sg13cmos5l_decap_8
X_5820_ _5820_/Y _5973_/A _7214_/Q _5819_/X vddd vssd sg13cmos5l_o21ai_1
X_5751_ _5751_/Y _7309_/Q _5769_/B vddd vssd sg13cmos5l_nor2b_1
XFILLER_31_973 vddd vssd sg13cmos5l_decap_8
X_4702_ _4702_/Y _4511_/A _4701_/Y _4769_/A1 vddd vssd sg13cmos5l_a21oi_1
X_5682_ _5682_/Y _5682_/A _5682_/B _5682_/C vddd vssd sg13cmos5l_nand3_1
X_4633_ _4633_/X _4633_/A _4633_/B vddd vssd sg13cmos5l_or2_1
X_4564_ _4565_/B _4608_/A1 _3609_/Y _4794_/B1 _4560_/B vddd vssd sg13cmos5l_a22oi_1
Xhold602 _7361_/D _4325_/Y vddd vssd sg13cmos5l_dlygate4sd3_1
X_7352_ _7352_/Q _7399_/CLK _7352_/D _6865_/Y vddd vssd sg13cmos5l_dfrbpq_1
X_7283_ _7283_/Q _7293_/CLK _7283_/D fanout383/X vddd vssd sg13cmos5l_dfrbpq_1
X_3515_ _5813_/A _3515_/A vddd vssd sg13cmos5l_inv_1
Xhold624 hold624/X _4835_/Y vddd vssd sg13cmos5l_dlygate4sd3_1
Xhold635 hold635/X _4842_/Y vddd vssd sg13cmos5l_dlygate4sd3_1
Xhold613 _7120_/D _6346_/Y vddd vssd sg13cmos5l_dlygate4sd3_1
X_6303_ _6303_/Y _6302_/A _7382_/Q vddd vssd sg13cmos5l_nand2b_1
XFILLER_28_2546 vddd vssd sg13cmos5l_decap_8
X_6234_ _6235_/B _6234_/A _6234_/B vddd vssd sg13cmos5l_nand2_1
X_4495_ _4495_/Y _4614_/B _3611_/Y _4494_/Y vddd vssd sg13cmos5l_a21oi_1
Xhold679 hold679/X _6381_/Y vddd vssd sg13cmos5l_dlygate4sd3_1
Xhold668 _6335_/A _7115_/Q vddd vssd sg13cmos5l_dlygate4sd3_1
Xhold657 hold657/X _4839_/Y vddd vssd sg13cmos5l_dlygate4sd3_1
Xhold646 hold646/X _6347_/Y vddd vssd sg13cmos5l_dlygate4sd3_1
X_6165_ _6165_/Y _6122_/A _5222_/C _6164_/Y vddd vssd sg13cmos5l_a21oi_1
Xhold1324 _6698_/A0 _7043_/Q vddd vssd sg13cmos5l_dlygate4sd3_1
Xhold1313 _7230_/D _6554_/Y vddd vssd sg13cmos5l_dlygate4sd3_1
Xhold1302 _6648_/A0 _7288_/Q vddd vssd sg13cmos5l_dlygate4sd3_1
X_5116_ _5118_/B _7236_/Q _5163_/B vddd vssd sg13cmos5l_nor2b_1
XFILLER_6_2353 vddd vssd sg13cmos5l_decap_8
X_6096_ _6096_/Y _3819_/Y _5169_/A _5169_/B vddd vssd sg13cmos5l_a21oi_1
Xhold1357 _7021_/D _6665_/X vddd vssd sg13cmos5l_dlygate4sd3_1
Xhold1346 _6688_/A0 _7036_/Q vddd vssd sg13cmos5l_dlygate4sd3_1
Xhold1335 _6484_/A1 _5682_/A vddd vssd sg13cmos5l_dlygate4sd3_1
Xhold1368 hold1368/X _7209_/Q vddd vssd sg13cmos5l_dlygate4sd3_1
X_5047_ _5234_/B _7240_/Q _7241_/Q vddd vssd sg13cmos5l_nor2_1
XFILLER_2_1516 vddd vssd sg13cmos5l_decap_4
Xhold1379 hold1379/X _7150_/Q vddd vssd sg13cmos5l_dlygate4sd3_1
X_6998_ _6998_/Q _7016_/CLK _6998_/D _6945_/Y vddd vssd sg13cmos5l_dfrbpq_1
XFILLER_26_778 vddd vssd sg13cmos5l_decap_8
XFILLER_20_1190 vddd vssd sg13cmos5l_decap_8
X_5949_ _5949_/Y _5949_/A _5949_/B _5949_/C vddd vssd sg13cmos5l_nand3_1
XFILLER_22_951 vddd vssd sg13cmos5l_decap_8
XFILLER_16_1226 vddd vssd sg13cmos5l_decap_4
XFILLER_16_1204 vddd vssd sg13cmos5l_decap_8
XFILLER_11_2561 vddd vssd sg13cmos5l_decap_4
XFILLER_0_321 vddd vssd sg13cmos5l_decap_8
XFILLER_27_1333 vddd vssd sg13cmos5l_decap_8
XFILLER_16_244 vddd vssd sg13cmos5l_decap_8
XFILLER_32_726 vddd vssd sg13cmos5l_decap_8
XFILLER_16_2483 vddd vssd sg13cmos5l_decap_8
XFILLER_32_1094 vddd vssd sg13cmos5l_decap_8
XFILLER_12_1657 vddd vssd sg13cmos5l_decap_8
X_4280_ _4280_/Y _4302_/A _4280_/B vddd vssd sg13cmos5l_nand2_1
XFILLER_23_2432 vddd vssd sg13cmos5l_decap_8
XFILLER_3_2515 vddd vssd sg13cmos5l_decap_8
X_6921_ _6921_/Y _6943_/A _6943_/B_N vddd vssd sg13cmos5l_nor2b_1
X_6852_ _6852_/Y _6958_/A _6957_/B_N vddd vssd sg13cmos5l_nor2b_1
Xfanout29 _4835_/B _4859_/A2 vddd vssd sg13cmos5l_buf_1
X_5803_ _5828_/B _5803_/A vddd vssd sg13cmos5l_inv_1
XFILLER_22_236 vddd vssd sg13cmos5l_decap_8
X_6783_ _6783_/X hold859/X _5030_/A _6784_/B vddd vssd sg13cmos5l_mux2_1
X_3995_ _3995_/Y _3626_/Y _4253_/B1 _3852_/A vddd vssd sg13cmos5l_a21oi_1
XFILLER_30_2403 vddd vssd sg13cmos5l_decap_8
X_5734_ _5734_/Y _5734_/A _5734_/B _5734_/C vddd vssd sg13cmos5l_nand3_1
XFILLER_13_28 vddd vssd sg13cmos5l_decap_8
XFILLER_30_291 vddd vssd sg13cmos5l_decap_8
X_5665_ _5665_/Y _6216_/A1 _5661_/Y _5664_/Y vddd vssd sg13cmos5l_o21ai_1
X_4616_ _4616_/Y _4616_/A _4616_/B vddd vssd sg13cmos5l_nor2_1
X_7335_ _7335_/Q _7337_/CLK _7335_/D _6848_/Y vddd vssd sg13cmos5l_dfrbpq_1
X_5596_ _5596_/Y _5596_/A _5596_/B _5596_/C vddd vssd sg13cmos5l_nand3_1
X_4547_ _4547_/Y _4594_/A1 _4546_/Y _4544_/X vddd vssd sg13cmos5l_o21ai_1
X_7266_ _7266_/Q _7294_/CLK _7266_/D fanout393/X vddd vssd sg13cmos5l_dfrbpq_1
X_4478_ _4478_/Y _4473_/A _4786_/B _4477_/Y vddd vssd sg13cmos5l_o21ai_1
Xhold476 _4951_/A hold972/X vddd vssd sg13cmos5l_dlygate4sd3_1
XFILLER_8_2437 vddd vssd sg13cmos5l_decap_8
Xhold487 sram_addr[7] _5994_/X vddd vssd sg13cmos5l_dlygate4sd3_1
Xhold498 _7002_/D hold498/A vddd vssd sg13cmos5l_dlygate4sd3_1
X_6217_ _6217_/Y _6215_/Y _6216_/Y _3622_/Y vddd vssd sg13cmos5l_o21ai_1
XFILLER_8_1725 vddd vssd sg13cmos5l_decap_8
X_7197_ _7197_/Q _7199_/CLK _7197_/D fanout371/X vddd vssd sg13cmos5l_dfrbpq_1
X_6148_ _6148_/Y _6063_/A _6063_/B _4978_/Y vddd vssd sg13cmos5l_a21oi_1
Xhold1132 _6456_/A1 _3569_/Y vddd vssd sg13cmos5l_dlygate4sd3_1
Xhold1121 _7239_/D _6568_/X vddd vssd sg13cmos5l_dlygate4sd3_1
Xhold1110 _3586_/A _7214_/Q vddd vssd sg13cmos5l_dlygate4sd3_1
Xhold1165 _7049_/D _6706_/X vddd vssd sg13cmos5l_dlygate4sd3_1
Xhold1143 _6671_/A0 _7025_/Q vddd vssd sg13cmos5l_dlygate4sd3_1
Xhold1176 _6598_/A0 _7257_/Q vddd vssd sg13cmos5l_dlygate4sd3_1
Xhold1154 _3559_/A _7158_/Q vddd vssd sg13cmos5l_dlygate4sd3_1
X_6079_ _6080_/C _6144_/A _6079_/B vddd vssd sg13cmos5l_nand2_1
Xhold1187 _7055_/D _6717_/X vddd vssd sg13cmos5l_dlygate4sd3_1
Xhold1198 _6432_/A1 _7165_/Q vddd vssd sg13cmos5l_dlygate4sd3_1
XFILLER_26_553 vddd vssd sg13cmos5l_decap_8
XFILLER_13_1911 vddd vssd sg13cmos5l_decap_8
XFILLER_13_1944 vddd vssd sg13cmos5l_decap_4
XFILLER_6_958 vddd vssd sg13cmos5l_decap_8
XFILLER_29_1428 vddd vssd sg13cmos5l_decap_8
Xtiedowns\[48\] mask_rev_in[4] vddd vssd sg13cmos5l_antennanp
XFILLER_2_2592 vddd vssd sg13cmos5l_decap_8
XFILLER_18_2523 vddd vssd sg13cmos5l_decap_8
XFILLER_2_1891 vddd vssd sg13cmos5l_decap_8
XFILLER_32_567 vddd vssd sg13cmos5l_decap_4
X_3780_ _3780_/Y mask_rev_in[30] _4079_/B vddd vssd sg13cmos5l_nor2_1
X_5450_ _5452_/B _7160_/Q _7161_/Q _5450_/C vddd vssd sg13cmos5l_nor3_1
X_4401_ _4414_/B _4403_/A _4416_/A _4401_/C vddd vssd sg13cmos5l_nand3_1
X_5381_ _5381_/Y _5607_/A _7152_/Q vddd vssd sg13cmos5l_nor2_1
XFILLER_12_1476 vddd vssd sg13cmos5l_decap_8
X_4332_ _4332_/X _4332_/A _4332_/B vddd vssd sg13cmos5l_xor2_1
XFILLER_5_51 vddd vssd sg13cmos5l_decap_8
X_7120_ _7120_/Q _7120_/CLK _7120_/D fanout400/X vddd vssd sg13cmos5l_dfrbpq_1
Xfanout219 _6958_/A _6845_/A vddd vssd sg13cmos5l_buf_1
X_7051_ _7051_/Q _7108_/CLK _7051_/D fanout398/X vddd vssd sg13cmos5l_dfrbpq_1
Xfanout208 _6605_/A _6777_/A1 vddd vssd sg13cmos5l_buf_1
X_4263_ _4296_/B _4323_/B _4308_/A vddd vssd sg13cmos5l_nor2b_1
X_6002_ _6002_/Y _5058_/D _6000_/Y _6001_/Y vddd vssd sg13cmos5l_o21ai_1
X_4194_ _4194_/X dbus_in_left[0] dbus_in_right[0] vddd vssd sg13cmos5l_or2_1
Xoutbuffers\[31\] bandgap_sink2[1] _7060_/Q vddd vssd sg13cmos5l_buf_16
XFILLER_3_1655 vddd vssd sg13cmos5l_decap_8
X_6904_ _6904_/Y _6908_/A _6906_/B_N vddd vssd sg13cmos5l_nor2b_1
XFILLER_19_1619 vddd vssd sg13cmos5l_decap_8
XFILLER_24_49 vddd vssd sg13cmos5l_decap_8
XFILLER_23_556 vddd vssd sg13cmos5l_decap_4
X_6835_ _6835_/Y _6837_/A _6877_/B_N vddd vssd sg13cmos5l_nor2b_1
XFILLER_23_589 vddd vssd sg13cmos5l_decap_4
X_3978_ _6711_/A _3978_/A _6615_/B vddd vssd sg13cmos5l_or2_1
X_6766_ _6766_/X hold833/X _6627_/A _6767_/S vddd vssd sg13cmos5l_mux2_1
XFILLER_11_718 vddd vssd sg13cmos5l_decap_8
X_5717_ _5717_/X _5733_/A _5739_/A vddd vssd sg13cmos5l_and2_1
X_6697_ _6697_/X _6697_/A0 _5027_/A _6698_/S vddd vssd sg13cmos5l_mux2_1
X_5648_ _5648_/Y _3496_/Y _5651_/B _5645_/B vddd vssd sg13cmos5l_a21oi_1
XFILLER_30_1587 vddd vssd sg13cmos5l_decap_8
X_5579_ _5580_/B _3545_/Y _5595_/A _5601_/B _3544_/Y _5583_/B vddd vssd sg13cmos5l_a221oi_1
XFILLER_3_917 vddd vssd sg13cmos5l_decap_8
X_7318_ _7318_/Q _7393_/CLK _7318_/D _6831_/Y vddd vssd sg13cmos5l_dfrbpq_1
XFILLER_6_7 vddd vssd sg13cmos5l_decap_8
X_7249_ _7249_/Q _7252_/CLK _7249_/D fanout389/X vddd vssd sg13cmos5l_dfrbpq_1
XFILLER_8_2245 vddd vssd sg13cmos5l_decap_8
XFILLER_28_1461 vddd vssd sg13cmos5l_decap_8
XFILLER_22_1071 vddd vssd sg13cmos5l_decap_8
XFILLER_2_1176 vddd vssd sg13cmos5l_decap_8
XFILLER_13_2497 vddd vssd sg13cmos5l_decap_8
XFILLER_30_70 vddd vssd sg13cmos5l_decap_8
XFILLER_29_1203 vddd vssd sg13cmos5l_decap_8
XFILLER_0_2507 vddd vssd sg13cmos5l_decap_8
XFILLER_20_1723 vddd vssd sg13cmos5l_decap_8
XFILLER_20_2479 vddd vssd sg13cmos5l_decap_8
XFILLER_18_895 vddd vssd sg13cmos5l_decap_8
X_4950_ _4950_/Y _4965_/B _4949_/Y _4948_/Y vddd vssd sg13cmos5l_o21ai_1
XFILLER_17_383 vddd vssd sg13cmos5l_decap_8
X_3901_ _3901_/Y _3901_/A _6243_/A vddd vssd sg13cmos5l_nand2_1
X_4881_ _4896_/B _4964_/A _7131_/Q vddd vssd sg13cmos5l_nand2_1
XFILLER_32_364 vddd vssd sg13cmos5l_decap_8
X_6620_ _6620_/X _6620_/A0 _6703_/A0 _6621_/S vddd vssd sg13cmos5l_mux2_1
X_3832_ _6691_/A _6361_/A _3937_/A vddd vssd sg13cmos5l_nand2_1
XFILLER_18_1630 vddd vssd sg13cmos5l_decap_8
XFILLER_31_2531 vddd vssd sg13cmos5l_decap_8
X_6551_ _6551_/Y _6632_/A _6555_/S vddd vssd sg13cmos5l_nor2_1
XFILLER_14_2228 vddd vssd sg13cmos5l_decap_8
X_3763_ _3772_/A _7032_/Q _4176_/A2 _6642_/A _7290_/Q vddd vssd sg13cmos5l_a22oi_1
X_5502_ _5503_/B _5533_/A _5511_/A _5501_/X vddd vssd sg13cmos5l_o21ai_1
X_6482_ _7192_/D _6482_/A1 _6487_/B _6481_/Y vddd vssd sg13cmos5l_o21ai_1
X_3694_ _6315_/B _4002_/A _3863_/C vddd vssd sg13cmos5l_or2_1
XFILLER_31_1863 vddd vssd sg13cmos5l_decap_8
X_5433_ _5457_/C _7160_/Q _5441_/B vddd vssd sg13cmos5l_nand2_1
X_5364_ _5364_/Y _5362_/X _5363_/X _5371_/C vddd vssd sg13cmos5l_a21oi_1
XFILLER_29_2471 vddd vssd sg13cmos5l_decap_8
Xoutbuffers\[79\] io_oe[6] wire31/X vddd vssd sg13cmos5l_buf_16
XFILLER_9_2521 vddd vssd sg13cmos5l_decap_8
X_7103_ _7103_/Q _7105_/CLK _7103_/D _6844_/B_N vddd vssd sg13cmos5l_dfrbpq_1
X_4315_ _4316_/B _4344_/A _4343_/A _4315_/C vddd vssd sg13cmos5l_nand3_1
X_5295_ _5295_/Y _7018_/Q _7021_/Q _7020_/Q _5295_/D vddd vssd sg13cmos5l_nor4_1
XFILLER_25_2379 vddd vssd sg13cmos5l_decap_8
X_7034_ _7034_/Q _7066_/CLK _7034_/D fanout346/X vddd vssd sg13cmos5l_dfrbpq_1
X_4246_ _4246_/Y _7080_/Q _3841_/Y _6748_/A vddd vssd sg13cmos5l_a21oi_1
XFILLER_9_2598 vddd vssd sg13cmos5l_decap_8
X_4177_ _4178_/B _7018_/Q _6660_/A vddd vssd sg13cmos5l_nand2_1
XFILLER_25_1656 vddd vssd sg13cmos5l_decap_8
XFILLER_19_49 vddd vssd sg13cmos5l_decap_8
XFILLER_3_2142 vddd vssd sg13cmos5l_decap_4
XFILLER_27_147 vddd vssd sg13cmos5l_decap_8
XFILLER_23_331 vddd vssd sg13cmos5l_decap_8
X_6818_ _6818_/Y _6838_/A _6867_/B_N vddd vssd sg13cmos5l_nor2b_1
XFILLER_32_2328 vddd vssd sg13cmos5l_decap_8
XFILLER_17_1151 vddd vssd sg13cmos5l_decap_8
X_6749_ _6749_/Y _6749_/A _6753_/B vddd vssd sg13cmos5l_nand2_1
XFILLER_8_2053 vddd vssd sg13cmos5l_decap_8
XFILLER_8_1363 vddd vssd sg13cmos5l_decap_4
XFILLER_24_1166 vddd vssd sg13cmos5l_decap_8
XFILLER_4_1238 vddd vssd sg13cmos5l_decap_8
XFILLER_15_832 vddd vssd sg13cmos5l_decap_4
XFILLER_29_1044 vddd vssd sg13cmos5l_decap_8
XFILLER_29_1077 vddd vssd sg13cmos5l_decap_8
X_4100_ _4100_/Y _5240_/B _6589_/A _6583_/A vddd vssd sg13cmos5l_o21ai_1
X_5080_ _5089_/C _5136_/B _5254_/B vddd vssd sg13cmos5l_and2_1
XFILLER_2_30 vddd vssd sg13cmos5l_decap_8
X_4031_ _4032_/B _7214_/Q _6517_/A _6510_/A vddd vssd sg13cmos5l_a21oi_1
XFILLER_20_1542 vddd vssd sg13cmos5l_decap_8
X_5982_ _5982_/Y _5977_/Y _5978_/X _5981_/Y vddd vssd sg13cmos5l_o21ai_1
XFILLER_0_1625 vddd vssd sg13cmos5l_decap_8
XFILLER_4_1783 vddd vssd sg13cmos5l_decap_8
X_4933_ _4941_/A _4933_/A _4946_/A vddd vssd sg13cmos5l_and2_1
XFILLER_17_180 vddd vssd sg13cmos5l_decap_4
XFILLER_32_161 vddd vssd sg13cmos5l_decap_8
X_4864_ _4864_/Y _4866_/A _4866_/B vddd vssd sg13cmos5l_nand2b_1
XANTENNA_13 _7378_/Q vddd vssd sg13cmos5l_antennanp
XANTENNA_46 _7045_/Q vddd vssd sg13cmos5l_antennanp
X_6603_ _6603_/Y _6603_/A _6608_/S vddd vssd sg13cmos5l_nor2_1
X_3815_ _6660_/A _4002_/B _4002_/C _4071_/C vddd vssd sg13cmos5l_nor3_1
XANTENNA_24 wire25/X vddd vssd sg13cmos5l_antennanp
XANTENNA_35 _5030_/A vddd vssd sg13cmos5l_antennanp
X_4795_ _4799_/A _4806_/A1 _4778_/Y _4782_/A vddd vssd sg13cmos5l_o21ai_1
XFILLER_21_28 vddd vssd sg13cmos5l_decap_8
X_6534_ _6534_/Y _6564_/A _6539_/S vddd vssd sg13cmos5l_nor2_1
X_3746_ _4079_/B _3883_/B _3781_/B vddd vssd sg13cmos5l_nand2_1
X_6465_ _6465_/Y _6465_/A _6465_/B vddd vssd sg13cmos5l_nor2_1
X_3677_ _3689_/A _3677_/A0 _4319_/A _3678_/S vddd vssd sg13cmos5l_mux2_1
X_5416_ _5416_/Y _5527_/A _5416_/B _5416_/C vddd vssd sg13cmos5l_nand3b_1
X_6396_ _7146_/D _6396_/A1 _6397_/B _6395_/Y vddd vssd sg13cmos5l_a21oi_1
X_5347_ _5347_/Y _5676_/A _5342_/A _5346_/Y vddd vssd sg13cmos5l_o21ai_1
XFILLER_25_2132 vddd vssd sg13cmos5l_decap_8
X_5278_ _5280_/C _5278_/A _5278_/B _5278_/C _5278_/D vddd vssd sg13cmos5l_nor4_1
X_4229_ _4229_/Y _4226_/Y _4227_/Y _4228_/Y vddd vssd sg13cmos5l_o21ai_1
XFILLER_21_2007 vddd vssd sg13cmos5l_decap_4
X_7017_ sdo_ena _7017_/CLK _7017_/D _3632_/Y vddd vssd sg13cmos5l_dfrbpq_1
XFILLER_29_946 vddd vssd sg13cmos5l_decap_8
XFILLER_25_1497 vddd vssd sg13cmos5l_decap_8
XFILLER_5_1569 vddd vssd sg13cmos5l_decap_4
XFILLER_16_629 vddd vssd sg13cmos5l_decap_8
XFILLER_3_1271 vddd vssd sg13cmos5l_decap_8
XFILLER_23_161 vddd vssd sg13cmos5l_decap_8
XFILLER_12_835 vddd vssd sg13cmos5l_decap_8
XFILLER_8_817 vddd vssd sg13cmos5l_decap_8
XFILLER_10_2489 vddd vssd sg13cmos5l_decap_8
Xtiedowns\[30\] dbus_in_left[10] vddd vssd sg13cmos5l_antennanp
Xfanout391 fanout391/X fanout394/X vddd vssd sg13cmos5l_buf_1
Xfanout380 _6829_/B_N _6828_/B_N vddd vssd sg13cmos5l_buf_1
XFILLER_21_2596 vddd vssd sg13cmos5l_decap_8
XFILLER_21_1851 vddd vssd sg13cmos5l_decap_8
XFILLER_15_651 vddd vssd sg13cmos5l_decap_8
XFILLER_19_2492 vddd vssd sg13cmos5l_decap_8
XFILLER_14_172 vddd vssd sg13cmos5l_decap_8
X_4580_ _4580_/Y _4594_/A1 _4571_/Y _4579_/Y vddd vssd sg13cmos5l_o21ai_1
X_3600_ _3600_/Y _3600_/A vddd vssd sg13cmos5l_inv_1
X_3531_ _4296_/A _4264_/A vddd vssd sg13cmos5l_inv_1
Xhold828 _4319_/A _7357_/Q vddd vssd sg13cmos5l_dlygate4sd3_1
Xhold817 _7101_/D _6306_/Y vddd vssd sg13cmos5l_dlygate4sd3_1
Xhold806 _7102_/D _6308_/Y vddd vssd sg13cmos5l_dlygate4sd3_1
X_3462_ _3462_/Y _4509_/A vddd vssd sg13cmos5l_inv_1
X_6250_ _6250_/Y _3791_/B _5279_/C _5274_/Y vddd vssd sg13cmos5l_a21oi_1
Xhold839 hold839/X _7129_/Q vddd vssd sg13cmos5l_dlygate4sd3_1
X_5201_ _5204_/C _5263_/B _5221_/B vddd vssd sg13cmos5l_nor2_1
X_6181_ _6181_/Y _3819_/Y _5239_/Y _5242_/B vddd vssd sg13cmos5l_a21oi_1
XFILLER_26_2441 vddd vssd sg13cmos5l_decap_8
X_5132_ _5139_/B _5132_/A vddd vssd sg13cmos5l_inv_1
Xclkbuf_1_0__f_clk clkload0/A clkbuf_0_clk/X vddd vssd sg13cmos5l_buf_8
Xhold1506 hold512/A _6978_/Q vddd vssd sg13cmos5l_dlygate4sd3_1
XFILLER_28_0 vddd vssd sg13cmos5l_decap_8
XFILLER_26_1762 vddd vssd sg13cmos5l_decap_8
XFILLER_22_2305 vddd vssd sg13cmos5l_decap_4
Xhold1517 hold1517/X _7306_/Q vddd vssd sg13cmos5l_dlygate4sd3_1
XFILLER_6_2568 vddd vssd sg13cmos5l_decap_8
X_5063_ _5063_/Y _6012_/B _5063_/B _5063_/C vddd vssd sg13cmos5l_nand3_1
XFILLER_22_1637 vddd vssd sg13cmos5l_decap_4
X_4014_ _4014_/Y _7250_/Q _6583_/A _6576_/A vddd vssd sg13cmos5l_o21ai_1
XFILLER_26_949 vddd vssd sg13cmos5l_decap_8
XFILLER_16_28 vddd vssd sg13cmos5l_decap_8
X_5965_ _5965_/Y _7316_/Q _5972_/B vddd vssd sg13cmos5l_nor2b_1
X_4916_ _4916_/Y _4920_/A sram_odata[2] _4918_/C vddd vssd sg13cmos5l_nand3_1
X_5896_ _5907_/A _5637_/A _5912_/C _3591_/Y vddd vssd sg13cmos5l_o21ai_1
XFILLER_21_643 vddd vssd sg13cmos5l_decap_4
X_4847_ _4847_/Y _4845_/A _4839_/B _4846_/Y vddd vssd sg13cmos5l_a21oi_1
XFILLER_32_49 vddd vssd sg13cmos5l_decap_8
X_4778_ _4778_/Y _4778_/A _4779_/B vddd vssd sg13cmos5l_nor2b_1
X_3729_ _6759_/B _3929_/B _4002_/D vddd vssd sg13cmos5l_or2_1
XFILLER_14_1198 vddd vssd sg13cmos5l_decap_8
X_6517_ _6524_/S _6517_/A _6660_/B vddd vssd sg13cmos5l_nand2_1
X_6448_ _6448_/X _6455_/A _6448_/A1 _6449_/S vddd vssd sg13cmos5l_mux2_1
XFILLER_27_2205 vddd vssd sg13cmos5l_decap_4
X_6379_ _6379_/Y _6379_/A _6381_/B vddd vssd sg13cmos5l_nor2_1
XFILLER_27_1537 vddd vssd sg13cmos5l_decap_8
XFILLER_5_2078 vddd vssd sg13cmos5l_decap_8
XFILLER_9_1480 vddd vssd sg13cmos5l_decap_8
XFILLER_32_908 vddd vssd sg13cmos5l_decap_8
XFILLER_19_1010 vddd vssd sg13cmos5l_decap_8
XFILLER_31_418 vddd vssd sg13cmos5l_decap_4
XFILLER_24_481 vddd vssd sg13cmos5l_decap_8
XFILLER_24_492 vddd vssd sg13cmos5l_decap_8
XFILLER_12_632 vddd vssd sg13cmos5l_decap_8
XFILLER_32_1221 vddd vssd sg13cmos5l_decap_8
XFILLER_19_1098 vddd vssd sg13cmos5l_decap_8
XFILLER_10_2220 vddd vssd sg13cmos5l_decap_8
XFILLER_32_1298 vddd vssd sg13cmos5l_decap_8
Xtiedowns\[78\] clkload1/A vddd vssd sg13cmos5l_antennanp
XFILLER_10_1574 vddd vssd sg13cmos5l_decap_8
XFILLER_23_1902 vddd vssd sg13cmos5l_decap_8
XFILLER_21_7 vddd vssd sg13cmos5l_decap_8
Xclkbuf_leaf_17_SCK_regs _7293_/CLK clkload7/A vddd vssd sg13cmos5l_buf_8
X_5750_ _5765_/C _7204_/Q _7205_/Q vddd vssd sg13cmos5l_nand2_1
X_5681_ _5682_/C _5571_/A _5683_/B vddd vssd sg13cmos5l_nand2b_1
X_4701_ _4701_/Y _4696_/A _4696_/B _4700_/Y vddd vssd sg13cmos5l_o21ai_1
X_4632_ _4633_/B _4680_/A _4632_/B vddd vssd sg13cmos5l_nor2_1
XFILLER_15_1430 vddd vssd sg13cmos5l_decap_8
XFILLER_8_84 vddd vssd sg13cmos5l_decap_8
X_4563_ _4566_/B _4807_/A _4563_/B vddd vssd sg13cmos5l_nor2_1
X_7351_ _7351_/Q _7351_/CLK _7351_/D _6864_/Y vddd vssd sg13cmos5l_dfrbpq_1
XFILLER_15_1485 vddd vssd sg13cmos5l_decap_8
Xhold603 _6590_/A _7252_/Q vddd vssd sg13cmos5l_dlygate4sd3_1
X_7282_ _7282_/Q _7293_/CLK _7282_/D fanout385/X vddd vssd sg13cmos5l_dfrbpq_1
X_4494_ _4494_/Y _4530_/A _4614_/B vddd vssd sg13cmos5l_nor2_1
X_3514_ _3514_/Y _3514_/A vddd vssd sg13cmos5l_inv_1
Xhold614 _4421_/A _7343_/Q vddd vssd sg13cmos5l_dlygate4sd3_1
Xhold636 _7323_/D _4844_/Y vddd vssd sg13cmos5l_dlygate4sd3_1
Xhold625 _7325_/D _4836_/Y vddd vssd sg13cmos5l_dlygate4sd3_1
X_6302_ _6302_/Y _6302_/A _7382_/Q vddd vssd sg13cmos5l_nor2b_1
XFILLER_28_2525 vddd vssd sg13cmos5l_decap_8
XFILLER_28_1802 vddd vssd sg13cmos5l_decap_8
X_6233_ _6235_/A _6233_/A _6233_/B _7229_/Q _6234_/A vddd vssd sg13cmos5l_nand4_1
Xhold669 hold669/X _6335_/Y vddd vssd sg13cmos5l_dlygate4sd3_1
Xhold658 _7324_/D _4840_/Y vddd vssd sg13cmos5l_dlygate4sd3_1
Xhold647 _7121_/D _6348_/Y vddd vssd sg13cmos5l_dlygate4sd3_1
Xoutbuffers\[61\] voltgen_ena[1] _7045_/Q vddd vssd sg13cmos5l_buf_16
X_6164_ _6164_/Y _6120_/A _5222_/A _6162_/Y _6163_/Y _5222_/C vddd vssd sg13cmos5l_a221oi_1
XFILLER_26_2282 vddd vssd sg13cmos5l_decap_8
Xhold1314 _6664_/A1 _7020_/Q vddd vssd sg13cmos5l_dlygate4sd3_1
Xhold1325 _7043_/D _6698_/X vddd vssd sg13cmos5l_dlygate4sd3_1
X_6095_ _6095_/Y _5168_/A _6093_/Y _6094_/Y vddd vssd sg13cmos5l_o21ai_1
Xhold1303 _7288_/D _6648_/X vddd vssd sg13cmos5l_dlygate4sd3_1
X_5115_ _5119_/C _5115_/A _5265_/B vddd vssd sg13cmos5l_nand2_1
Xhold1336 _6682_/A0 _7033_/Q vddd vssd sg13cmos5l_dlygate4sd3_1
Xhold1347 _7036_/D _6688_/X vddd vssd sg13cmos5l_dlygate4sd3_1
Xhold1358 _3761_/A1 SDO vddd vssd sg13cmos5l_dlygate4sd3_1
XFILLER_6_1664 vddd vssd sg13cmos5l_decap_4
X_5046_ _5046_/Y _7248_/Q _7249_/Q _7250_/Q _7251_/Q vddd vssd sg13cmos5l_nor4_1
XFILLER_26_713 vddd vssd sg13cmos5l_decap_4
XFILLER_27_49 vddd vssd sg13cmos5l_decap_8
XFILLER_22_1467 vddd vssd sg13cmos5l_decap_8
XFILLER_22_1456 vddd vssd sg13cmos5l_decap_8
Xhold1369 _6513_/A1 _5786_/B vddd vssd sg13cmos5l_dlygate4sd3_1
XFILLER_25_212 vddd vssd sg13cmos5l_decap_8
XFILLER_22_1489 vddd vssd sg13cmos5l_decap_8
X_6997_ _6997_/Q _7013_/CLK _6997_/D _6944_/Y vddd vssd sg13cmos5l_dfrbpq_1
X_5948_ _6970_/D _5954_/A _5948_/B vddd vssd sg13cmos5l_nor2_1
XFILLER_0_1274 vddd vssd sg13cmos5l_decap_8
XFILLER_22_985 vddd vssd sg13cmos5l_decap_8
X_5879_ _5879_/Y _5879_/A _5879_/B _5879_/C vddd vssd sg13cmos5l_nor3_1
XFILLER_11_2540 vddd vssd sg13cmos5l_decap_8
XFILLER_11_2584 vddd vssd sg13cmos5l_decap_8
XFILLER_11_1894 vddd vssd sg13cmos5l_decap_8
XFILLER_27_1301 vddd vssd sg13cmos5l_decap_4
XFILLER_0_300 vddd vssd sg13cmos5l_decap_8
XFILLER_17_702 vddd vssd sg13cmos5l_decap_8
XFILLER_5_1174 vddd vssd sg13cmos5l_decap_8
XFILLER_32_705 vddd vssd sg13cmos5l_decap_8
XFILLER_17_779 vddd vssd sg13cmos5l_decap_8
XFILLER_17_82 vddd vssd sg13cmos5l_decap_8
XFILLER_31_226 vddd vssd sg13cmos5l_decap_8
XFILLER_9_901 vddd vssd sg13cmos5l_decap_8
Xclkbuf_4_9__f_clk_regs _7012_/CLK clkbuf_3_4_0_clk_regs/X vddd vssd sg13cmos5l_buf_8
XFILLER_16_2462 vddd vssd sg13cmos5l_decap_8
XFILLER_12_462 vddd vssd sg13cmos5l_decap_8
XFILLER_13_996 vddd vssd sg13cmos5l_decap_4
XFILLER_16_1750 vddd vssd sg13cmos5l_decap_8
XFILLER_32_1073 vddd vssd sg13cmos5l_decap_8
XFILLER_10_2072 vddd vssd sg13cmos5l_decap_8
XFILLER_3_171 vddd vssd sg13cmos5l_decap_8
XFILLER_4_694 vddd vssd sg13cmos5l_decap_8
XFILLER_23_2411 vddd vssd sg13cmos5l_decap_8
XFILLER_23_2488 vddd vssd sg13cmos5l_decap_8
X_6920_ _6920_/Y _6961_/A _6961_/B_N vddd vssd sg13cmos5l_nor2b_1
X_6851_ _6851_/Y _6956_/A _6957_/B_N vddd vssd sg13cmos5l_nor2b_1
Xfanout19 _4681_/A _4633_/A vddd vssd sg13cmos5l_buf_1
X_5802_ _5803_/A _7214_/Q _7215_/Q vddd vssd sg13cmos5l_nor2_1
XFILLER_17_2259 vddd vssd sg13cmos5l_decap_8
XFILLER_17_1525 vddd vssd sg13cmos5l_decap_4
X_3994_ _3994_/Y _3992_/Y _3994_/B vddd vssd sg13cmos5l_nand2b_1
X_6782_ _6782_/X hold749/X _5029_/A _6784_/B vddd vssd sg13cmos5l_mux2_1
Xoutbuffers\[5\] analog_bus_ena[3] _7033_/Q vddd vssd sg13cmos5l_buf_16
X_5733_ _5734_/C _5733_/A _5733_/B vddd vssd sg13cmos5l_nand2_1
X_5664_ _5664_/Y _3545_/Y _5662_/Y _5679_/B _5639_/A vddd vssd sg13cmos5l_a22oi_1
XFILLER_30_2459 vddd vssd sg13cmos5l_decap_8
X_5595_ _5596_/C _5595_/A _5595_/B vddd vssd sg13cmos5l_nand2_1
X_4615_ _4616_/B _4614_/B _3606_/Y _4614_/Y vddd vssd sg13cmos5l_a21oi_1
XFILLER_30_1769 vddd vssd sg13cmos5l_decap_8
X_7334_ _7334_/Q _7337_/CLK _7334_/D _6847_/Y vddd vssd sg13cmos5l_dfrbpq_1
X_4546_ _4546_/Y _4614_/B _3609_/Y _4545_/Y vddd vssd sg13cmos5l_a21oi_1
XFILLER_28_1610 vddd vssd sg13cmos5l_decap_8
X_7265_ _7265_/Q _7294_/CLK _7265_/D fanout393/X vddd vssd sg13cmos5l_dfrbpq_1
Xhold477 sram_addr[5] _5992_/X vddd vssd sg13cmos5l_dlygate4sd3_1
X_4477_ _4477_/Y _4786_/B _4477_/B vddd vssd sg13cmos5l_nand2_1
Xmax_cap174 _6784_/A hold1519/X vddd vssd sg13cmos5l_buf_8
XFILLER_28_2399 vddd vssd sg13cmos5l_decap_8
Xhold499 _7009_/D hold499/A vddd vssd sg13cmos5l_dlygate4sd3_1
X_6216_ _6216_/Y _6216_/A1 _6237_/C _6226_/B vddd vssd sg13cmos5l_o21ai_1
X_7196_ _7196_/Q _7199_/CLK _7196_/D fanout371/X vddd vssd sg13cmos5l_dfrbpq_1
Xhold488 _4962_/A hold488/A vddd vssd sg13cmos5l_dlygate4sd3_1
X_6147_ wire16/A _6129_/Y _6146_/Y _6128_/Y vddd vssd sg13cmos5l_o21ai_1
Xhold1100 _7149_/D _6402_/X vddd vssd sg13cmos5l_dlygate4sd3_1
Xhold1122 _6707_/A1 _7050_/Q vddd vssd sg13cmos5l_dlygate4sd3_1
Xhold1133 _7178_/D _6456_/Y vddd vssd sg13cmos5l_dlygate4sd3_1
Xhold1111 _6523_/A1 _3586_/Y vddd vssd sg13cmos5l_dlygate4sd3_1
Xhold1144 _7025_/D _6671_/X vddd vssd sg13cmos5l_dlygate4sd3_1
Xhold1166 _3617_/A _7233_/Q vddd vssd sg13cmos5l_dlygate4sd3_1
Xhold1155 _6417_/A1 _5416_/C vddd vssd sg13cmos5l_dlygate4sd3_1
X_6078_ _6080_/B _6079_/B _6078_/B vddd vssd sg13cmos5l_or2_1
X_5029_ sram_idata[5] _5029_/A _5032_/B vddd vssd sg13cmos5l_and2_1
Xhold1188 _4526_/B _7339_/Q vddd vssd sg13cmos5l_dlygate4sd3_1
Xhold1199 _7165_/D _6432_/X vddd vssd sg13cmos5l_dlygate4sd3_1
Xhold1177 _7257_/D _6598_/X vddd vssd sg13cmos5l_dlygate4sd3_1
XFILLER_0_1071 vddd vssd sg13cmos5l_decap_8
XFILLER_13_2602 vddd vssd sg13cmos5l_decap_4
XFILLER_22_793 vddd vssd sg13cmos5l_decap_4
XFILLER_16_1079 vddd vssd sg13cmos5l_decap_4
XFILLER_6_937 vddd vssd sg13cmos5l_decap_8
XFILLER_1_653 vddd vssd sg13cmos5l_decap_4
XFILLER_2_2571 vddd vssd sg13cmos5l_decap_8
XFILLER_18_2502 vddd vssd sg13cmos5l_decap_8
XFILLER_32_535 vddd vssd sg13cmos5l_decap_8
XFILLER_18_2579 vddd vssd sg13cmos5l_decap_8
XFILLER_9_753 vddd vssd sg13cmos5l_decap_8
XFILLER_12_270 vddd vssd sg13cmos5l_decap_8
X_4400_ _4419_/A _4403_/A _4401_/C vddd vssd sg13cmos5l_nand2_1
XFILLER_12_1444 vddd vssd sg13cmos5l_decap_8
XFILLER_5_30 vddd vssd sg13cmos5l_decap_8
X_5380_ _5387_/A _5533_/A _5401_/A _5379_/Y vddd vssd sg13cmos5l_a21oi_1
X_4331_ _4331_/Y _4313_/X _4319_/B _4319_/A vddd vssd sg13cmos5l_o21ai_1
X_7050_ _7050_/Q _7279_/CLK _7050_/D fanout388/X vddd vssd sg13cmos5l_dfrbpq_1
Xfanout209 _6788_/A _6777_/A1 vddd vssd sg13cmos5l_buf_1
X_4262_ _7382_/D _4296_/A _4289_/B _4262_/C vddd vssd sg13cmos5l_nor3_1
X_6001_ _6001_/Y _6151_/A _5058_/D _5058_/B vddd vssd sg13cmos5l_a21oi_1
XFILLER_25_1827 vddd vssd sg13cmos5l_decap_8
X_4193_ _6122_/A dbus_in_left[0] dbus_in_right[0] vddd vssd sg13cmos5l_nor2_1
Xclkbuf_leaf_32_SCK_regs _7287_/CLK clkload5/A vddd vssd sg13cmos5l_buf_8
XFILLER_23_2263 vddd vssd sg13cmos5l_decap_4
XFILLER_10_0 vddd vssd sg13cmos5l_decap_8
Xoutbuffers\[24\] voltgen_sink2[0] _7064_/Q vddd vssd sg13cmos5l_buf_16
X_6903_ _6903_/Y _6906_/A _6906_/B_N vddd vssd sg13cmos5l_nor2b_1
XFILLER_24_28 vddd vssd sg13cmos5l_decap_8
XFILLER_23_535 vddd vssd sg13cmos5l_decap_8
XFILLER_17_2034 vddd vssd sg13cmos5l_decap_8
X_6834_ _6834_/Y _6837_/A _6834_/B_N vddd vssd sg13cmos5l_nor2b_1
X_3977_ _3983_/B _3978_/A _6615_/B vddd vssd sg13cmos5l_nor2_1
XFILLER_17_2056 vddd vssd sg13cmos5l_decap_8
X_6765_ _6765_/Y _6790_/A _6767_/S hold782/X vddd vssd sg13cmos5l_a21oi_1
XFILLER_10_218 vddd vssd sg13cmos5l_decap_8
X_5716_ _5739_/A _5736_/A _7203_/Q vddd vssd sg13cmos5l_nor2_1
X_6696_ _6696_/Y _6696_/A1 _6698_/S _6695_/Y vddd vssd sg13cmos5l_o21ai_1
X_5647_ _5647_/Y _7190_/Q _5647_/B _5647_/C vddd vssd sg13cmos5l_nor3_1
X_5578_ _5601_/B _5581_/A _7181_/Q vddd vssd sg13cmos5l_nor2_1
X_4529_ _4532_/B _4530_/A _4520_/Y _4528_/Y vddd vssd sg13cmos5l_a21oi_1
X_7317_ _7317_/Q _7351_/CLK _7317_/D _6830_/Y vddd vssd sg13cmos5l_dfrbpq_1
X_7248_ _7248_/Q _7252_/CLK _7248_/D fanout389/X vddd vssd sg13cmos5l_dfrbpq_1
XFILLER_28_1495 vddd vssd sg13cmos5l_decap_8
X_7179_ _7179_/Q _7179_/CLK _7179_/D fanout368/X vddd vssd sg13cmos5l_dfrbpq_1
XFILLER_6_1280 vddd vssd sg13cmos5l_decap_8
XFILLER_26_373 vddd vssd sg13cmos5l_decap_8
XFILLER_14_568 vddd vssd sg13cmos5l_decap_4
XFILLER_13_2476 vddd vssd sg13cmos5l_decap_8
XFILLER_10_774 vddd vssd sg13cmos5l_decap_8
Xtiedowns\[60\] mask_rev_in[16] vddd vssd sg13cmos5l_antennanp
XFILLER_24_2583 vddd vssd sg13cmos5l_decap_8
XFILLER_20_2458 vddd vssd sg13cmos5l_decap_8
XFILLER_4_1954 vddd vssd sg13cmos5l_decap_8
XFILLER_20_1757 vddd vssd sg13cmos5l_decap_8
X_3900_ _6130_/A dbus_in_left[11] dbus_in_right[11] vddd vssd sg13cmos5l_or2_1
Xoutbuffers\[114\] dbus_out[17] _5801_/X vddd vssd sg13cmos5l_buf_16
X_4880_ _4899_/A _4968_/A _7130_/Q _4879_/X vddd vssd sg13cmos5l_o21ai_1
XFILLER_32_343 vddd vssd sg13cmos5l_decap_8
X_3831_ _3831_/X _6361_/A _3937_/A vddd vssd sg13cmos5l_and2_1
XFILLER_31_2510 vddd vssd sg13cmos5l_decap_8
X_6550_ _6550_/Y _6675_/A1 _6555_/S hold573/X vddd vssd sg13cmos5l_o21ai_1
X_3762_ _3762_/Y _3762_/A _4173_/B vddd vssd sg13cmos5l_nand2_1
X_5501_ _5501_/X _5532_/A _7171_/Q vddd vssd sg13cmos5l_or2_1
XFILLER_31_2587 vddd vssd sg13cmos5l_decap_8
X_6481_ _6481_/Y _6481_/A _6487_/B vddd vssd sg13cmos5l_nand2_1
XFILLER_9_594 vddd vssd sg13cmos5l_decap_8
X_3693_ _3958_/A _4002_/A _3863_/C vddd vssd sg13cmos5l_nor2_1
X_5432_ _5435_/A _5607_/A _7160_/Q _7161_/Q vddd vssd sg13cmos5l_nor3_1
XFILLER_9_2500 vddd vssd sg13cmos5l_decap_8
X_5363_ _5363_/X _5533_/A _5363_/B vddd vssd sg13cmos5l_or2_1
XFILLER_29_2450 vddd vssd sg13cmos5l_decap_8
X_4314_ _4344_/B _4336_/A _4323_/B vddd vssd sg13cmos5l_nand2_1
X_7102_ _7102_/Q _7120_/CLK _7102_/D _6844_/B_N vddd vssd sg13cmos5l_dfrbpq_1
X_5294_ _5295_/D _7022_/Q _7019_/Q vddd vssd sg13cmos5l_or2_1
XFILLER_9_2577 vddd vssd sg13cmos5l_decap_8
X_7033_ _7033_/Q _7188_/CLK _7033_/D fanout376/X vddd vssd sg13cmos5l_dfrbpq_1
XFILLER_25_2358 vddd vssd sg13cmos5l_decap_8
XFILLER_25_1635 vddd vssd sg13cmos5l_decap_8
XFILLER_19_28 vddd vssd sg13cmos5l_decap_8
X_4245_ _4245_/X _4242_/Y _4243_/Y _4244_/Y vddd vssd sg13cmos5l_a21o_1
X_4176_ _4178_/A _7023_/Q _4176_/A2 _6673_/A _7027_/Q vddd vssd sg13cmos5l_a22oi_1
XFILLER_9_1898 vddd vssd sg13cmos5l_decap_8
XFILLER_27_126 vddd vssd sg13cmos5l_decap_8
XFILLER_3_1475 vddd vssd sg13cmos5l_decap_4
XFILLER_24_866 vddd vssd sg13cmos5l_decap_4
X_6817_ _6817_/Y _6838_/A _6834_/B_N vddd vssd sg13cmos5l_nor2b_1
XFILLER_11_549 vddd vssd sg13cmos5l_decap_8
XFILLER_17_1185 vddd vssd sg13cmos5l_decap_8
X_6748_ _6753_/B _6748_/A _6748_/B vddd vssd sg13cmos5l_nand2_1
X_6679_ _6679_/X _6679_/A0 _6739_/A1 _6681_/S vddd vssd sg13cmos5l_mux2_1
XFILLER_8_2021 vddd vssd sg13cmos5l_decap_8
XFILLER_8_1342 vddd vssd sg13cmos5l_decap_8
XFILLER_4_1206 vddd vssd sg13cmos5l_decap_8
XFILLER_27_671 vddd vssd sg13cmos5l_decap_4
XFILLER_25_93 vddd vssd sg13cmos5l_decap_8
XFILLER_15_2549 vddd vssd sg13cmos5l_decap_8
XFILLER_15_1837 vddd vssd sg13cmos5l_decap_8
XFILLER_13_2284 vddd vssd sg13cmos5l_decap_4
XFILLER_13_1583 vddd vssd sg13cmos5l_decap_8
XFILLER_29_1023 vddd vssd sg13cmos5l_decap_8
X_4030_ _4030_/Y _3588_/Y _6525_/A _4028_/Y _4029_/Y _6517_/A vddd vssd sg13cmos5l_a221oi_1
XFILLER_24_2380 vddd vssd sg13cmos5l_decap_8
XFILLER_2_86 vddd vssd sg13cmos5l_decap_8
XFILLER_4_2474 vddd vssd sg13cmos5l_decap_8
X_5981_ _5981_/Y _6233_/A _5979_/Y _5980_/Y vddd vssd sg13cmos5l_a21oi_1
XFILLER_20_2288 vddd vssd sg13cmos5l_decap_8
X_4932_ _4946_/A _4932_/A _4949_/A _4952_/A vddd vssd sg13cmos5l_and3_1
XFILLER_32_140 vddd vssd sg13cmos5l_decap_8
X_4863_ _4866_/B _4863_/A _7139_/Q vddd vssd sg13cmos5l_or2_1
X_6602_ _6608_/S _6602_/A _6615_/C vddd vssd sg13cmos5l_nor2_1
XANTENNA_14 _7297_/Q vddd vssd sg13cmos5l_antennanp
X_3814_ _3822_/A _7288_/Q _6642_/A vddd vssd sg13cmos5l_nand2_1
XANTENNA_36 _5030_/A vddd vssd sg13cmos5l_antennanp
XANTENNA_25 wire61/X vddd vssd sg13cmos5l_antennanp
XANTENNA_47 sram_odata[3] vddd vssd sg13cmos5l_antennanp
X_4794_ _4794_/Y _4430_/B _3598_/Y _4794_/B1 _4793_/X vddd vssd sg13cmos5l_a22oi_1
XFILLER_14_1358 vddd vssd sg13cmos5l_decap_4
X_6533_ _6539_/S _6533_/A _6667_/B vddd vssd sg13cmos5l_nand2_1
X_3745_ _3745_/Y _3911_/A _4251_/B vddd vssd sg13cmos5l_nor2_1
XFILLER_31_2384 vddd vssd sg13cmos5l_decap_8
X_6464_ _6464_/X _6455_/A hold741/X _6465_/B vddd vssd sg13cmos5l_mux2_1
Xoutbuffers\[91\] io_out[6] wire16/X vddd vssd sg13cmos5l_buf_16
X_3676_ _4002_/B _3717_/A _3919_/A vddd vssd sg13cmos5l_nand2b_1
X_5415_ _5415_/Y _7330_/Q _5408_/B _5414_/X vddd vssd sg13cmos5l_o21ai_1
X_6395_ _6395_/Y _6715_/A _6397_/B vddd vssd sg13cmos5l_nor2_1
X_5346_ _5346_/Y _5428_/A _5339_/D _5332_/Y _5398_/A vddd vssd sg13cmos5l_a22oi_1
X_5277_ _5278_/D _5277_/A _6243_/C _6254_/S vddd vssd sg13cmos5l_nand3_1
X_7016_ _7016_/Q _7016_/CLK _7016_/D _6963_/Y vddd vssd sg13cmos5l_dfrbpq_1
X_4228_ _4228_/Y _7067_/Q _3817_/Y _6725_/A vddd vssd sg13cmos5l_a21oi_1
XFILLER_21_2019 vddd vssd sg13cmos5l_decap_8
XFILLER_29_925 vddd vssd sg13cmos5l_decap_8
XFILLER_5_1548 vddd vssd sg13cmos5l_decap_4
X_4159_ _4159_/X _7107_/Q _3695_/Y _4158_/Y vddd vssd sg13cmos5l_a21o_1
XFILLER_16_608 vddd vssd sg13cmos5l_decap_8
XFILLER_23_140 vddd vssd sg13cmos5l_decap_8
XFILLER_32_2104 vddd vssd sg13cmos5l_decap_8
XFILLER_24_674 vddd vssd sg13cmos5l_decap_8
XFILLER_12_814 vddd vssd sg13cmos5l_decap_8
XFILLER_20_891 vddd vssd sg13cmos5l_decap_8
XFILLER_10_1745 vddd vssd sg13cmos5l_decap_4
XFILLER_10_2468 vddd vssd sg13cmos5l_decap_8
XFILLER_10_1767 vddd vssd sg13cmos5l_decap_8
XFILLER_11_84 vddd vssd sg13cmos5l_decap_8
Xtiedowns\[23\] dbus_in_left[3] vddd vssd sg13cmos5l_antennanp
Xfanout370 fanout370/X fanout379/X vddd vssd sg13cmos5l_buf_1
Xfanout392 fanout392/X fanout394/X vddd vssd sg13cmos5l_buf_1
Xfanout381 _6828_/B_N fanout384/X vddd vssd sg13cmos5l_buf_1
XFILLER_4_1003 vddd vssd sg13cmos5l_decap_8
XFILLER_21_2575 vddd vssd sg13cmos5l_decap_8
XFILLER_19_435 vddd vssd sg13cmos5l_decap_4
XFILLER_19_2471 vddd vssd sg13cmos5l_decap_8
X_3530_ _3530_/Y _3530_/A vddd vssd sg13cmos5l_inv_1
Xhold818 _3607_/A _7108_/Q vddd vssd sg13cmos5l_dlygate4sd3_1
Xhold807 hold807/X _7128_/Q vddd vssd sg13cmos5l_dlygate4sd3_1
X_3461_ _3461_/Y _3461_/A vddd vssd sg13cmos5l_inv_1
Xhold829 _4332_/B _4331_/Y vddd vssd sg13cmos5l_dlygate4sd3_1
XFILLER_26_2420 vddd vssd sg13cmos5l_decap_8
X_6180_ _6180_/Y _6180_/A _6180_/B vddd vssd sg13cmos5l_nand2_1
X_5200_ _5206_/C _7244_/Q _5200_/B _5213_/B vddd vssd sg13cmos5l_nor3_1
X_5131_ _5132_/A _7250_/Q _7251_/Q _5221_/A vddd vssd sg13cmos5l_nor3_1
XFILLER_26_2497 vddd vssd sg13cmos5l_decap_8
Xhold1507 hold513/A _7007_/Q vddd vssd sg13cmos5l_dlygate4sd3_1
X_5062_ _5063_/C _5062_/A _6013_/A _5062_/C _5062_/D vddd vssd sg13cmos5l_nor4_1
XFILLER_6_2547 vddd vssd sg13cmos5l_decap_8
XFILLER_22_1605 vddd vssd sg13cmos5l_decap_8
XFILLER_22_1616 vddd vssd sg13cmos5l_decap_8
Xhold1518 hold967/A _7304_/Q vddd vssd sg13cmos5l_dlygate4sd3_1
X_4013_ _4013_/Y _5149_/B _3882_/Y _4011_/Y _4012_/Y _3889_/B vddd vssd sg13cmos5l_a221oi_1
XFILLER_4_2260 vddd vssd sg13cmos5l_decap_4
XFILLER_0_2146 vddd vssd sg13cmos5l_decap_8
X_5964_ _5979_/C _7232_/Q _7233_/Q vddd vssd sg13cmos5l_nand2_1
X_5895_ _5909_/B _5910_/B _5910_/C vddd vssd sg13cmos5l_nor2b_1
X_4915_ _7312_/D hold964/X _4905_/Y _4914_/Y vddd vssd sg13cmos5l_o21ai_1
XFILLER_32_28 vddd vssd sg13cmos5l_decap_8
X_4846_ _4846_/Y sram_odata[4] _4856_/A2 _4845_/Y _4841_/B _4839_/B vddd vssd sg13cmos5l_a221oi_1
Xtiedowns\[7\] sram_odata[7] vddd vssd sg13cmos5l_antennanp
XFILLER_14_1166 vddd vssd sg13cmos5l_decap_8
X_4777_ _4785_/B _4671_/A _4776_/X _4498_/A vddd vssd sg13cmos5l_a21o_1
X_6516_ _6516_/X _6501_/A _6516_/A1 _6516_/S vddd vssd sg13cmos5l_mux2_1
X_3728_ _3728_/Y _3869_/B _3728_/B vddd vssd sg13cmos5l_nand2b_1
X_6447_ _7173_/D _6447_/A1 _6449_/S _6446_/Y vddd vssd sg13cmos5l_a21oi_1
X_3659_ _4292_/B _3659_/A _4282_/A _3659_/C vddd vssd sg13cmos5l_or3_1
X_6378_ _6381_/B _6378_/A _6733_/B vddd vssd sg13cmos5l_nor2_1
X_5329_ _5329_/Y _5329_/A _5339_/C vddd vssd sg13cmos5l_nor2_1
XFILLER_9_2193 vddd vssd sg13cmos5l_decap_8
XFILLER_5_2057 vddd vssd sg13cmos5l_decap_8
XFILLER_28_232 vddd vssd sg13cmos5l_decap_4
XFILLER_21_1148 vddd vssd sg13cmos5l_decap_8
XFILLER_3_1091 vddd vssd sg13cmos5l_decap_8
Xclkbuf_4_8__f_clk_regs _7351_/CLK clkbuf_3_4_0_clk_regs/X vddd vssd sg13cmos5l_buf_8
XFILLER_32_1200 vddd vssd sg13cmos5l_decap_8
XFILLER_16_1965 vddd vssd sg13cmos5l_decap_4
XFILLER_12_2519 vddd vssd sg13cmos5l_decap_8
XFILLER_12_1829 vddd vssd sg13cmos5l_decap_4
XFILLER_32_1277 vddd vssd sg13cmos5l_decap_8
XFILLER_14_7 vddd vssd sg13cmos5l_decap_8
XFILLER_21_1660 vddd vssd sg13cmos5l_decap_8
X_6897__467 _7385_/CLK _7399_/CLK vddd vssd sg13cmos5l_inv_1
X_5680_ _5680_/Y _5680_/A _5680_/B vddd vssd sg13cmos5l_nand2_1
XFILLER_17_1718 vddd vssd sg13cmos5l_decap_8
X_4700_ _4700_/Y _4659_/B _4690_/B _4696_/A vddd vssd sg13cmos5l_o21ai_1
X_4631_ _4632_/B _4435_/A _3606_/Y _4794_/B1 _4628_/B vddd vssd sg13cmos5l_a22oi_1
XFILLER_15_2176 vddd vssd sg13cmos5l_decap_4
XFILLER_15_2187 vddd vssd sg13cmos5l_decap_8
XFILLER_15_1464 vddd vssd sg13cmos5l_decap_8
XFILLER_8_63 vddd vssd sg13cmos5l_decap_8
X_4562_ _4563_/B _4805_/B1 _4547_/Y _4558_/Y _4561_/Y vddd vssd sg13cmos5l_a22oi_1
X_7350_ _7350_/Q _7350_/CLK _7350_/D _6863_/Y vddd vssd sg13cmos5l_dfrbpq_1
X_6301_ _6301_/Y _3628_/Y _6290_/B _6297_/A vddd vssd sg13cmos5l_a21oi_1
XFILLER_28_2504 vddd vssd sg13cmos5l_decap_8
X_7281_ _7281_/Q _7293_/CLK _7281_/D fanout385/X vddd vssd sg13cmos5l_dfrbpq_1
X_4493_ _4493_/X _4456_/B _4492_/Y _4745_/B1 vddd vssd sg13cmos5l_a21o_1
X_3513_ _3513_/Y _3513_/A vddd vssd sg13cmos5l_inv_1
Xhold615 _7343_/D _4422_/Y vddd vssd sg13cmos5l_dlygate4sd3_1
XFILLER_7_692 vddd vssd sg13cmos5l_decap_8
Xhold626 _4828_/B _7395_/Q vddd vssd sg13cmos5l_dlygate4sd3_1
Xhold604 hold604/X _6590_/Y vddd vssd sg13cmos5l_dlygate4sd3_1
X_6232_ _6232_/X _6232_/A _6232_/B vddd vssd sg13cmos5l_and2_1
Xhold637 _3493_/A _7342_/Q vddd vssd sg13cmos5l_dlygate4sd3_1
Xhold648 _4861_/B _7317_/Q vddd vssd sg13cmos5l_dlygate4sd3_1
Xhold659 _6786_/A _7098_/Q vddd vssd sg13cmos5l_dlygate4sd3_1
XFILLER_28_1847 vddd vssd sg13cmos5l_decap_8
XFILLER_26_2250 vddd vssd sg13cmos5l_decap_4
X_6163_ _6163_/Y _6012_/A _5222_/B _5222_/A vddd vssd sg13cmos5l_a21oi_1
Xoutbuffers\[54\] bandgap_trim[15] _6809_/X vddd vssd sg13cmos5l_buf_16
Xhold1304 _6697_/A0 _7042_/Q vddd vssd sg13cmos5l_dlygate4sd3_1
Xhold1315 _7020_/D _6664_/X vddd vssd sg13cmos5l_dlygate4sd3_1
XFILLER_22_2136 vddd vssd sg13cmos5l_decap_8
X_6094_ _6094_/Y _3791_/B _5168_/A _5169_/A vddd vssd sg13cmos5l_a21oi_1
X_5114_ _5114_/X _5115_/A _5265_/B vddd vssd sg13cmos5l_and2_1
XFILLER_6_2377 vddd vssd sg13cmos5l_decap_8
Xhold1337 _7033_/D _6682_/X vddd vssd sg13cmos5l_dlygate4sd3_1
X_5045_ _5045_/X _5237_/B _5133_/B vddd vssd sg13cmos5l_and2_1
XFILLER_26_1582 vddd vssd sg13cmos5l_decap_4
Xhold1326 _6690_/A0 _7038_/Q vddd vssd sg13cmos5l_dlygate4sd3_1
Xhold1348 hold1348/X _7294_/Q vddd vssd sg13cmos5l_dlygate4sd3_1
Xhold1359 _7390_/D _3761_/X vddd vssd sg13cmos5l_dlygate4sd3_1
XFILLER_27_28 vddd vssd sg13cmos5l_decap_8
X_6996_ _6996_/Q _7013_/CLK _6996_/D _6943_/Y vddd vssd sg13cmos5l_dfrbpq_1
XFILLER_14_909 vddd vssd sg13cmos5l_decap_8
XFILLER_22_920 vddd vssd sg13cmos5l_decap_4
X_5947_ _5947_/Y _5949_/A _5949_/C vddd vssd sg13cmos5l_xnor2_1
X_5878_ _5879_/C _5876_/X _5877_/X _5884_/C vddd vssd sg13cmos5l_a21oi_1
X_4829_ _4829_/Y _4829_/A _4829_/B vddd vssd sg13cmos5l_nand2_1
XFILLER_0_356 vddd vssd sg13cmos5l_decap_8
XFILLER_0_378 vddd vssd sg13cmos5l_decap_8
XFILLER_17_61 vddd vssd sg13cmos5l_decap_8
XFILLER_31_205 vddd vssd sg13cmos5l_decap_8
XFILLER_24_290 vddd vssd sg13cmos5l_decap_8
XFILLER_16_2441 vddd vssd sg13cmos5l_decap_8
XFILLER_9_979 vddd vssd sg13cmos5l_decap_8
XFILLER_12_1604 vddd vssd sg13cmos5l_decap_8
XFILLER_32_1052 vddd vssd sg13cmos5l_decap_8
Xclkbuf_3_1_0_clk_regs clkbuf_3_1_0_clk_regs/X clkbuf_0_clk_regs/X vddd vssd sg13cmos5l_buf_8
XFILLER_10_2040 vddd vssd sg13cmos5l_decap_8
XFILLER_12_1648 vddd vssd sg13cmos5l_decap_4
XFILLER_10_2084 vddd vssd sg13cmos5l_decap_4
XFILLER_4_673 vddd vssd sg13cmos5l_decap_8
XFILLER_10_1394 vddd vssd sg13cmos5l_decap_8
XFILLER_27_1880 vddd vssd sg13cmos5l_decap_4
XFILLER_23_2467 vddd vssd sg13cmos5l_decap_8
XFILLER_3_1827 vddd vssd sg13cmos5l_decap_4
X_6850_ _6850_/Y _6956_/A _6955_/B_N vddd vssd sg13cmos5l_nor2b_1
X_6781_ _6781_/X hold733/X _7378_/Q _6781_/S vddd vssd sg13cmos5l_mux2_1
XFILLER_1_1584 vddd vssd sg13cmos5l_decap_8
X_5801_ _5801_/X _5683_/A _5800_/A _5800_/Y vddd vssd sg13cmos5l_a21o_1
X_3993_ _3994_/B mask_rev_in[11] _4077_/B _4253_/B1 vddd vssd sg13cmos5l_a21oi_1
X_5732_ _5734_/B _5732_/A _5739_/B _5733_/B vddd vssd sg13cmos5l_nand3_1
XFILLER_17_1548 vddd vssd sg13cmos5l_decap_4
XFILLER_30_2438 vddd vssd sg13cmos5l_decap_8
X_5663_ _5679_/B _5683_/B _5682_/A vddd vssd sg13cmos5l_nor2_1
X_5594_ _5596_/B _5594_/A _5601_/B _5595_/B vddd vssd sg13cmos5l_nand3_1
X_4614_ _4614_/Y _4614_/A _4614_/B vddd vssd sg13cmos5l_nor2_1
XFILLER_15_1272 vddd vssd sg13cmos5l_decap_8
X_4545_ _4545_/Y _4545_/A _4614_/B vddd vssd sg13cmos5l_nor2_1
X_7333_ _7333_/Q _7348_/CLK _7333_/D _6846_/Y vddd vssd sg13cmos5l_dfrbpq_1
XFILLER_11_1158 vddd vssd sg13cmos5l_decap_8
X_7264_ _7264_/Q _7278_/CLK _7264_/D fanout393/X vddd vssd sg13cmos5l_dfrbpq_1
X_4476_ _4476_/Y _4457_/Y _4458_/Y _4475_/Y _4734_/A vddd vssd sg13cmos5l_a22oi_1
XFILLER_8_2417 vddd vssd sg13cmos5l_decap_4
Xhold478 _4964_/A hold935/X vddd vssd sg13cmos5l_dlygate4sd3_1
XFILLER_28_2378 vddd vssd sg13cmos5l_decap_8
XFILLER_28_1633 vddd vssd sg13cmos5l_decap_4
X_6215_ _6215_/Y _6215_/A _6233_/B _7229_/Q vddd vssd sg13cmos5l_nor3_1
Xhold489 sram_addr[2] hold489/A vddd vssd sg13cmos5l_dlygate4sd3_1
X_7195_ _7195_/Q _7199_/CLK _7195_/D fanout371/X vddd vssd sg13cmos5l_dfrbpq_1
X_6146_ _6146_/Y _4194_/X _5206_/A _6144_/Y _6145_/Y _7290_/Q vddd vssd sg13cmos5l_a221oi_1
Xhold1123 _7050_/D _6707_/X vddd vssd sg13cmos5l_dlygate4sd3_1
XFILLER_28_1699 vddd vssd sg13cmos5l_decap_8
Xhold1101 _6731_/A1 _7065_/Q vddd vssd sg13cmos5l_dlygate4sd3_1
Xhold1112 _7214_/D _6523_/Y vddd vssd sg13cmos5l_dlygate4sd3_1
Xhold1134 _6679_/A0 _7030_/Q vddd vssd sg13cmos5l_dlygate4sd3_1
Xhold1145 _6601_/A0 _7259_/Q vddd vssd sg13cmos5l_dlygate4sd3_1
Xhold1167 _6560_/A1 _5967_/B vddd vssd sg13cmos5l_dlygate4sd3_1
Xhold1156 _7158_/D _6417_/Y vddd vssd sg13cmos5l_dlygate4sd3_1
XFILLER_6_1473 vddd vssd sg13cmos5l_decap_8
X_6077_ _6078_/B _6012_/A _5135_/Y _6076_/Y vddd vssd sg13cmos5l_a21oi_1
Xhold1178 _6666_/A1 _7022_/Q vddd vssd sg13cmos5l_dlygate4sd3_1
X_5028_ sram_idata[4] _5028_/A _5032_/B vddd vssd sg13cmos5l_and2_1
Xhold1189 _7339_/D _4541_/X vddd vssd sg13cmos5l_dlygate4sd3_1
XFILLER_22_1276 vddd vssd sg13cmos5l_decap_8
X_6979_ _6979_/Q _7013_/CLK _6979_/D _6926_/Y vddd vssd sg13cmos5l_dfrbpq_1
XFILLER_22_772 vddd vssd sg13cmos5l_decap_8
XFILLER_21_271 vddd vssd sg13cmos5l_decap_4
Xclkbuf_leaf_2_SCK_regs _7398_/CLK clkbuf_3_0_0_SCK_regs/X vddd vssd sg13cmos5l_buf_8
XFILLER_13_1979 vddd vssd sg13cmos5l_decap_8
Xhold990 hold990/X _6603_/Y vddd vssd sg13cmos5l_dlygate4sd3_1
XFILLER_32_514 vddd vssd sg13cmos5l_decap_8
XFILLER_17_577 vddd vssd sg13cmos5l_decap_8
XFILLER_2_1871 vddd vssd sg13cmos5l_decap_8
XFILLER_18_2558 vddd vssd sg13cmos5l_decap_8
XFILLER_8_220 vddd vssd sg13cmos5l_decap_8
XFILLER_13_783 vddd vssd sg13cmos5l_decap_8
XFILLER_16_1581 vddd vssd sg13cmos5l_decap_8
XFILLER_8_275 vddd vssd sg13cmos5l_decap_8
XFILLER_8_286 vddd vssd sg13cmos5l_decap_8
X_4330_ _4332_/A _4330_/A _4344_/B vddd vssd sg13cmos5l_nand2_1
XFILLER_29_1942 vddd vssd sg13cmos5l_decap_4
XFILLER_25_2529 vddd vssd sg13cmos5l_decap_8
XFILLER_4_481 vddd vssd sg13cmos5l_decap_8
XFILLER_5_86 vddd vssd sg13cmos5l_decap_8
X_4261_ _4261_/Y _4261_/A _7368_/Q vddd vssd sg13cmos5l_nor2_1
X_6000_ _6000_/Y _6130_/A _6000_/B _6043_/B vddd vssd sg13cmos5l_nand3_1
X_4192_ _4192_/Y _5117_/A _6563_/A _4190_/X _4191_/Y _3901_/A vddd vssd sg13cmos5l_a221oi_1
XFILLER_3_1613 vddd vssd sg13cmos5l_decap_8
XFILLER_23_1574 vddd vssd sg13cmos5l_decap_8
Xoutbuffers\[17\] proj_sel[4] _7022_/Q vddd vssd sg13cmos5l_buf_16
XFILLER_23_514 vddd vssd sg13cmos5l_decap_8
X_6833_ _6833_/Y _6838_/A _6834_/B_N vddd vssd sg13cmos5l_nor2b_1
XFILLER_17_1301 vddd vssd sg13cmos5l_decap_4
X_3976_ _3976_/Y _7042_/Q _6691_/A vddd vssd sg13cmos5l_nor2_1
XFILLER_17_2079 vddd vssd sg13cmos5l_decap_8
X_6764_ _6764_/Y _6764_/A _6767_/S vddd vssd sg13cmos5l_nor2_1
X_6695_ _6695_/Y _6695_/A _6698_/S vddd vssd sg13cmos5l_nand2_1
X_5715_ _5733_/A _7200_/Q _7201_/Q vddd vssd sg13cmos5l_nor2_1
X_5646_ _5647_/C _5651_/B _5657_/B _5646_/C _5646_/D vddd vssd sg13cmos5l_nor4_1
X_5577_ _5577_/X _5595_/A _5601_/A vddd vssd sg13cmos5l_and2_1
X_4528_ _4528_/Y _4530_/A _4520_/Y _4782_/A vddd vssd sg13cmos5l_o21ai_1
X_7316_ _7316_/Q _7338_/CLK _7316_/D _6829_/Y vddd vssd sg13cmos5l_dfrbpq_1
X_4459_ _4459_/Y _4641_/A _4552_/A vddd vssd sg13cmos5l_nor2_1
X_7247_ _7247_/Q _7252_/CLK _7247_/D fanout391/X vddd vssd sg13cmos5l_dfrbpq_1
XFILLER_24_2028 vddd vssd sg13cmos5l_decap_4
XFILLER_24_1316 vddd vssd sg13cmos5l_decap_8
XFILLER_8_1546 vddd vssd sg13cmos5l_decap_8
X_7178_ _7178_/Q _7179_/CLK _7178_/D fanout368/X vddd vssd sg13cmos5l_dfrbpq_1
X_6129_ _6129_/Y _7315_/Q _5241_/A _5205_/B vddd vssd sg13cmos5l_a21oi_1
XFILLER_22_591 vddd vssd sg13cmos5l_decap_8
XFILLER_13_2455 vddd vssd sg13cmos5l_decap_8
XFILLER_10_753 vddd vssd sg13cmos5l_decap_8
XFILLER_14_84 vddd vssd sg13cmos5l_decap_8
XFILLER_13_1732 vddd vssd sg13cmos5l_decap_8
XFILLER_6_757 vddd vssd sg13cmos5l_decap_8
XFILLER_30_94 vddd vssd sg13cmos5l_decap_8
XFILLER_2_952 vddd vssd sg13cmos5l_decap_4
Xtiedowns\[53\] mask_rev_in[9] vddd vssd sg13cmos5l_antennanp
XFILLER_7_1012 vddd vssd sg13cmos5l_decap_8
XFILLER_24_2562 vddd vssd sg13cmos5l_decap_8
XFILLER_20_2437 vddd vssd sg13cmos5l_decap_8
XFILLER_20_1736 vddd vssd sg13cmos5l_decap_8
XFILLER_17_330 vddd vssd sg13cmos5l_decap_8
XFILLER_18_864 vddd vssd sg13cmos5l_decap_8
XFILLER_32_322 vddd vssd sg13cmos5l_decap_8
X_3830_ _3937_/A _4002_/D _3869_/D vddd vssd sg13cmos5l_nor2_1
XFILLER_32_399 vddd vssd sg13cmos5l_decap_8
Xoutbuffers\[107\] dbus_out[10] _5604_/Y vddd vssd sg13cmos5l_buf_16
XFILLER_18_1665 vddd vssd sg13cmos5l_decap_8
X_3761_ _3761_/X _3761_/A1 _4173_/B _3760_/Y vddd vssd sg13cmos5l_a21o_1
XFILLER_18_1698 vddd vssd sg13cmos5l_decap_8
X_5500_ _5507_/B _7171_/Q _7170_/Q vddd vssd sg13cmos5l_nor2b_1
XFILLER_31_2566 vddd vssd sg13cmos5l_decap_8
XFILLER_12_1231 vddd vssd sg13cmos5l_decap_4
X_6480_ _6487_/B _6480_/A _6660_/B vddd vssd sg13cmos5l_nand2_1
X_3692_ _3863_/C _3750_/C _3750_/D vddd vssd sg13cmos5l_nand2_1
X_5431_ _5431_/Y _7160_/Q _7161_/Q _5454_/A _7163_/Q vddd vssd sg13cmos5l_nor4_1
X_5362_ _5362_/X _5532_/A _7151_/Q vddd vssd sg13cmos5l_or2_1
X_7101_ _7101_/Q _7125_/CLK _7101_/D _6844_/B_N vddd vssd sg13cmos5l_dfrbpq_1
X_4313_ _4313_/X _4336_/A _4323_/B vddd vssd sg13cmos5l_and2_1
X_7032_ _7032_/Q _7278_/CLK _7032_/D fanout382/X vddd vssd sg13cmos5l_dfrbpq_1
XFILLER_9_2556 vddd vssd sg13cmos5l_decap_8
X_5293_ _5293_/X _4323_/B _4308_/B _4264_/A vddd vssd sg13cmos5l_a21o_1
XFILLER_29_1794 vddd vssd sg13cmos5l_decap_8
X_4244_ _4244_/Y _7098_/Q _6304_/A _6755_/A vddd vssd sg13cmos5l_o21ai_1
XFILLER_28_606 vddd vssd sg13cmos5l_decap_8
X_4175_ _4175_/Y _7264_/Q _4175_/B vddd vssd sg13cmos5l_nand2b_1
XFILLER_3_2111 vddd vssd sg13cmos5l_decap_8
XFILLER_27_105 vddd vssd sg13cmos5l_decap_8
XFILLER_24_845 vddd vssd sg13cmos5l_decap_8
X_6816_ _6816_/Y _6906_/A _6871_/B_N vddd vssd sg13cmos5l_nor2b_1
X_6747_ _7076_/D _6747_/A1 _6746_/B _6746_/Y vddd vssd sg13cmos5l_o21ai_1
XFILLER_23_377 vddd vssd sg13cmos5l_decap_8
X_3959_ _3959_/Y _7159_/Q _6412_/A _3956_/Y _3953_/Y _6406_/A vddd vssd sg13cmos5l_a221oi_1
XFILLER_13_1006 vddd vssd sg13cmos5l_decap_8
X_6678_ _6678_/X _6678_/A0 _6678_/A1 _6678_/S vddd vssd sg13cmos5l_mux2_1
XFILLER_30_2087 vddd vssd sg13cmos5l_decap_8
X_5629_ _5629_/Y _5737_/A _5627_/Y _5628_/Y vddd vssd sg13cmos5l_a21oi_1
XFILLER_24_1179 vddd vssd sg13cmos5l_decap_4
XFILLER_19_639 vddd vssd sg13cmos5l_decap_8
XFILLER_27_694 vddd vssd sg13cmos5l_decap_8
XFILLER_26_182 vddd vssd sg13cmos5l_decap_8
XFILLER_30_804 vddd vssd sg13cmos5l_decap_4
XFILLER_25_72 vddd vssd sg13cmos5l_decap_8
XFILLER_15_856 vddd vssd sg13cmos5l_decap_4
XFILLER_19_1963 vddd vssd sg13cmos5l_decap_8
XFILLER_15_2528 vddd vssd sg13cmos5l_decap_8
XFILLER_15_1816 vddd vssd sg13cmos5l_decap_8
XFILLER_29_1002 vddd vssd sg13cmos5l_decap_8
XFILLER_26_2602 vddd vssd sg13cmos5l_decap_4
XFILLER_9_1118 vddd vssd sg13cmos5l_decap_8
XFILLER_26_1945 vddd vssd sg13cmos5l_decap_8
XFILLER_2_65 vddd vssd sg13cmos5l_decap_8
XFILLER_24_1680 vddd vssd sg13cmos5l_decap_8
X_5980_ _5980_/Y _7234_/Q _7235_/Q _5980_/C vddd vssd sg13cmos5l_nor3_1
XFILLER_24_119 vddd vssd sg13cmos5l_decap_8
X_4931_ _4952_/A _4951_/A _4955_/A vddd vssd sg13cmos5l_and2_1
XFILLER_18_2152 vddd vssd sg13cmos5l_decap_8
X_4862_ _4866_/A _4863_/A _7139_/Q _7138_/Q _4933_/A vddd vssd sg13cmos5l_a22oi_1
X_6601_ _6601_/X _6601_/A0 _6704_/A0 _6601_/S vddd vssd sg13cmos5l_mux2_1
X_3813_ _3813_/Y _3813_/A _4173_/B vddd vssd sg13cmos5l_nand2_1
XFILLER_32_196 vddd vssd sg13cmos5l_decap_8
X_4793_ _4793_/X _6793_/A _6979_/D vddd vssd sg13cmos5l_xor2_1
XFILLER_18_2196 vddd vssd sg13cmos5l_decap_8
XFILLER_18_1484 vddd vssd sg13cmos5l_decap_8
XANTENNA_26 wire61/X vddd vssd sg13cmos5l_antennanp
XANTENNA_48 wire13/X vddd vssd sg13cmos5l_antennanp
XANTENNA_37 _5029_/A vddd vssd sg13cmos5l_antennanp
XANTENNA_15 _7297_/Q vddd vssd sg13cmos5l_antennanp
XFILLER_31_2363 vddd vssd sg13cmos5l_decap_8
X_3744_ _3744_/Y _3630_/Y _4077_/B _4168_/B1 vddd vssd sg13cmos5l_a21oi_1
X_6532_ _7219_/D _6546_/A _6532_/A1 _6532_/S vddd vssd sg13cmos5l_mux2_1
X_6463_ _7181_/D hold910/X _6465_/B _6462_/Y vddd vssd sg13cmos5l_a21oi_1
X_3675_ _3919_/A _4333_/B _4336_/B _3678_/S vddd vssd sg13cmos5l_mux2_1
XFILLER_9_381 vddd vssd sg13cmos5l_decap_4
XFILLER_31_1673 vddd vssd sg13cmos5l_decap_4
Xoutbuffers\[84\] io_oe[11] _5022_/Y vddd vssd sg13cmos5l_buf_16
X_5414_ _5414_/X _7156_/Q _5416_/B vddd vssd sg13cmos5l_and2_1
X_6394_ _7145_/D _6394_/A1 _6397_/B _6393_/Y vddd vssd sg13cmos5l_a21oi_1
X_5345_ _5345_/X _5345_/A _5345_/B vddd vssd sg13cmos5l_and2_1
XFILLER_9_2353 vddd vssd sg13cmos5l_decap_8
X_5276_ _5278_/C _5274_/A _5274_/B _5270_/Y vddd vssd sg13cmos5l_o21ai_1
X_7015_ _7015_/Q _7016_/CLK _7015_/D _6962_/Y vddd vssd sg13cmos5l_dfrbpq_1
X_4227_ _4227_/Y _7140_/Q _6383_/A _6733_/A vddd vssd sg13cmos5l_o21ai_1
X_4158_ _4158_/Y _7115_/Q _3701_/Y _6304_/A vddd vssd sg13cmos5l_o21ai_1
X_4089_ _4089_/Y _3536_/Y _6652_/A _4087_/Y _4088_/Y _6642_/A vddd vssd sg13cmos5l_a221oi_1
XFILLER_24_631 vddd vssd sg13cmos5l_decap_8
Xclkbuf_4_7__f_clk_regs _7340_/CLK clkbuf_3_3_0_clk_regs/X vddd vssd sg13cmos5l_buf_8
XFILLER_24_697 vddd vssd sg13cmos5l_decap_8
XFILLER_14_2583 vddd vssd sg13cmos5l_decap_8
XFILLER_10_2447 vddd vssd sg13cmos5l_decap_8
XFILLER_30_1161 vddd vssd sg13cmos5l_decap_8
XFILLER_10_1724 vddd vssd sg13cmos5l_decap_8
XFILLER_3_513 vddd vssd sg13cmos5l_decap_8
XFILLER_11_63 vddd vssd sg13cmos5l_decap_8
Xfanout382 fanout382/X fanout384/X vddd vssd sg13cmos5l_buf_1
Xfanout393 fanout393/X fanout394/X vddd vssd sg13cmos5l_buf_1
XFILLER_19_414 vddd vssd sg13cmos5l_decap_8
Xfanout371 fanout371/X fanout373/X vddd vssd sg13cmos5l_buf_1
Xfanout360 fanout360/X fanout363/X vddd vssd sg13cmos5l_buf_1
XFILLER_21_2554 vddd vssd sg13cmos5l_decap_8
Xtiedowns\[16\] _6215_/A vddd vssd sg13cmos5l_antennanp
XFILLER_19_458 vddd vssd sg13cmos5l_decap_8
XFILLER_19_2450 vddd vssd sg13cmos5l_decap_8
XFILLER_14_130 vddd vssd sg13cmos5l_decap_4
XFILLER_32_1960 vddd vssd sg13cmos5l_decap_8
XFILLER_15_1668 vddd vssd sg13cmos5l_decap_8
XFILLER_13_2071 vddd vssd sg13cmos5l_decap_8
XFILLER_11_892 vddd vssd sg13cmos5l_decap_8
Xhold819 hold819/X _3607_/Y vddd vssd sg13cmos5l_dlygate4sd3_1
Xhold808 _7128_/D _6359_/X vddd vssd sg13cmos5l_dlygate4sd3_1
X_3460_ _3460_/Y _5023_/A vddd vssd sg13cmos5l_inv_1
X_5130_ _6079_/B _5208_/A _5115_/A vddd vssd sg13cmos5l_nor2b_1
XFILLER_6_2526 vddd vssd sg13cmos5l_decap_8
XFILLER_26_2476 vddd vssd sg13cmos5l_decap_8
X_5061_ _5062_/D _5061_/A _5061_/B vddd vssd sg13cmos5l_nand2_1
Xhold1508 _4330_/A _7358_/Q vddd vssd sg13cmos5l_dlygate4sd3_1
Xhold1519 hold1519/X _7381_/Q vddd vssd sg13cmos5l_dlygate4sd3_1
X_4012_ _4012_/Y _4981_/B _3879_/Y _3882_/Y vddd vssd sg13cmos5l_a21oi_1
XFILLER_26_1797 vddd vssd sg13cmos5l_decap_4
XFILLER_20_2075 vddd vssd sg13cmos5l_decap_8
XFILLER_19_970 vddd vssd sg13cmos5l_decap_8
XFILLER_0_2125 vddd vssd sg13cmos5l_decap_8
XFILLER_20_1352 vddd vssd sg13cmos5l_decap_8
X_5963_ _5980_/C _5963_/A _7233_/Q vddd vssd sg13cmos5l_nand2_1
X_4914_ _4914_/Y _4914_/A sram_odata[3] _4920_/C vddd vssd sg13cmos5l_nand3_1
XFILLER_0_1468 vddd vssd sg13cmos5l_decap_8
X_5894_ _5899_/B _5910_/B _5910_/C vddd vssd sg13cmos5l_nand2_1
X_4845_ _4845_/Y _4845_/A _4845_/B vddd vssd sg13cmos5l_xnor2_1
X_4776_ _4776_/X _4776_/A _4779_/B vddd vssd sg13cmos5l_xor2_1
X_3727_ _3727_/Y _3869_/B _3728_/B vddd vssd sg13cmos5l_nor2b_1
X_6515_ _6515_/Y _6515_/A1 _6516_/S _6514_/Y vddd vssd sg13cmos5l_a21oi_1
X_6446_ _6446_/Y _6470_/A _6449_/S vddd vssd sg13cmos5l_nor2_1
X_3658_ _3658_/Y _7367_/Q _4282_/A _7365_/Q vddd vssd sg13cmos5l_nor3_1
X_3589_ _5867_/A _3589_/A vddd vssd sg13cmos5l_inv_1
X_6377_ _6377_/Y _6330_/A _6376_/B hold728/X vddd vssd sg13cmos5l_o21ai_1
X_5328_ _5342_/A _7144_/Q _7145_/Q vddd vssd sg13cmos5l_nand2_1
XFILLER_9_2172 vddd vssd sg13cmos5l_decap_8
X_5259_ _5260_/D _5273_/A _5259_/B vddd vssd sg13cmos5l_nor2_1
XFILLER_5_2036 vddd vssd sg13cmos5l_decap_8
XFILLER_28_211 vddd vssd sg13cmos5l_decap_8
XFILLER_21_1127 vddd vssd sg13cmos5l_decap_8
XFILLER_5_1357 vddd vssd sg13cmos5l_decap_8
Xwire81 wire81/X wire81/A vddd vssd sg13cmos5l_buf_4
XFILLER_25_984 vddd vssd sg13cmos5l_decap_8
XFILLER_19_1034 vddd vssd sg13cmos5l_decap_8
XFILLER_16_1911 vddd vssd sg13cmos5l_decap_8
XFILLER_8_638 vddd vssd sg13cmos5l_decap_8
XFILLER_32_1256 vddd vssd sg13cmos5l_decap_8
XFILLER_22_84 vddd vssd sg13cmos5l_decap_8
XFILLER_4_844 vddd vssd sg13cmos5l_decap_4
XFILLER_26_1005 vddd vssd sg13cmos5l_decap_8
XFILLER_0_0 vddd vssd sg13cmos5l_decap_8
XFILLER_4_888 vddd vssd sg13cmos5l_decap_8
Xfanout190 _6665_/A0 hold1454/X vddd vssd sg13cmos5l_buf_1
XFILLER_21_1683 vddd vssd sg13cmos5l_decap_8
XFILLER_16_951 vddd vssd sg13cmos5l_decap_8
XFILLER_15_2100 vddd vssd sg13cmos5l_decap_8
XFILLER_15_450 vddd vssd sg13cmos5l_decap_8
XFILLER_31_943 vddd vssd sg13cmos5l_decap_4
XFILLER_19_2291 vddd vssd sg13cmos5l_decap_8
Xclkbuf_3_6_0_SCK_regs clkload7/A clkbuf_0_SCK_regs/X vddd vssd sg13cmos5l_buf_8
X_4630_ _4630_/Y _4628_/Y _4629_/Y _4617_/Y vddd vssd sg13cmos5l_o21ai_1
XFILLER_15_2155 vddd vssd sg13cmos5l_decap_8
XFILLER_8_42 vddd vssd sg13cmos5l_decap_8
X_6300_ _6300_/X _7072_/Q _6297_/Y _6299_/Y vddd vssd sg13cmos5l_a21o_1
X_4561_ _4561_/Y _4652_/A _4561_/B vddd vssd sg13cmos5l_nor2_1
Xclkbuf_leaf_26_SCK_regs _7105_/CLK clkload6/A vddd vssd sg13cmos5l_buf_8
X_4492_ _4492_/Y _4492_/A _4492_/B vddd vssd sg13cmos5l_nand2_1
X_7280_ _7280_/Q _7293_/CLK _7280_/D fanout385/X vddd vssd sg13cmos5l_dfrbpq_1
Xhold605 _4302_/A _7371_/Q vddd vssd sg13cmos5l_dlygate4sd3_1
Xhold616 hold616/X _7383_/Q vddd vssd sg13cmos5l_dlygate4sd3_1
Xhold627 _5282_/A _5281_/Y vddd vssd sg13cmos5l_dlygate4sd3_1
XFILLER_7_671 vddd vssd sg13cmos5l_decap_8
X_3512_ _3512_/Y _3512_/A vddd vssd sg13cmos5l_inv_1
X_6231_ _6231_/Y _6231_/A1 _6225_/Y _6229_/Y _6217_/Y _6232_/B vddd vssd sg13cmos5l_a221oi_1
Xhold638 _7342_/D _4440_/X vddd vssd sg13cmos5l_dlygate4sd3_1
Xhold649 hold649/X _4861_/Y vddd vssd sg13cmos5l_dlygate4sd3_1
X_6162_ _6162_/Y _6159_/Y _6160_/X _6161_/Y vddd vssd sg13cmos5l_o21ai_1
X_5113_ _5265_/B _7240_/Q _5199_/B vddd vssd sg13cmos5l_nor2_1
Xhold1305 _7042_/D _6697_/X vddd vssd sg13cmos5l_dlygate4sd3_1
X_6093_ _6093_/Y _3768_/X _5168_/D _6091_/Y _6092_/Y vddd vssd sg13cmos5l_a22oi_1
Xhold1316 _3616_/A _7229_/Q vddd vssd sg13cmos5l_dlygate4sd3_1
XFILLER_6_1622 vddd vssd sg13cmos5l_decap_8
Xoutbuffers\[47\] bandgap_trim[8] _6295_/X vddd vssd sg13cmos5l_buf_16
Xhold1338 hold1338/X _7174_/Q vddd vssd sg13cmos5l_dlygate4sd3_1
X_5044_ _5133_/B _7267_/Q _7266_/Q vddd vssd sg13cmos5l_nor2_1
Xhold1327 _7038_/D _6690_/X vddd vssd sg13cmos5l_dlygate4sd3_1
Xhold1349 _6657_/A0 _6258_/C1 vddd vssd sg13cmos5l_dlygate4sd3_1
XFILLER_0_1210 vddd vssd sg13cmos5l_decap_8
X_6995_ _6995_/Q _7013_/CLK _6995_/D _6942_/Y vddd vssd sg13cmos5l_dfrbpq_1
X_5946_ _5946_/Y _5954_/A _5949_/C _5946_/C vddd vssd sg13cmos5l_nor3_1
X_5877_ _5877_/X _5973_/A _7222_/Q vddd vssd sg13cmos5l_or2_1
XFILLER_22_965 vddd vssd sg13cmos5l_decap_8
X_4828_ _4829_/B _4828_/A _4828_/B vddd vssd sg13cmos5l_nor2_1
XFILLER_21_475 vddd vssd sg13cmos5l_decap_8
X_4759_ _4759_/Y _4499_/A _4754_/Y _4758_/Y _4713_/A vddd vssd sg13cmos5l_a22oi_1
X_6429_ _6434_/S _6429_/A _6459_/B vddd vssd sg13cmos5l_nand2_1
XFILLER_27_1347 vddd vssd sg13cmos5l_decap_4
XFILLER_0_335 vddd vssd sg13cmos5l_decap_8
XFILLER_9_1290 vddd vssd sg13cmos5l_decap_8
XFILLER_29_542 vddd vssd sg13cmos5l_decap_8
XFILLER_22_1992 vddd vssd sg13cmos5l_decap_8
XFILLER_16_258 vddd vssd sg13cmos5l_decap_8
XFILLER_13_910 vddd vssd sg13cmos5l_decap_8
XFILLER_25_781 vddd vssd sg13cmos5l_decap_8
XFILLER_13_943 vddd vssd sg13cmos5l_decap_8
XFILLER_9_925 vddd vssd sg13cmos5l_decap_8
XFILLER_13_965 vddd vssd sg13cmos5l_decap_8
XFILLER_32_1031 vddd vssd sg13cmos5l_decap_8
XFILLER_16_2497 vddd vssd sg13cmos5l_decap_8
XFILLER_8_479 vddd vssd sg13cmos5l_decap_4
XFILLER_10_2030 vddd vssd sg13cmos5l_decap_4
XFILLER_27_2593 vddd vssd sg13cmos5l_decap_8
XFILLER_23_2446 vddd vssd sg13cmos5l_decap_8
XFILLER_23_1723 vddd vssd sg13cmos5l_decap_8
XFILLER_3_2529 vddd vssd sg13cmos5l_decap_8
XFILLER_7_1975 vddd vssd sg13cmos5l_decap_8
X_3992_ _3992_/Y _3625_/Y _4250_/A _3990_/X _3991_/Y _4252_/A vddd vssd sg13cmos5l_a221oi_1
X_5800_ _5800_/Y _5800_/A _5800_/B _5800_/C vddd vssd sg13cmos5l_nor3_1
X_6780_ _6780_/X hold792/X _6627_/A _6781_/S vddd vssd sg13cmos5l_mux2_1
XFILLER_22_217 vddd vssd sg13cmos5l_decap_8
X_5731_ _5734_/A _5736_/A _5719_/Y _5730_/Y vddd vssd sg13cmos5l_o21ai_1
XFILLER_30_2417 vddd vssd sg13cmos5l_decap_8
X_5662_ _5662_/Y _5683_/B _7193_/Q vddd vssd sg13cmos5l_nor2_1
X_5593_ _5596_/A _5593_/A _5593_/B _5593_/C vddd vssd sg13cmos5l_nand3_1
X_4613_ _4613_/Y _4590_/B _4624_/B _4745_/B1 vddd vssd sg13cmos5l_a21oi_1
X_4544_ _4544_/X _4520_/B _4543_/Y _4806_/A1 vddd vssd sg13cmos5l_a21o_1
X_7332_ _7332_/Q _7350_/CLK _7332_/D _6845_/Y vddd vssd sg13cmos5l_dfrbpq_1
Xmax_cap110 _3908_/A _3951_/A vddd vssd sg13cmos5l_buf_8
XFILLER_11_1137 vddd vssd sg13cmos5l_decap_8
X_7263_ _7263_/Q _7294_/CLK _7263_/D fanout392/X vddd vssd sg13cmos5l_dfrbpq_1
XFILLER_28_2357 vddd vssd sg13cmos5l_decap_8
X_6214_ _6237_/C _6233_/B _6221_/B vddd vssd sg13cmos5l_nand2_1
X_4475_ _4475_/Y _4511_/A _4474_/X _4616_/A vddd vssd sg13cmos5l_o21ai_1
XFILLER_8_2407 vddd vssd sg13cmos5l_decap_4
Xhold479 sram_addr[1] _5988_/X vddd vssd sg13cmos5l_dlygate4sd3_1
X_7194_ _7194_/Q _7199_/CLK _7194_/D fanout368/X vddd vssd sg13cmos5l_dfrbpq_1
XFILLER_28_1656 vddd vssd sg13cmos5l_decap_8
XFILLER_8_1739 vddd vssd sg13cmos5l_decap_4
X_6145_ _6145_/Y _6142_/Y _6143_/Y _5206_/A vddd vssd sg13cmos5l_a21oi_1
Xhold1124 _6672_/A0 _7026_/Q vddd vssd sg13cmos5l_dlygate4sd3_1
Xhold1102 _7065_/D _6731_/X vddd vssd sg13cmos5l_dlygate4sd3_1
Xhold1113 _3583_/A _7210_/Q vddd vssd sg13cmos5l_dlygate4sd3_1
XFILLER_6_2164 vddd vssd sg13cmos5l_decap_8
X_6076_ _6076_/Y _3904_/X _5132_/A _6074_/Y _6075_/Y _5135_/Y vddd vssd sg13cmos5l_a221oi_1
Xhold1135 _7030_/D _6679_/X vddd vssd sg13cmos5l_dlygate4sd3_1
Xhold1146 _7259_/D _6601_/X vddd vssd sg13cmos5l_dlygate4sd3_1
Xhold1157 _6643_/A _7284_/Q vddd vssd sg13cmos5l_dlygate4sd3_1
X_5027_ sram_idata[3] _5027_/A _5032_/B vddd vssd sg13cmos5l_and2_1
Xhold1179 _7022_/D _6666_/X vddd vssd sg13cmos5l_dlygate4sd3_1
XFILLER_26_512 vddd vssd sg13cmos5l_decap_8
Xhold1168 _3619_/A _7054_/Q vddd vssd sg13cmos5l_dlygate4sd3_1
XFILLER_22_1299 vddd vssd sg13cmos5l_decap_8
XFILLER_22_1288 vddd vssd sg13cmos5l_decap_4
XFILLER_26_567 vddd vssd sg13cmos5l_decap_4
X_6978_ _6978_/Q _7013_/CLK _6978_/D _6925_/Y vddd vssd sg13cmos5l_dfrbpq_1
XFILLER_0_1095 vddd vssd sg13cmos5l_decap_4
XFILLER_22_740 vddd vssd sg13cmos5l_decap_8
X_5929_ _5929_/Y _3538_/Y _7096_/Q _5928_/Y vddd vssd sg13cmos5l_o21ai_1
XFILLER_13_1936 vddd vssd sg13cmos5l_decap_4
XFILLER_13_1925 vddd vssd sg13cmos5l_decap_4
XFILLER_5_427 vddd vssd sg13cmos5l_decap_8
XFILLER_29_1409 vddd vssd sg13cmos5l_decap_8
XFILLER_11_1671 vddd vssd sg13cmos5l_decap_8
Xhold991 hold991/X _7282_/Q vddd vssd sg13cmos5l_dlygate4sd3_1
Xhold980 _7247_/D _6582_/X vddd vssd sg13cmos5l_dlygate4sd3_1
XFILLER_23_1008 vddd vssd sg13cmos5l_decap_4
XFILLER_29_350 vddd vssd sg13cmos5l_decap_8
XFILLER_28_72 vddd vssd sg13cmos5l_decap_8
XFILLER_22_2490 vddd vssd sg13cmos5l_decap_8
XFILLER_29_383 vddd vssd sg13cmos5l_decap_8
XFILLER_18_2537 vddd vssd sg13cmos5l_decap_8
XFILLER_9_722 vddd vssd sg13cmos5l_decap_8
XFILLER_16_1560 vddd vssd sg13cmos5l_decap_4
XFILLER_12_294 vddd vssd sg13cmos5l_decap_4
XFILLER_12_2125 vddd vssd sg13cmos5l_decap_8
XFILLER_29_1921 vddd vssd sg13cmos5l_decap_8
XFILLER_25_2508 vddd vssd sg13cmos5l_decap_8
X_4260_ _4260_/X hold616/X _3656_/Y _4259_/Y vddd vssd sg13cmos5l_a21o_1
XFILLER_5_65 vddd vssd sg13cmos5l_decap_8
X_4191_ _4191_/Y _7240_/Q _4017_/B _6563_/A vddd vssd sg13cmos5l_a21oi_1
XFILLER_27_2390 vddd vssd sg13cmos5l_decap_8
XFILLER_3_2315 vddd vssd sg13cmos5l_decap_4
XFILLER_7_2473 vddd vssd sg13cmos5l_decap_8
XFILLER_23_1531 vddd vssd sg13cmos5l_decap_8
XFILLER_3_1669 vddd vssd sg13cmos5l_decap_4
XFILLER_1_2072 vddd vssd sg13cmos5l_decap_8
X_6832_ _6832_/Y _6908_/A _6906_/B_N vddd vssd sg13cmos5l_nor2b_1
X_3975_ _3975_/Y _7047_/Q _4231_/C1 _3973_/Y _3974_/Y _3831_/X vddd vssd sg13cmos5l_a221oi_1
X_6763_ _6763_/Y _6777_/A1 _6767_/S hold785/X vddd vssd sg13cmos5l_a21oi_1
X_6694_ _6694_/X _6694_/A0 _6393_/A _6698_/S vddd vssd sg13cmos5l_mux2_1
X_5714_ _5714_/Y _5916_/A1 _5685_/Y _5713_/Y vddd vssd sg13cmos5l_a21oi_1
X_5645_ _5646_/D _5737_/A _5645_/B vddd vssd sg13cmos5l_nor2_1
X_5576_ _5601_/A _5597_/A _7183_/Q vddd vssd sg13cmos5l_nor2_1
X_4527_ _4532_/A _4641_/A _4503_/B _4530_/C _4530_/B _4552_/A vddd vssd sg13cmos5l_a221oi_1
X_7315_ _7315_/Q _7338_/CLK _7315_/D _6828_/Y vddd vssd sg13cmos5l_dfrbpq_1
X_4458_ _4458_/Y _4461_/A _4734_/A vddd vssd sg13cmos5l_nor2_1
X_7246_ _7246_/Q _7252_/CLK _7246_/D fanout391/X vddd vssd sg13cmos5l_dfrbpq_1
X_7177_ _7177_/Q _7199_/CLK _7177_/D fanout369/X vddd vssd sg13cmos5l_dfrbpq_1
XFILLER_8_2259 vddd vssd sg13cmos5l_decap_4
X_6128_ _6128_/Y _7336_/Q _6128_/A2 _6127_/Y vddd vssd sg13cmos5l_o21ai_1
X_4389_ _4390_/D _7331_/Q _7119_/Q _7116_/Q _4771_/A vddd vssd sg13cmos5l_a22oi_1
X_6059_ _6059_/Y _6122_/A _5119_/D _3535_/Y vddd vssd sg13cmos5l_o21ai_1
XFILLER_27_854 vddd vssd sg13cmos5l_decap_8
XFILLER_22_1085 vddd vssd sg13cmos5l_decap_8
XFILLER_17_2581 vddd vssd sg13cmos5l_decap_8
XFILLER_14_63 vddd vssd sg13cmos5l_decap_8
XFILLER_13_2434 vddd vssd sg13cmos5l_decap_8
XFILLER_6_736 vddd vssd sg13cmos5l_decap_8
XFILLER_10_787 vddd vssd sg13cmos5l_decap_8
XFILLER_30_84 vddd vssd sg13cmos5l_decap_4
XFILLER_29_1217 vddd vssd sg13cmos5l_decap_8
Xtiedowns\[46\] mask_rev_in[2] vddd vssd sg13cmos5l_antennanp
XFILLER_24_2541 vddd vssd sg13cmos5l_decap_8
XFILLER_18_843 vddd vssd sg13cmos5l_decap_4
XFILLER_32_301 vddd vssd sg13cmos5l_decap_8
XFILLER_18_2334 vddd vssd sg13cmos5l_decap_8
XFILLER_17_397 vddd vssd sg13cmos5l_decap_8
XFILLER_18_2367 vddd vssd sg13cmos5l_decap_8
XFILLER_32_378 vddd vssd sg13cmos5l_decap_8
XFILLER_18_1644 vddd vssd sg13cmos5l_decap_8
X_3760_ _3760_/Y wire14/X _3759_/Y _3660_/Y vddd vssd sg13cmos5l_a21oi_1
XFILLER_31_2545 vddd vssd sg13cmos5l_decap_8
X_3691_ _3691_/Y _4002_/B _3728_/B vddd vssd sg13cmos5l_nand2b_1
X_5430_ _5430_/X _5683_/A _5429_/A _5429_/Y vddd vssd sg13cmos5l_a21o_1
XFILLER_31_1877 vddd vssd sg13cmos5l_decap_4
X_5361_ _5368_/B _7151_/Q _5363_/B vddd vssd sg13cmos5l_nor2b_1
X_7100_ _7100_/Q _7100_/CLK _7100_/D _6844_/B_N vddd vssd sg13cmos5l_dfrbpq_1
X_5292_ _7399_/D _5292_/A vddd vssd sg13cmos5l_inv_1
XFILLER_9_2535 vddd vssd sg13cmos5l_decap_8
X_4312_ _4317_/A _4311_/Y _4312_/B vddd vssd sg13cmos5l_nand2b_1
XFILLER_29_2485 vddd vssd sg13cmos5l_decap_8
X_7031_ _7031_/Q _7188_/CLK _7031_/D fanout375/X vddd vssd sg13cmos5l_dfrbpq_1
X_4243_ _4243_/Y _7106_/Q _3695_/Y _3803_/B vddd vssd sg13cmos5l_a21oi_1
XFILLER_4_290 vddd vssd sg13cmos5l_decap_8
XFILLER_29_1773 vddd vssd sg13cmos5l_decap_8
X_4174_ _4174_/Y _4171_/Y _4172_/Y hold580/X vddd vssd sg13cmos5l_o21ai_1
XFILLER_24_802 vddd vssd sg13cmos5l_decap_8
XFILLER_19_2109 vddd vssd sg13cmos5l_decap_8
Xclkbuf_4_6__f_clk_regs _7337_/CLK clkbuf_3_3_0_clk_regs/X vddd vssd sg13cmos5l_buf_8
XFILLER_23_345 vddd vssd sg13cmos5l_decap_8
X_6815_ _6815_/Y _6906_/A _6871_/B_N vddd vssd sg13cmos5l_nor2b_1
X_6746_ _6746_/Y _6768_/A _6746_/B vddd vssd sg13cmos5l_nand2_1
XFILLER_32_1619 vddd vssd sg13cmos5l_decap_8
XFILLER_17_1165 vddd vssd sg13cmos5l_decap_8
X_3958_ _4139_/B _3958_/A _3967_/B vddd vssd sg13cmos5l_nand2_1
X_6677_ _6677_/Y _6677_/A1 _6678_/S _6676_/Y vddd vssd sg13cmos5l_o21ai_1
X_3889_ _3898_/B _7251_/Q _3889_/B vddd vssd sg13cmos5l_nand2_1
X_5628_ _5628_/Y _7186_/Q _7187_/Q _5628_/C vddd vssd sg13cmos5l_nor3_1
XFILLER_10_1928 vddd vssd sg13cmos5l_decap_8
X_5559_ _5559_/X _5727_/A _7179_/Q vddd vssd sg13cmos5l_or2_1
XFILLER_4_7 vddd vssd sg13cmos5l_decap_8
X_7229_ _7229_/Q _7233_/CLK _7229_/D fanout376/X vddd vssd sg13cmos5l_dfrbpq_1
XFILLER_8_2067 vddd vssd sg13cmos5l_decap_8
XFILLER_6_1090 vddd vssd sg13cmos5l_decap_8
XFILLER_26_161 vddd vssd sg13cmos5l_decap_8
XFILLER_25_51 vddd vssd sg13cmos5l_decap_8
XFILLER_15_2507 vddd vssd sg13cmos5l_decap_8
XFILLER_19_1997 vddd vssd sg13cmos5l_decap_8
XFILLER_13_1552 vddd vssd sg13cmos5l_decap_8
XFILLER_13_1596 vddd vssd sg13cmos5l_decap_8
XFILLER_29_1058 vddd vssd sg13cmos5l_decap_8
XFILLER_4_2443 vddd vssd sg13cmos5l_decap_4
XFILLER_20_1523 vddd vssd sg13cmos5l_decap_4
XFILLER_4_2498 vddd vssd sg13cmos5l_decap_8
XFILLER_20_2279 vddd vssd sg13cmos5l_decap_4
XFILLER_20_1556 vddd vssd sg13cmos5l_decap_8
XFILLER_18_684 vddd vssd sg13cmos5l_decap_8
X_4930_ _4955_/A _4930_/A _4930_/B vddd vssd sg13cmos5l_and2_1
XFILLER_0_1639 vddd vssd sg13cmos5l_decap_8
X_4861_ _4861_/Y _6973_/D _4861_/B vddd vssd sg13cmos5l_nand2_1
X_3812_ _3812_/Y _3810_/Y _3811_/Y hold570/X vddd vssd sg13cmos5l_o21ai_1
X_6600_ _7258_/D _6600_/A1 _6601_/S _6599_/Y vddd vssd sg13cmos5l_o21ai_1
XFILLER_32_175 vddd vssd sg13cmos5l_decap_8
XFILLER_18_1463 vddd vssd sg13cmos5l_decap_8
X_4792_ _7328_/D _4681_/A _4792_/A2 _4771_/Y vddd vssd sg13cmos5l_o21ai_1
XANTENNA_38 _6829_/A vddd vssd sg13cmos5l_antennanp
XANTENNA_27 wire81/X vddd vssd sg13cmos5l_antennanp
XANTENNA_16 _7297_/Q vddd vssd sg13cmos5l_antennanp
XFILLER_31_2342 vddd vssd sg13cmos5l_decap_8
XANTENNA_49 _6330_/A vddd vssd sg13cmos5l_antennanp
X_6531_ _7218_/D hold704/X _6532_/S _6530_/Y vddd vssd sg13cmos5l_a21oi_1
X_3743_ _3743_/Y _3908_/A _4251_/B vddd vssd sg13cmos5l_nor2_1
X_6462_ _6462_/Y _6470_/A _6465_/B vddd vssd sg13cmos5l_nor2_1
X_3674_ _3717_/A _4319_/A _4333_/B _3678_/S vddd vssd sg13cmos5l_mux2_1
X_6393_ _6393_/Y _6393_/A _6397_/B vddd vssd sg13cmos5l_nor2_1
X_5413_ _5413_/Y _7156_/Q _5416_/B vddd vssd sg13cmos5l_nor2b_1
X_5344_ _5344_/Y _5337_/Y _5340_/Y _5343_/Y vddd vssd sg13cmos5l_o21ai_1
Xoutbuffers\[77\] io_oe[4] _5172_/X vddd vssd sg13cmos5l_buf_16
XFILLER_25_2146 vddd vssd sg13cmos5l_decap_4
X_5275_ _6248_/A _5275_/A _5275_/B vddd vssd sg13cmos5l_nor2_1
XFILLER_9_1642 vddd vssd sg13cmos5l_decap_8
XFILLER_9_2387 vddd vssd sg13cmos5l_decap_8
X_7014_ _7014_/Q _7016_/CLK _7014_/D _6961_/Y vddd vssd sg13cmos5l_dfrbpq_1
XFILLER_25_1412 vddd vssd sg13cmos5l_decap_4
X_4226_ _4226_/Y _7144_/Q _4053_/B _4224_/Y _4225_/Y _3966_/Y vddd vssd sg13cmos5l_a221oi_1
XFILLER_25_1456 vddd vssd sg13cmos5l_decap_8
X_4157_ _4157_/Y _3528_/Y _4156_/A wire9/X _4156_/Y vddd vssd sg13cmos5l_a22oi_1
X_4088_ _4088_/Y _7025_/Q _4176_/A2 _6652_/A vddd vssd sg13cmos5l_a21oi_1
XFILLER_23_175 vddd vssd sg13cmos5l_decap_8
XFILLER_12_849 vddd vssd sg13cmos5l_decap_8
XFILLER_32_1438 vddd vssd sg13cmos5l_decap_8
X_6729_ _6729_/X _6715_/A _6729_/A1 _6732_/S vddd vssd sg13cmos5l_mux2_1
XFILLER_14_2562 vddd vssd sg13cmos5l_decap_8
XFILLER_11_42 vddd vssd sg13cmos5l_decap_8
Xfanout350 _6871_/B_N _6838_/B_N vddd vssd sg13cmos5l_buf_1
Xfanout361 fanout361/X fanout362/X vddd vssd sg13cmos5l_buf_1
Xfanout383 fanout383/X fanout384/X vddd vssd sg13cmos5l_buf_1
XFILLER_21_2533 vddd vssd sg13cmos5l_decap_8
Xfanout372 fanout372/X fanout373/X vddd vssd sg13cmos5l_buf_1
Xfanout394 fanout394/X fanout418/X vddd vssd sg13cmos5l_buf_1
XFILLER_14_186 vddd vssd sg13cmos5l_decap_8
XFILLER_15_1625 vddd vssd sg13cmos5l_decap_8
XFILLER_32_1950 vddd vssd sg13cmos5l_decap_4
XFILLER_13_2050 vddd vssd sg13cmos5l_decap_8
XFILLER_32_1994 vddd vssd sg13cmos5l_decap_8
Xhold809 _4293_/A _7368_/Q vddd vssd sg13cmos5l_dlygate4sd3_1
XFILLER_7_886 vddd vssd sg13cmos5l_decap_8
XFILLER_26_2455 vddd vssd sg13cmos5l_decap_8
XFILLER_6_2505 vddd vssd sg13cmos5l_decap_8
X_5060_ _5061_/B _7284_/Q _5278_/A _5060_/C vddd vssd sg13cmos5l_nor3_1
XFILLER_2_591 vddd vssd sg13cmos5l_decap_8
XFILLER_26_1776 vddd vssd sg13cmos5l_decap_8
X_4011_ _4011_/Y _4011_/A _4011_/B _4011_/C vddd vssd sg13cmos5l_nand3_1
Xhold1509 _3677_/A0 _7358_/Q vddd vssd sg13cmos5l_dlygate4sd3_1
XFILLER_20_2032 vddd vssd sg13cmos5l_decap_8
XFILLER_0_2104 vddd vssd sg13cmos5l_decap_8
XFILLER_26_908 vddd vssd sg13cmos5l_decap_8
XFILLER_4_1561 vddd vssd sg13cmos5l_decap_8
X_5962_ _5975_/A _5983_/A _5962_/B vddd vssd sg13cmos5l_nor2_1
XFILLER_0_1425 vddd vssd sg13cmos5l_decap_8
X_4913_ _4913_/Y hold757/X _4920_/C _4912_/Y vddd vssd sg13cmos5l_o21ai_1
XFILLER_0_1458 vddd vssd sg13cmos5l_decap_8
X_5893_ _5912_/C _5910_/C _5910_/B vddd vssd sg13cmos5l_nand2b_1
X_4844_ _4844_/Y _4839_/B _4843_/Y hold635/X vddd vssd sg13cmos5l_o21ai_1
XFILLER_21_679 vddd vssd sg13cmos5l_decap_8
XFILLER_18_1271 vddd vssd sg13cmos5l_decap_8
X_4775_ _4779_/B _5329_/A _4815_/A _4771_/A vddd vssd sg13cmos5l_o21ai_1
XFILLER_14_1124 vddd vssd sg13cmos5l_decap_8
X_3726_ _3735_/A _4477_/B _4067_/B1 _3722_/Y _3688_/Y vddd vssd sg13cmos5l_a22oi_1
X_6514_ _6514_/Y _6553_/A _6516_/S vddd vssd sg13cmos5l_nor2_1
X_6445_ _7172_/D _6482_/A1 _6449_/S hold994/X vddd vssd sg13cmos5l_o21ai_1
X_3657_ _4258_/A _4173_/B vddd vssd sg13cmos5l_inv_1
XFILLER_27_2219 vddd vssd sg13cmos5l_decap_8
X_3588_ _3588_/Y _3588_/A vddd vssd sg13cmos5l_inv_1
X_6376_ _6376_/Y _6376_/A _6376_/B vddd vssd sg13cmos5l_nand2_1
X_5327_ _5337_/A _7146_/Q _5327_/B vddd vssd sg13cmos5l_nor2_1
XFILLER_0_517 vddd vssd sg13cmos5l_decap_8
XFILLER_5_1303 vddd vssd sg13cmos5l_decap_4
X_5258_ _6203_/B _5263_/A _5258_/B vddd vssd sg13cmos5l_nor2_1
XFILLER_25_1275 vddd vssd sg13cmos5l_decap_4
XFILLER_21_1106 vddd vssd sg13cmos5l_decap_8
X_5189_ _5189_/Y _5189_/A _6106_/B _6113_/A _5189_/D vddd vssd sg13cmos5l_nand4_1
XFILLER_9_1494 vddd vssd sg13cmos5l_decap_8
X_4209_ _4209_/Y _4206_/Y _4207_/Y _4208_/Y vddd vssd sg13cmos5l_o21ai_1
XFILLER_29_768 vddd vssd sg13cmos5l_decap_8
Xwire60 wire60/X wire60/A vddd vssd sg13cmos5l_buf_4
XFILLER_25_963 vddd vssd sg13cmos5l_decap_8
XFILLER_19_1024 vddd vssd sg13cmos5l_decap_4
XFILLER_16_2602 vddd vssd sg13cmos5l_decap_4
XFILLER_19_1079 vddd vssd sg13cmos5l_decap_4
XFILLER_8_617 vddd vssd sg13cmos5l_decap_8
XFILLER_12_668 vddd vssd sg13cmos5l_decap_8
XFILLER_32_1235 vddd vssd sg13cmos5l_decap_8
XFILLER_22_63 vddd vssd sg13cmos5l_decap_8
XFILLER_10_1511 vddd vssd sg13cmos5l_decap_8
XFILLER_4_823 vddd vssd sg13cmos5l_decap_8
XFILLER_10_2289 vddd vssd sg13cmos5l_decap_8
XFILLER_3_388 vddd vssd sg13cmos5l_decap_4
XFILLER_23_1916 vddd vssd sg13cmos5l_decap_8
Xfanout191 _6715_/A _6695_/A vddd vssd sg13cmos5l_buf_1
Xfanout180 _6739_/A1 _7378_/Q vddd vssd sg13cmos5l_buf_1
XFILLER_5_2582 vddd vssd sg13cmos5l_decap_8
XFILLER_8_21 vddd vssd sg13cmos5l_decap_8
X_4560_ _4561_/B _4789_/A _4560_/B vddd vssd sg13cmos5l_nor2_1
XFILLER_15_1444 vddd vssd sg13cmos5l_decap_4
X_4491_ _4491_/X _4473_/A _4771_/B _4490_/Y vddd vssd sg13cmos5l_a21o_1
Xhold617 _7383_/D _4260_/X vddd vssd sg13cmos5l_dlygate4sd3_1
Xhold606 hold606/X _4280_/Y vddd vssd sg13cmos5l_dlygate4sd3_1
X_3511_ _6219_/A _3511_/A vddd vssd sg13cmos5l_inv_1
XFILLER_28_2539 vddd vssd sg13cmos5l_decap_8
X_6230_ _6232_/B _6233_/B _7229_/Q _6230_/C vddd vssd sg13cmos5l_nor3_1
Xhold639 _4302_/B _7370_/Q vddd vssd sg13cmos5l_dlygate4sd3_1
Xhold628 _7396_/D _5282_/Y vddd vssd sg13cmos5l_dlygate4sd3_1
XFILLER_28_1816 vddd vssd sg13cmos5l_decap_8
X_6161_ _6161_/Y _3904_/X _5222_/D _5222_/B vddd vssd sg13cmos5l_a21oi_1
X_5112_ _6048_/B _7271_/Q _7270_/Q _5264_/B vddd vssd sg13cmos5l_or3_1
XFILLER_26_2296 vddd vssd sg13cmos5l_decap_4
XFILLER_26_0 vddd vssd sg13cmos5l_decap_8
X_6092_ _6092_/Y _6156_/A _5172_/B _5168_/D vddd vssd sg13cmos5l_a21oi_1
Xhold1306 hold629/A _7373_/Q vddd vssd sg13cmos5l_dlygate4sd3_1
XFILLER_6_1601 vddd vssd sg13cmos5l_decap_8
Xhold1339 _6448_/A1 _5543_/A vddd vssd sg13cmos5l_dlygate4sd3_1
Xhold1328 _6723_/A1 _7059_/Q vddd vssd sg13cmos5l_dlygate4sd3_1
X_5043_ _5237_/B _7264_/Q _7265_/Q vddd vssd sg13cmos5l_nor2_1
Xhold1317 _6552_/A1 _6221_/B vddd vssd sg13cmos5l_dlygate4sd3_1
XFILLER_6_1689 vddd vssd sg13cmos5l_decap_8
XFILLER_4_1380 vddd vssd sg13cmos5l_decap_8
X_6994_ _6994_/Q _7016_/CLK _6994_/D _6941_/Y vddd vssd sg13cmos5l_dfrbpq_1
XFILLER_20_1183 vddd vssd sg13cmos5l_decap_8
X_5945_ _5945_/Y _5945_/A _5945_/B vddd vssd sg13cmos5l_nor2_1
XFILLER_0_1288 vddd vssd sg13cmos5l_decap_8
X_5876_ _5876_/X _5902_/A _7223_/Q vddd vssd sg13cmos5l_or2_1
XFILLER_16_1219 vddd vssd sg13cmos5l_decap_8
X_4827_ _4827_/Y _5285_/A _5999_/S vddd vssd sg13cmos5l_nor2_1
X_4758_ _4758_/Y _4758_/A _4758_/B vddd vssd sg13cmos5l_xnor2_1
XFILLER_11_2554 vddd vssd sg13cmos5l_decap_8
X_4689_ _4690_/B _4712_/A _4689_/B vddd vssd sg13cmos5l_nor2_1
X_3709_ _4156_/A _6315_/A _3908_/A vddd vssd sg13cmos5l_nor2_1
XFILLER_11_2598 vddd vssd sg13cmos5l_decap_8
X_6428_ _6428_/Y _6428_/A1 _6427_/B _6427_/Y vddd vssd sg13cmos5l_a21oi_1
XFILLER_27_2016 vddd vssd sg13cmos5l_decap_4
X_6359_ _6359_/X hold807/X _6328_/A _6359_/S vddd vssd sg13cmos5l_mux2_1
XFILLER_0_314 vddd vssd sg13cmos5l_decap_8
XFILLER_5_1188 vddd vssd sg13cmos5l_decap_8
XFILLER_32_719 vddd vssd sg13cmos5l_decap_8
XFILLER_12_421 vddd vssd sg13cmos5l_decap_8
XFILLER_13_922 vddd vssd sg13cmos5l_decap_8
XFILLER_32_1010 vddd vssd sg13cmos5l_decap_8
XFILLER_16_2476 vddd vssd sg13cmos5l_decap_8
XFILLER_32_1087 vddd vssd sg13cmos5l_decap_8
Xtiedowns\[76\] _6885_/A vddd vssd sg13cmos5l_antennanp
XFILLER_27_2572 vddd vssd sg13cmos5l_decap_8
XFILLER_23_2425 vddd vssd sg13cmos5l_decap_8
XFILLER_3_2508 vddd vssd sg13cmos5l_decap_8
XFILLER_23_708 vddd vssd sg13cmos5l_decap_4
X_3991_ _3991_/Y _7085_/Q _4073_/A _3990_/A _7093_/Q _4250_/A vddd vssd sg13cmos5l_a221oi_1
XFILLER_1_1597 vddd vssd sg13cmos5l_decap_4
X_5730_ _5730_/Y _5736_/C _5725_/Y _5733_/B _5739_/B _5729_/Y vddd vssd sg13cmos5l_a221oi_1
X_5661_ _5661_/Y _5683_/B _5682_/A vddd vssd sg13cmos5l_nand2_1
X_5592_ _5593_/C _5601_/B _5595_/B _5580_/Y vddd vssd sg13cmos5l_a21oi_1
X_4612_ _4624_/B _4614_/A _4612_/B vddd vssd sg13cmos5l_nand2b_1
X_4543_ _4543_/Y _4553_/B vddd vssd sg13cmos5l_inv_1
X_7331_ _7331_/Q _7348_/CLK _7331_/D _6844_/Y vddd vssd sg13cmos5l_dfrbpq_1
XFILLER_8_981 vddd vssd sg13cmos5l_decap_8
Xmax_cap122 _3788_/A _3931_/A vddd vssd sg13cmos5l_buf_2
X_7262_ _7262_/Q _7294_/CLK _7262_/D fanout392/X vddd vssd sg13cmos5l_dfrbpq_1
Xmax_cap111 _3876_/B _6361_/B vddd vssd sg13cmos5l_buf_4
X_6213_ _6213_/Y _6233_/B _7229_/Q _7230_/Q _6226_/B vddd vssd sg13cmos5l_nor4_1
X_4474_ _4474_/X _4474_/A _4474_/B vddd vssd sg13cmos5l_and2_1
XFILLER_28_1624 vddd vssd sg13cmos5l_decap_4
X_7193_ _7193_/Q _7199_/CLK _7193_/D fanout369/X vddd vssd sg13cmos5l_dfrbpq_1
XFILLER_6_2110 vddd vssd sg13cmos5l_decap_8
XFILLER_8_1718 vddd vssd sg13cmos5l_decap_8
X_6144_ _6144_/Y _6144_/A _6144_/B vddd vssd sg13cmos5l_nand2_1
Xhold1103 _3525_/A _7275_/Q vddd vssd sg13cmos5l_dlygate4sd3_1
Xhold1114 _6515_/A1 _5786_/C vddd vssd sg13cmos5l_dlygate4sd3_1
XFILLER_6_1431 vddd vssd sg13cmos5l_decap_8
X_6075_ _6075_/Y _3819_/Y _6073_/A _5132_/A vddd vssd sg13cmos5l_a21oi_1
Xhold1136 _3628_/A _7076_/Q vddd vssd sg13cmos5l_dlygate4sd3_1
Xhold1125 _7026_/D _6672_/X vddd vssd sg13cmos5l_dlygate4sd3_1
Xhold1147 _6678_/A0 _7029_/Q vddd vssd sg13cmos5l_dlygate4sd3_1
Xhold1158 _6644_/B1 _6643_/Y vddd vssd sg13cmos5l_dlygate4sd3_1
X_5026_ sram_idata[2] _6695_/A _5032_/B vddd vssd sg13cmos5l_and2_1
Xhold1169 _6716_/A1 _3619_/Y vddd vssd sg13cmos5l_dlygate4sd3_1
XFILLER_2_1317 vddd vssd sg13cmos5l_decap_4
XFILLER_2_1339 vddd vssd sg13cmos5l_decap_4
XFILLER_26_546 vddd vssd sg13cmos5l_decap_8
X_6977_ _6977_/Q _7013_/CLK _6977_/D _6924_/Y vddd vssd sg13cmos5l_dfrbpq_1
X_5928_ _5928_/Y _5928_/A1 _3594_/Y _5927_/Y vddd vssd sg13cmos5l_o21ai_1
X_5859_ _5859_/Y _5828_/A _5857_/Y _5858_/Y _5856_/Y _5831_/Y vddd vssd sg13cmos5l_a221oi_1
Xhold970 _6734_/A _7067_/Q vddd vssd sg13cmos5l_dlygate4sd3_1
Xhold981 _4416_/A _7345_/Q vddd vssd sg13cmos5l_dlygate4sd3_1
Xhold992 _7282_/D _6640_/X vddd vssd sg13cmos5l_dlygate4sd3_1
XFILLER_0_133 vddd vssd sg13cmos5l_decap_8
XFILLER_7_1217 vddd vssd sg13cmos5l_decap_8
XFILLER_28_51 vddd vssd sg13cmos5l_decap_8
XFILLER_2_2585 vddd vssd sg13cmos5l_decap_8
XFILLER_18_2516 vddd vssd sg13cmos5l_decap_8
XFILLER_9_767 vddd vssd sg13cmos5l_decap_4
XFILLER_12_2137 vddd vssd sg13cmos5l_decap_8
XFILLER_12_1469 vddd vssd sg13cmos5l_decap_8
XFILLER_5_44 vddd vssd sg13cmos5l_decap_8
X_4190_ _4190_/X _4187_/X _4188_/Y _4189_/Y vddd vssd sg13cmos5l_a21o_1
XFILLER_7_2452 vddd vssd sg13cmos5l_decap_8
XFILLER_3_1637 vddd vssd sg13cmos5l_decap_8
Xclkbuf_4_5__f_clk_regs _7341_/CLK clkbuf_3_2_0_clk_regs/X vddd vssd sg13cmos5l_buf_8
X_6831_ _6831_/Y _6908_/A _6906_/B_N vddd vssd sg13cmos5l_nor2b_1
X_3974_ _3974_/Y _3623_/Y _4085_/B _4231_/C1 vddd vssd sg13cmos5l_a21oi_1
XFILLER_23_549 vddd vssd sg13cmos5l_decap_8
X_6762_ _6762_/Y _6762_/A _6767_/S vddd vssd sg13cmos5l_nor2_1
Xoutbuffers\[3\] analog_bus_ena[1] _7031_/Q vddd vssd sg13cmos5l_buf_16
X_6693_ _7039_/D _6693_/A1 _6698_/S _6693_/B1 vddd vssd sg13cmos5l_a21oi_1
X_5713_ _5713_/Y _5828_/A _5711_/Y _5712_/Y _5710_/Y _5685_/Y vddd vssd sg13cmos5l_a221oi_1
X_5644_ _5646_/C _5398_/A _7189_/Q _5643_/X _7188_/Q vddd vssd sg13cmos5l_a22oi_1
XFILLER_15_1082 vddd vssd sg13cmos5l_decap_8
Xclkbuf_leaf_10_SCK_regs _7066_/CLK clkload3/A vddd vssd sg13cmos5l_buf_8
X_5575_ _5595_/A _7180_/Q _7181_/Q vddd vssd sg13cmos5l_nor2_1
X_7314_ _7314_/Q _7393_/CLK _7314_/D _6827_/Y vddd vssd sg13cmos5l_dfrbpq_1
X_4526_ _4530_/C _4471_/B _4526_/B vddd vssd sg13cmos5l_nand2b_1
X_4457_ _4457_/Y _4819_/A _4457_/B vddd vssd sg13cmos5l_nand2_1
X_7245_ _7245_/Q _7252_/CLK _7245_/D fanout391/X vddd vssd sg13cmos5l_dfrbpq_1
X_7176_ _7176_/Q _7180_/CLK _7176_/D fanout365/X vddd vssd sg13cmos5l_dfrbpq_1
X_4388_ _4390_/C _4388_/A _7128_/Q vddd vssd sg13cmos5l_xnor2_1
X_6127_ _6127_/Y _6041_/A _6128_/A2 _5241_/A vddd vssd sg13cmos5l_a21oi_1
X_6058_ _6058_/Y _6144_/A _5114_/X _5118_/B _5126_/B _6057_/Y vddd vssd sg13cmos5l_a221oi_1
XFILLER_27_822 vddd vssd sg13cmos5l_decap_8
X_5009_ _5213_/A _7244_/Q _7245_/Q vddd vssd sg13cmos5l_nand2_1
XFILLER_2_1158 vddd vssd sg13cmos5l_decap_4
XFILLER_22_571 vddd vssd sg13cmos5l_decap_8
XFILLER_17_2560 vddd vssd sg13cmos5l_decap_8
XFILLER_14_42 vddd vssd sg13cmos5l_decap_8
XFILLER_10_722 vddd vssd sg13cmos5l_decap_8
XFILLER_30_63 vddd vssd sg13cmos5l_decap_8
Xtiedowns\[39\] dbus_in_right[7] vddd vssd sg13cmos5l_antennanp
XFILLER_24_2520 vddd vssd sg13cmos5l_decap_8
XFILLER_4_2603 vddd vssd sg13cmos5l_decap_4
XFILLER_7_1047 vddd vssd sg13cmos5l_decap_8
XFILLER_24_2597 vddd vssd sg13cmos5l_decap_8
XFILLER_20_1716 vddd vssd sg13cmos5l_decap_8
XFILLER_17_376 vddd vssd sg13cmos5l_decap_8
XFILLER_32_357 vddd vssd sg13cmos5l_decap_8
XFILLER_13_571 vddd vssd sg13cmos5l_decap_8
XFILLER_31_2524 vddd vssd sg13cmos5l_decap_8
X_3690_ _3690_/Y _4002_/B _3728_/B vddd vssd sg13cmos5l_nor2b_1
X_5360_ _5360_/Y _5363_/B _5358_/Y _5359_/Y vddd vssd sg13cmos5l_o21ai_1
XFILLER_29_2464 vddd vssd sg13cmos5l_decap_8
XFILLER_5_792 vddd vssd sg13cmos5l_decap_8
X_5291_ _5291_/Y _4323_/B _4289_/B _4288_/A _4303_/B vddd vssd sg13cmos5l_a22oi_1
XFILLER_9_2514 vddd vssd sg13cmos5l_decap_8
X_4311_ _4311_/Y _4264_/A _4308_/B _4323_/B vddd vssd sg13cmos5l_a21oi_1
X_7030_ _7030_/Q _7191_/CLK _7030_/D fanout375/X vddd vssd sg13cmos5l_dfrbpq_1
X_4242_ _4242_/Y _3521_/Y _4242_/A2 _4241_/Y vddd vssd sg13cmos5l_a21oi_1
XFILLER_25_1605 vddd vssd sg13cmos5l_decap_4
XFILLER_25_1649 vddd vssd sg13cmos5l_decap_8
X_4173_ _4173_/Y _4173_/A _4173_/B vddd vssd sg13cmos5l_nand2_1
XFILLER_7_2293 vddd vssd sg13cmos5l_decap_4
XFILLER_3_2157 vddd vssd sg13cmos5l_decap_8
Xoutbuffers\[22\] voltgen_source[3] _7070_/Q vddd vssd sg13cmos5l_buf_16
XFILLER_23_324 vddd vssd sg13cmos5l_decap_8
X_6814_ _6814_/Y _6838_/A _6834_/B_N vddd vssd sg13cmos5l_nor2b_1
X_6745_ _6745_/X hold857/X _6324_/A _6745_/S vddd vssd sg13cmos5l_mux2_1
X_3957_ _6406_/A _6315_/B _3957_/B vddd vssd sg13cmos5l_nor2_1
XFILLER_32_880 vddd vssd sg13cmos5l_decap_8
Xclkbuf_0_clk_regs clkbuf_0_clk_regs/X clkbuf_regs_0_clk/X vddd vssd sg13cmos5l_buf_8
X_6676_ _6676_/Y _6676_/A _6678_/S vddd vssd sg13cmos5l_nand2_1
X_3888_ _3898_/A _5148_/A _6589_/A _3885_/Y vddd vssd sg13cmos5l_o21ai_1
XFILLER_30_1322 vddd vssd sg13cmos5l_decap_8
X_5627_ _5627_/Y _7186_/Q _7187_/Q _5627_/C vddd vssd sg13cmos5l_nor3_1
XFILLER_10_1907 vddd vssd sg13cmos5l_decap_8
X_5558_ _5558_/Y _3546_/Y _5552_/B _5557_/Y _3569_/Y _5556_/Y vddd vssd sg13cmos5l_a221oi_1
X_4509_ _4510_/B _4509_/A _4509_/B vddd vssd sg13cmos5l_xnor2_1
XFILLER_8_2002 vddd vssd sg13cmos5l_decap_8
X_7228_ _7228_/Q _7233_/CLK _7228_/D fanout376/X vddd vssd sg13cmos5l_dfrbpq_1
Xwire1 wire1/X wire2/X vddd vssd sg13cmos5l_buf_4
X_5489_ _5489_/X _5507_/A _5513_/A vddd vssd sg13cmos5l_and2_1
X_6964__473 _7017_/CLK _7364_/CLK vddd vssd sg13cmos5l_inv_1
XFILLER_8_1323 vddd vssd sg13cmos5l_decap_4
XFILLER_8_2046 vddd vssd sg13cmos5l_decap_8
X_7159_ _7159_/Q _7171_/CLK _7159_/D fanout364/X vddd vssd sg13cmos5l_dfrbpq_1
XFILLER_8_1356 vddd vssd sg13cmos5l_decap_8
XFILLER_24_1159 vddd vssd sg13cmos5l_decap_8
XFILLER_26_140 vddd vssd sg13cmos5l_decap_8
XFILLER_25_30 vddd vssd sg13cmos5l_decap_8
XFILLER_10_552 vddd vssd sg13cmos5l_decap_8
XFILLER_10_596 vddd vssd sg13cmos5l_decap_8
XFILLER_29_1037 vddd vssd sg13cmos5l_decap_8
XFILLER_2_23 vddd vssd sg13cmos5l_decap_8
XFILLER_24_2394 vddd vssd sg13cmos5l_decap_8
XFILLER_4_1721 vddd vssd sg13cmos5l_decap_8
XFILLER_20_1535 vddd vssd sg13cmos5l_decap_8
XFILLER_18_641 vddd vssd sg13cmos5l_decap_8
XFILLER_0_1618 vddd vssd sg13cmos5l_decap_8
XFILLER_17_173 vddd vssd sg13cmos5l_decap_8
X_4860_ _4860_/Y _4861_/B _4815_/B vddd vssd sg13cmos5l_nor2b_1
XFILLER_32_154 vddd vssd sg13cmos5l_decap_8
Xoutbuffers\[112\] dbus_out[15] _5742_/Y vddd vssd sg13cmos5l_buf_16
X_3811_ _3811_/Y _3813_/A _4258_/B _7017_/D vddd vssd sg13cmos5l_o21ai_1
XANTENNA_17 porb vddd vssd sg13cmos5l_antennanp
X_4791_ _4791_/Y _4789_/Y _4790_/Y _4774_/Y vddd vssd sg13cmos5l_o21ai_1
XANTENNA_28 wire81/X vddd vssd sg13cmos5l_antennanp
XANTENNA_39 _7338_/CLK vddd vssd sg13cmos5l_antennanp
X_6530_ _6530_/Y _6544_/A _6532_/S vddd vssd sg13cmos5l_nor2_1
X_3742_ _3742_/Y _3735_/Y _3736_/Y _3741_/Y vddd vssd sg13cmos5l_o21ai_1
X_6461_ _7180_/D hold873/X _6465_/B _6460_/Y vddd vssd sg13cmos5l_a21oi_1
X_3673_ _3963_/A _3673_/A _3708_/A vddd vssd sg13cmos5l_nand2_1
XFILLER_31_2398 vddd vssd sg13cmos5l_decap_8
X_6392_ _7144_/D _6735_/A1 _6397_/B hold889/X vddd vssd sg13cmos5l_o21ai_1
X_5412_ _5412_/Y _5410_/Y _5411_/Y _5416_/C vddd vssd sg13cmos5l_o21ai_1
X_5343_ _5343_/Y _5626_/A _5338_/Y _5342_/Y vddd vssd sg13cmos5l_a21oi_1
X_5274_ _5274_/Y _5274_/A _5274_/B vddd vssd sg13cmos5l_nor2_1
X_7013_ _7013_/Q _7013_/CLK _7013_/D _6960_/Y vddd vssd sg13cmos5l_dfrbpq_1
XFILLER_9_1676 vddd vssd sg13cmos5l_decap_4
X_4225_ _4225_/Y _5355_/A _6399_/A _4053_/B vddd vssd sg13cmos5l_a21oi_1
XFILLER_29_939 vddd vssd sg13cmos5l_decap_8
X_4156_ _4156_/Y _4156_/A wire50/X vddd vssd sg13cmos5l_nor2_1
X_4087_ _4087_/Y _7019_/Q _6660_/A _6673_/A _4086_/Y vddd vssd sg13cmos5l_a22oi_1
XFILLER_23_154 vddd vssd sg13cmos5l_decap_8
XFILLER_12_828 vddd vssd sg13cmos5l_decap_8
X_4989_ _6262_/B _6150_/B _5268_/A vddd vssd sg13cmos5l_nand2b_1
X_6728_ _6728_/X _6393_/A _6728_/A1 _6732_/S vddd vssd sg13cmos5l_mux2_1
XFILLER_14_2541 vddd vssd sg13cmos5l_decap_8
X_6659_ _6659_/Y _6837_/A _6877_/B_N vddd vssd sg13cmos5l_nor2b_1
XFILLER_11_21 vddd vssd sg13cmos5l_decap_8
XFILLER_30_1185 vddd vssd sg13cmos5l_decap_4
Xfanout340 fanout340/X _3458_/Y vddd vssd sg13cmos5l_buf_1
Xfanout384 fanout384/X fanout387/X vddd vssd sg13cmos5l_buf_1
Xfanout362 fanout362/X fanout363/X vddd vssd sg13cmos5l_buf_1
Xfanout373 fanout373/X fanout378/X vddd vssd sg13cmos5l_buf_1
Xfanout351 _6838_/B_N fanout379/X vddd vssd sg13cmos5l_buf_1
XFILLER_21_2512 vddd vssd sg13cmos5l_decap_8
XFILLER_4_1017 vddd vssd sg13cmos5l_decap_4
Xfanout395 fanout395/X fanout396/X vddd vssd sg13cmos5l_buf_1
XFILLER_21_2589 vddd vssd sg13cmos5l_decap_8
XFILLER_21_1844 vddd vssd sg13cmos5l_decap_8
XFILLER_15_644 vddd vssd sg13cmos5l_decap_8
XFILLER_19_2485 vddd vssd sg13cmos5l_decap_8
XFILLER_7_810 vddd vssd sg13cmos5l_decap_8
XFILLER_13_1350 vddd vssd sg13cmos5l_decap_8
XFILLER_26_2434 vddd vssd sg13cmos5l_decap_8
XFILLER_26_1755 vddd vssd sg13cmos5l_decap_8
X_4010_ _4011_/C _7266_/Q _4175_/B _3875_/Y _7262_/Q _3879_/Y vddd vssd sg13cmos5l_a221oi_1
XFILLER_20_2000 vddd vssd sg13cmos5l_decap_4
XFILLER_24_2180 vddd vssd sg13cmos5l_decap_4
XFILLER_4_1551 vddd vssd sg13cmos5l_decap_4
XFILLER_4_2296 vddd vssd sg13cmos5l_decap_8
XFILLER_20_2099 vddd vssd sg13cmos5l_decap_8
X_5961_ _5962_/B _5961_/A _5961_/B vddd vssd sg13cmos5l_nor2_1
XFILLER_4_1595 vddd vssd sg13cmos5l_decap_4
X_4912_ _4912_/Y _4914_/A sram_odata[4] _4920_/C vddd vssd sg13cmos5l_nand3_1
X_5892_ _5892_/Y _5910_/B _5910_/C _7226_/Q _5908_/A vddd vssd sg13cmos5l_nor4_1
XFILLER_21_636 vddd vssd sg13cmos5l_decap_8
X_4843_ _4843_/Y _4837_/B _4841_/B _4856_/A2 sram_odata[5] vddd vssd sg13cmos5l_a22oi_1
X_4774_ _4774_/Y _4773_/Y _4774_/B vddd vssd sg13cmos5l_nand2b_1
XFILLER_14_1103 vddd vssd sg13cmos5l_decap_4
X_6513_ _7209_/D _6520_/A _6513_/A1 _6516_/S vddd vssd sg13cmos5l_mux2_1
X_3725_ _6304_/A _3842_/B _3961_/A vddd vssd sg13cmos5l_nand2_1
X_6444_ _6444_/Y _6444_/A _6449_/S vddd vssd sg13cmos5l_nand2_1
X_3656_ _3656_/Y _7369_/Q _7398_/Q vddd vssd sg13cmos5l_nand2_1
X_6375_ _6375_/Y _5030_/A _6376_/B hold797/X vddd vssd sg13cmos5l_o21ai_1
X_3587_ _5841_/B _3587_/A vddd vssd sg13cmos5l_inv_1
X_5326_ _5327_/B _3544_/Y _5339_/D _5345_/A _3545_/Y _5339_/C vddd vssd sg13cmos5l_a221oi_1
X_5257_ _6207_/A _5269_/A _5257_/B vddd vssd sg13cmos5l_nor2_1
XFILLER_25_1221 vddd vssd sg13cmos5l_decap_4
XFILLER_9_1473 vddd vssd sg13cmos5l_decap_8
X_4208_ _4208_/Y _7200_/Q _4123_/A _6489_/A vddd vssd sg13cmos5l_a21oi_1
X_5188_ _5189_/D _7289_/Q _5188_/B _5188_/C _5188_/D vddd vssd sg13cmos5l_nor4_1
X_4139_ _4139_/Y _5393_/B _4139_/B vddd vssd sg13cmos5l_nor2_1
XFILLER_25_920 vddd vssd sg13cmos5l_decap_8
XFILLER_25_942 vddd vssd sg13cmos5l_decap_8
Xwire61 wire61/X wire61/A vddd vssd sg13cmos5l_buf_8
Xwire50 wire50/X wire50/A vddd vssd sg13cmos5l_buf_4
XFILLER_19_1003 vddd vssd sg13cmos5l_decap_8
XFILLER_24_474 vddd vssd sg13cmos5l_decap_8
XFILLER_8_629 vddd vssd sg13cmos5l_decap_4
XFILLER_32_1214 vddd vssd sg13cmos5l_decap_8
XFILLER_22_42 vddd vssd sg13cmos5l_decap_8
XFILLER_10_2213 vddd vssd sg13cmos5l_decap_8
XFILLER_10_1567 vddd vssd sg13cmos5l_decap_8
Xtiedowns\[21\] dbus_in_left[1] vddd vssd sg13cmos5l_antennanp
Xfanout181 _6324_/A _7378_/Q vddd vssd sg13cmos5l_buf_1
XFILLER_19_202 vddd vssd sg13cmos5l_decap_8
Xfanout192 _6695_/A fanout200/X vddd vssd sg13cmos5l_buf_1
XFILLER_5_2561 vddd vssd sg13cmos5l_decap_8
Xfanout170 hold1227/A hold1226/X vddd vssd sg13cmos5l_buf_1
XFILLER_21_1630 vddd vssd sg13cmos5l_decap_8
XFILLER_15_1423 vddd vssd sg13cmos5l_decap_8
XFILLER_32_2482 vddd vssd sg13cmos5l_decap_8
XFILLER_8_77 vddd vssd sg13cmos5l_decap_8
XFILLER_11_691 vddd vssd sg13cmos5l_decap_8
X_3510_ _3510_/Y _3510_/A vddd vssd sg13cmos5l_inv_1
X_4490_ _4490_/Y _4490_/A _4490_/B _4681_/A vddd vssd sg13cmos5l_nor3_1
Xhold607 _7371_/D _4281_/Y vddd vssd sg13cmos5l_dlygate4sd3_1
Xhold618 _4892_/B _7392_/Q vddd vssd sg13cmos5l_dlygate4sd3_1
XFILLER_28_2518 vddd vssd sg13cmos5l_decap_8
Xhold629 _4970_/A hold629/A vddd vssd sg13cmos5l_dlygate4sd3_1
X_6160_ _6160_/X _3819_/Y _5225_/C _5222_/D vddd vssd sg13cmos5l_a21o_1
X_5111_ _5264_/B _7268_/Q _7269_/Q vddd vssd sg13cmos5l_nand2b_1
X_6091_ _6091_/Y _6088_/Y _6089_/X _6090_/Y vddd vssd sg13cmos5l_o21ai_1
Xhold1307 _7397_/D _3639_/X vddd vssd sg13cmos5l_dlygate4sd3_1
Xhold1329 _7059_/D _6723_/X vddd vssd sg13cmos5l_dlygate4sd3_1
Xhold1318 _6738_/A0 _7070_/Q vddd vssd sg13cmos5l_dlygate4sd3_1
X_5042_ _5058_/C _7256_/Q _7257_/Q _7259_/Q _7258_/Q vddd vssd sg13cmos5l_nor4_1
XFILLER_6_1657 vddd vssd sg13cmos5l_decap_8
XFILLER_22_1449 vddd vssd sg13cmos5l_decap_8
XFILLER_19_0 vddd vssd sg13cmos5l_decap_8
Xclkbuf_leaf_35_SCK_regs _7218_/CLK clkload2/A vddd vssd sg13cmos5l_buf_8
XFILLER_26_739 vddd vssd sg13cmos5l_decap_8
XFILLER_26_706 vddd vssd sg13cmos5l_decap_8
XFILLER_25_205 vddd vssd sg13cmos5l_decap_8
X_6993_ _6993_/Q _7012_/CLK _6993_/D _6940_/Y vddd vssd sg13cmos5l_dfrbpq_1
X_5944_ _5949_/C _5945_/A _5945_/B vddd vssd sg13cmos5l_and2_1
X_5875_ _5879_/B _5887_/C _5880_/C vddd vssd sg13cmos5l_nor2_1
X_4826_ _4826_/Y _4826_/A _5999_/S vddd vssd sg13cmos5l_nor2_1
Xtiedowns\[5\] sram_odata[5] vddd vssd sg13cmos5l_antennanp
XFILLER_18_1091 vddd vssd sg13cmos5l_decap_8
X_4757_ _4758_/B _4776_/A _4757_/B vddd vssd sg13cmos5l_nor2_1
XFILLER_11_2533 vddd vssd sg13cmos5l_decap_8
X_4688_ _4688_/Y _4755_/A _4666_/Y _4430_/Y vddd vssd sg13cmos5l_a21oi_1
X_3708_ _3951_/A _3708_/A _3738_/B vddd vssd sg13cmos5l_nand2_1
XFILLER_11_2577 vddd vssd sg13cmos5l_decap_8
X_3639_ _3639_/X _4308_/B _4288_/A _4308_/A vddd vssd sg13cmos5l_a21o_1
X_6427_ _6427_/Y _6465_/A _6427_/B vddd vssd sg13cmos5l_nor2_1
X_6358_ _7127_/D hold760/X _6359_/S _6357_/Y vddd vssd sg13cmos5l_o21ai_1
XFILLER_11_1887 vddd vssd sg13cmos5l_decap_8
X_5309_ _5309_/Y _5533_/A _5304_/B _5308_/X vddd vssd sg13cmos5l_o21ai_1
X_6289_ _6290_/B _7072_/Q _7073_/Q vddd vssd sg13cmos5l_nand2_1
XFILLER_25_1062 vddd vssd sg13cmos5l_decap_4
XFILLER_5_1167 vddd vssd sg13cmos5l_decap_8
XFILLER_17_42 vddd vssd sg13cmos5l_decap_8
XFILLER_25_750 vddd vssd sg13cmos5l_decap_8
XFILLER_17_75 vddd vssd sg13cmos5l_decap_8
XFILLER_31_219 vddd vssd sg13cmos5l_decap_8
XFILLER_24_260 vddd vssd sg13cmos5l_decap_4
XFILLER_16_2455 vddd vssd sg13cmos5l_decap_8
XFILLER_12_455 vddd vssd sg13cmos5l_decap_8
XFILLER_16_1743 vddd vssd sg13cmos5l_decap_8
XFILLER_32_1066 vddd vssd sg13cmos5l_decap_8
Xtiedowns\[69\] mask_rev_in[25] vddd vssd sg13cmos5l_antennanp
XFILLER_4_621 vddd vssd sg13cmos5l_decap_8
XFILLER_10_2065 vddd vssd sg13cmos5l_decap_8
XFILLER_10_2098 vddd vssd sg13cmos5l_decap_8
XFILLER_27_2551 vddd vssd sg13cmos5l_decap_8
XFILLER_4_687 vddd vssd sg13cmos5l_decap_8
XFILLER_7_2601 vddd vssd sg13cmos5l_decap_4
XFILLER_23_2404 vddd vssd sg13cmos5l_decap_8
XFILLER_0_871 vddd vssd sg13cmos5l_decap_8
XFILLER_12_7 vddd vssd sg13cmos5l_decap_8
Xclkbuf_4_4__f_clk_regs _7338_/CLK clkbuf_3_2_0_clk_regs/X vddd vssd sg13cmos5l_buf_8
XFILLER_21_1482 vddd vssd sg13cmos5l_decap_8
X_3990_ _3990_/X _3990_/A _3990_/B _3990_/C _3990_/D vddd vssd sg13cmos5l_or4_1
XFILLER_16_772 vddd vssd sg13cmos5l_decap_8
XFILLER_15_260 vddd vssd sg13cmos5l_decap_8
XFILLER_17_1518 vddd vssd sg13cmos5l_decap_8
X_5660_ _5660_/Y _5753_/A _5659_/Y _7195_/Q vddd vssd sg13cmos5l_o21ai_1
X_4611_ _4611_/X _4592_/A _4811_/B _4610_/Y vddd vssd sg13cmos5l_a21o_1
X_5591_ _5593_/B _5599_/C _5591_/B vddd vssd sg13cmos5l_nand2b_1
XFILLER_15_1242 vddd vssd sg13cmos5l_decap_8
X_4542_ _4553_/B _4545_/A _4542_/B vddd vssd sg13cmos5l_nor2_1
X_7330_ _7330_/Q _7350_/CLK _7330_/D _6843_/Y vddd vssd sg13cmos5l_dfrbpq_1
XFILLER_11_1106 vddd vssd sg13cmos5l_decap_4
X_7261_ _7261_/Q _7294_/CLK _7261_/D fanout392/X vddd vssd sg13cmos5l_dfrbpq_1
X_4473_ _4474_/B _4473_/A _4530_/A _4530_/B vddd vssd sg13cmos5l_or3_1
Xmax_cap112 _3911_/A _3954_/A vddd vssd sg13cmos5l_buf_8
XFILLER_28_1603 vddd vssd sg13cmos5l_decap_8
X_6212_ _6234_/A _7230_/Q _6226_/B vddd vssd sg13cmos5l_nor2_1
X_7192_ _7192_/Q _7199_/CLK _7192_/D _6822_/B_N vddd vssd sg13cmos5l_dfrbpq_1
X_6143_ _6143_/Y _4023_/X _5206_/C _6144_/B vddd vssd sg13cmos5l_a21oi_1
Xoutbuffers\[52\] bandgap_trim[13] _6299_/Y vddd vssd sg13cmos5l_buf_16
Xhold1104 _6628_/A1 _5004_/A vddd vssd sg13cmos5l_dlygate4sd3_1
X_6074_ _6074_/Y _6138_/A _5137_/B _6073_/Y vddd vssd sg13cmos5l_o21ai_1
Xhold1115 _7210_/D _6515_/Y vddd vssd sg13cmos5l_dlygate4sd3_1
Xhold1137 _6747_/A1 _3628_/Y vddd vssd sg13cmos5l_dlygate4sd3_1
Xhold1148 _7029_/D _6678_/X vddd vssd sg13cmos5l_dlygate4sd3_1
X_5025_ sram_idata[1] _6686_/A _5032_/B vddd vssd sg13cmos5l_and2_1
Xhold1126 _3560_/A _7159_/Q vddd vssd sg13cmos5l_dlygate4sd3_1
Xhold1159 _3524_/A _7269_/Q vddd vssd sg13cmos5l_dlygate4sd3_1
X_6976_ _6976_/Q _7003_/CLK _6976_/D _6923_/Y vddd vssd sg13cmos5l_dfrbpq_1
X_5927_ _5927_/Y _5924_/Y _5925_/Y _5926_/Y vddd vssd sg13cmos5l_o21ai_1
XFILLER_0_1064 vddd vssd sg13cmos5l_decap_8
XFILLER_22_786 vddd vssd sg13cmos5l_decap_8
X_5858_ _5858_/Y _5679_/A _5854_/Y _5857_/Y vddd vssd sg13cmos5l_a21oi_1
XFILLER_10_904 vddd vssd sg13cmos5l_decap_4
X_4809_ _4809_/Y _5329_/A _4811_/B vddd vssd sg13cmos5l_nand2_1
X_5789_ _5789_/Y _5789_/A _5789_/B vddd vssd sg13cmos5l_nor2_1
XFILLER_11_2341 vddd vssd sg13cmos5l_decap_8
Xhold971 hold971/X _6734_/Y vddd vssd sg13cmos5l_dlygate4sd3_1
Xhold982 _4417_/B _4416_/X vddd vssd sg13cmos5l_dlygate4sd3_1
XFILLER_0_112 vddd vssd sg13cmos5l_decap_8
Xhold960 _4404_/A _3489_/Y vddd vssd sg13cmos5l_dlygate4sd3_1
Xhold993 _6444_/A _7172_/Q vddd vssd sg13cmos5l_dlygate4sd3_1
XFILLER_7_1229 vddd vssd sg13cmos5l_decap_8
XFILLER_28_30 vddd vssd sg13cmos5l_decap_8
XFILLER_2_2564 vddd vssd sg13cmos5l_decap_8
XFILLER_2_1863 vddd vssd sg13cmos5l_decap_4
XFILLER_32_528 vddd vssd sg13cmos5l_decap_8
XFILLER_12_263 vddd vssd sg13cmos5l_decap_8
XFILLER_8_234 vddd vssd sg13cmos5l_decap_4
XFILLER_9_746 vddd vssd sg13cmos5l_decap_8
XFILLER_16_1595 vddd vssd sg13cmos5l_decap_8
XFILLER_12_1437 vddd vssd sg13cmos5l_decap_8
XFILLER_5_23 vddd vssd sg13cmos5l_decap_8
XFILLER_5_952 vddd vssd sg13cmos5l_decap_8
XFILLER_4_495 vddd vssd sg13cmos5l_decap_8
XFILLER_10_1183 vddd vssd sg13cmos5l_decap_8
XFILLER_7_1730 vddd vssd sg13cmos5l_decap_8
XFILLER_27_1680 vddd vssd sg13cmos5l_decap_8
XFILLER_23_2256 vddd vssd sg13cmos5l_decap_8
XFILLER_7_1763 vddd vssd sg13cmos5l_decap_8
XFILLER_3_1627 vddd vssd sg13cmos5l_decap_4
XFILLER_23_1599 vddd vssd sg13cmos5l_decap_4
X_6830_ _6830_/Y _6961_/A _6961_/B_N vddd vssd sg13cmos5l_nor2b_1
XFILLER_23_528 vddd vssd sg13cmos5l_decap_8
X_6761_ _7082_/D _6564_/A _6767_/S hold633/X vddd vssd sg13cmos5l_a21oi_1
X_3973_ _3973_/Y _3970_/Y _3971_/Y _3972_/Y vddd vssd sg13cmos5l_o21ai_1
X_5712_ _5712_/Y _5679_/A _5708_/Y _5711_/Y vddd vssd sg13cmos5l_a21oi_1
X_6692_ _6692_/Y _6692_/A _6698_/S vddd vssd sg13cmos5l_nor2_1
X_5643_ _5643_/X _5828_/A _7189_/Q vddd vssd sg13cmos5l_or2_1
X_5574_ _5574_/Y _5574_/A _5574_/B vddd vssd sg13cmos5l_nand2_1
X_4525_ _4525_/Y _4521_/Y _4524_/Y _4805_/B1 vddd vssd sg13cmos5l_o21ai_1
X_7313_ _7313_/Q _7338_/CLK _7313_/D _6826_/Y vddd vssd sg13cmos5l_dfrbpq_1
X_4456_ _4457_/B _4473_/A _4456_/B vddd vssd sg13cmos5l_xor2_1
X_7244_ _7244_/Q _7285_/CLK _7244_/D fanout391/X vddd vssd sg13cmos5l_dfrbpq_1
XFILLER_28_1433 vddd vssd sg13cmos5l_decap_8
X_7175_ _7175_/Q _7187_/CLK _7175_/D fanout366/X vddd vssd sg13cmos5l_dfrbpq_1
X_4387_ _4392_/C _4387_/A _4387_/B _4387_/C _4387_/D vddd vssd sg13cmos5l_nand4_1
XFILLER_28_1488 vddd vssd sg13cmos5l_decap_8
X_6126_ _6126_/X _6124_/Y _6125_/Y _6105_/Y vddd vssd sg13cmos5l_a21o_1
X_6057_ _6057_/Y _6057_/A _6057_/B vddd vssd sg13cmos5l_nor2_1
Xclkbuf_3_0_0_clk_regs clkbuf_3_0_0_clk_regs/X clkbuf_0_clk_regs/X vddd vssd sg13cmos5l_buf_8
X_5008_ _5022_/B _5008_/A _5008_/B _6262_/C vddd vssd sg13cmos5l_nor3_1
X_6959_ _6959_/Y _6959_/A _6959_/B_N vddd vssd sg13cmos5l_nor2b_1
XFILLER_22_550 vddd vssd sg13cmos5l_decap_8
XFILLER_14_21 vddd vssd sg13cmos5l_decap_8
XFILLER_13_1702 vddd vssd sg13cmos5l_decap_8
XFILLER_13_2469 vddd vssd sg13cmos5l_decap_8
XFILLER_13_1746 vddd vssd sg13cmos5l_decap_8
XFILLER_10_767 vddd vssd sg13cmos5l_decap_8
XFILLER_30_42 vddd vssd sg13cmos5l_decap_8
XFILLER_2_911 vddd vssd sg13cmos5l_decap_8
Xhold790 hold790/X _7126_/Q vddd vssd sg13cmos5l_dlygate4sd3_1
XFILLER_1_432 vddd vssd sg13cmos5l_decap_8
XFILLER_2_988 vddd vssd sg13cmos5l_decap_8
XFILLER_24_2576 vddd vssd sg13cmos5l_decap_8
XFILLER_4_1947 vddd vssd sg13cmos5l_decap_8
XFILLER_29_193 vddd vssd sg13cmos5l_decap_8
Xhold1490 _6740_/A0 _7072_/Q vddd vssd sg13cmos5l_dlygate4sd3_1
XFILLER_32_336 vddd vssd sg13cmos5l_decap_8
XFILLER_31_2503 vddd vssd sg13cmos5l_decap_8
XFILLER_9_510 vddd vssd sg13cmos5l_decap_4
XFILLER_9_532 vddd vssd sg13cmos5l_decap_4
XFILLER_9_587 vddd vssd sg13cmos5l_decap_8
XFILLER_29_2443 vddd vssd sg13cmos5l_decap_8
X_4310_ _5996_/B _4310_/A _4323_/B vddd vssd sg13cmos5l_nor2_1
X_5290_ _7392_/D _5290_/A vddd vssd sg13cmos5l_inv_1
X_4241_ _4241_/Y wire12/X _4241_/B vddd vssd sg13cmos5l_nor2_1
XFILLER_25_1617 vddd vssd sg13cmos5l_decap_4
XFILLER_23_2053 vddd vssd sg13cmos5l_decap_8
X_4172_ _4172_/Y hold616/X _4258_/B _7017_/D vddd vssd sg13cmos5l_o21ai_1
XFILLER_7_2272 vddd vssd sg13cmos5l_decap_8
XFILLER_3_2125 vddd vssd sg13cmos5l_decap_8
XFILLER_27_119 vddd vssd sg13cmos5l_decap_8
XFILLER_23_1352 vddd vssd sg13cmos5l_decap_8
XFILLER_7_1593 vddd vssd sg13cmos5l_decap_8
Xoutbuffers\[15\] proj_sel[2] _7020_/Q vddd vssd sg13cmos5l_buf_16
XFILLER_24_859 vddd vssd sg13cmos5l_decap_8
X_6813_ _6813_/Y _6838_/A _6834_/B_N vddd vssd sg13cmos5l_nor2b_1
X_6744_ _7074_/D _6744_/A1 _6745_/S _6743_/Y vddd vssd sg13cmos5l_o21ai_1
X_3956_ _3956_/Y _5444_/B _6420_/A _6412_/A vddd vssd sg13cmos5l_a21oi_1
X_6675_ _6675_/Y _6675_/A1 _6678_/S hold977/X vddd vssd sg13cmos5l_a21oi_1
X_5626_ _5626_/X _5626_/A _5626_/B vddd vssd sg13cmos5l_and2_1
XFILLER_17_1178 vddd vssd sg13cmos5l_decap_8
X_3887_ _6583_/A _3896_/A _3887_/B vddd vssd sg13cmos5l_nand2_1
X_5557_ _5557_/Y _5753_/A _5557_/B vddd vssd sg13cmos5l_nor2_1
XFILLER_12_2491 vddd vssd sg13cmos5l_decap_8
X_4508_ _4508_/Y _4616_/A _4495_/Y _4507_/Y vddd vssd sg13cmos5l_o21ai_1
X_5488_ _5513_/A _5511_/A _7171_/Q vddd vssd sg13cmos5l_nor2_1
X_4439_ _4439_/Y _4489_/A _4818_/A _4461_/A vddd vssd sg13cmos5l_nor3_1
Xwire2 wire2/X wire2/A vddd vssd sg13cmos5l_buf_4
X_7227_ _7227_/Q _7295_/CLK _7227_/D fanout377/X vddd vssd sg13cmos5l_dfrbpq_1
XFILLER_28_1252 vddd vssd sg13cmos5l_decap_8
X_7158_ _7158_/Q _7171_/CLK _7158_/D fanout364/X vddd vssd sg13cmos5l_dfrbpq_1
X_6109_ _6109_/Y _6048_/A _5187_/C _6108_/Y vddd vssd sg13cmos5l_a21oi_1
X_7089_ _7089_/Q _7120_/CLK _7089_/D _6863_/B_N vddd vssd sg13cmos5l_dfrbpq_1
XFILLER_27_664 vddd vssd sg13cmos5l_decap_8
XFILLER_26_196 vddd vssd sg13cmos5l_decap_8
XFILLER_30_818 vddd vssd sg13cmos5l_decap_8
XFILLER_25_86 vddd vssd sg13cmos5l_decap_8
XFILLER_19_1977 vddd vssd sg13cmos5l_decap_4
XFILLER_10_542 vddd vssd sg13cmos5l_decap_4
XFILLER_17_1690 vddd vssd sg13cmos5l_decap_8
XFILLER_13_1521 vddd vssd sg13cmos5l_decap_8
XFILLER_13_1576 vddd vssd sg13cmos5l_decap_8
XFILLER_13_1565 vddd vssd sg13cmos5l_decap_8
XFILLER_30_1890 vddd vssd sg13cmos5l_decap_8
XFILLER_29_1016 vddd vssd sg13cmos5l_decap_8
Xtiedowns\[51\] mask_rev_in[7] vddd vssd sg13cmos5l_antennanp
XFILLER_2_752 vddd vssd sg13cmos5l_decap_4
Xclkbuf_1_1__f_SCK sram_clk_mux/A0 clkbuf_0_SCK/X vddd vssd sg13cmos5l_buf_8
XFILLER_24_2373 vddd vssd sg13cmos5l_decap_8
XFILLER_24_1661 vddd vssd sg13cmos5l_decap_8
XFILLER_20_1503 vddd vssd sg13cmos5l_decap_4
XFILLER_2_79 vddd vssd sg13cmos5l_decap_8
XFILLER_4_2467 vddd vssd sg13cmos5l_decap_8
XFILLER_32_133 vddd vssd sg13cmos5l_decap_8
XFILLER_20_306 vddd vssd sg13cmos5l_decap_8
X_4790_ _4790_/Y _4484_/C _4790_/B vddd vssd sg13cmos5l_nand2b_1
X_3810_ _3810_/Y _4257_/B sram_odata[5] _3753_/X wire17/X _4292_/B vddd vssd sg13cmos5l_a221oi_1
XANTENNA_18 porb vddd vssd sg13cmos5l_antennanp
Xoutbuffers\[105\] dbus_out[8] _5546_/Y vddd vssd sg13cmos5l_buf_16
XANTENNA_29 _6773_/C vddd vssd sg13cmos5l_antennanp
X_3741_ _3741_/Y mask_rev_in[7] _4250_/A _4252_/A vddd vssd sg13cmos5l_a21oi_1
XFILLER_18_1498 vddd vssd sg13cmos5l_decap_8
XFILLER_31_2377 vddd vssd sg13cmos5l_decap_8
X_6460_ _6460_/Y _6518_/A _6465_/B vddd vssd sg13cmos5l_nor2_1
X_3672_ _3752_/A _4002_/A _3929_/A vddd vssd sg13cmos5l_nor2_1
X_6391_ _6391_/Y _6391_/A _6397_/B vddd vssd sg13cmos5l_nand2_1
X_5411_ _5411_/Y _3544_/A _5428_/C _7159_/Q vddd vssd sg13cmos5l_o21ai_1
XFILLER_12_1042 vddd vssd sg13cmos5l_decap_8
X_5342_ _5342_/Y _5342_/A _5345_/B vddd vssd sg13cmos5l_nor2b_1
XFILLER_12_1097 vddd vssd sg13cmos5l_decap_8
X_7012_ _7012_/Q _7012_/CLK _7012_/D _6959_/Y vddd vssd sg13cmos5l_dfrbpq_1
X_5273_ _5279_/C _5273_/A _5273_/B vddd vssd sg13cmos5l_nor2_1
X_4224_ _4224_/Y _4221_/Y _4222_/Y _4223_/Y vddd vssd sg13cmos5l_o21ai_1
XFILLER_29_918 vddd vssd sg13cmos5l_decap_8
XFILLER_5_1519 vddd vssd sg13cmos5l_decap_8
X_4155_ wire50/A _7131_/Q _4155_/B vddd vssd sg13cmos5l_nor2_1
X_4086_ _4086_/Y _3673_/A _3708_/A _3618_/Y vddd vssd sg13cmos5l_a21oi_1
XFILLER_24_645 vddd vssd sg13cmos5l_decap_4
XFILLER_23_133 vddd vssd sg13cmos5l_decap_8
XFILLER_12_807 vddd vssd sg13cmos5l_decap_8
X_4988_ _5268_/A _7282_/Q _7283_/Q vddd vssd sg13cmos5l_nor2b_1
XFILLER_14_2520 vddd vssd sg13cmos5l_decap_8
X_6727_ _7061_/D _6735_/A1 _6732_/S hold996/X vddd vssd sg13cmos5l_o21ai_1
X_3939_ _3939_/Y _6622_/B _3966_/B vddd vssd sg13cmos5l_nor2_1
XFILLER_20_884 vddd vssd sg13cmos5l_decap_8
XFILLER_14_2597 vddd vssd sg13cmos5l_decap_8
X_6658_ _7295_/D _6658_/A0 _6704_/A0 _6658_/S vddd vssd sg13cmos5l_mux2_1
X_5609_ _5610_/B _5609_/A _5609_/B vddd vssd sg13cmos5l_nor2_1
X_6589_ _6594_/S _6589_/A _6615_/C vddd vssd sg13cmos5l_nor2_1
XFILLER_10_1738 vddd vssd sg13cmos5l_decap_8
XFILLER_11_77 vddd vssd sg13cmos5l_decap_8
Xfanout330 _5626_/A _5882_/A vddd vssd sg13cmos5l_buf_1
Xfanout341 _6885_/B_N _6911_/B_N vddd vssd sg13cmos5l_buf_1
Xfanout363 fanout363/X fanout379/X vddd vssd sg13cmos5l_buf_1
Xfanout374 _6825_/B_N fanout377/X vddd vssd sg13cmos5l_buf_1
XFILLER_8_1165 vddd vssd sg13cmos5l_decap_8
Xfanout352 _6908_/B_N fanout363/X vddd vssd sg13cmos5l_buf_1
Xfanout385 fanout385/X fanout386/X vddd vssd sg13cmos5l_buf_1
XFILLER_19_428 vddd vssd sg13cmos5l_decap_8
Xfanout396 fanout396/X fanout400/X vddd vssd sg13cmos5l_buf_1
XFILLER_8_1187 vddd vssd sg13cmos5l_decap_4
XFILLER_28_962 vddd vssd sg13cmos5l_decap_8
XFILLER_21_2568 vddd vssd sg13cmos5l_decap_8
XFILLER_19_2464 vddd vssd sg13cmos5l_decap_8
XFILLER_15_1605 vddd vssd sg13cmos5l_decap_4
XFILLER_13_2085 vddd vssd sg13cmos5l_decap_8
XFILLER_26_2413 vddd vssd sg13cmos5l_decap_8
XFILLER_6_1817 vddd vssd sg13cmos5l_decap_4
XFILLER_4_2253 vddd vssd sg13cmos5l_decap_8
XFILLER_20_2056 vddd vssd sg13cmos5l_decap_8
XFILLER_0_2139 vddd vssd sg13cmos5l_decap_8
XFILLER_4_1530 vddd vssd sg13cmos5l_decap_8
X_5960_ _5961_/B _6216_/A1 _5983_/C _5972_/B vddd vssd sg13cmos5l_o21ai_1
XFILLER_20_2089 vddd vssd sg13cmos5l_decap_4
XFILLER_19_984 vddd vssd sg13cmos5l_decap_4
XFILLER_0_1416 vddd vssd sg13cmos5l_decap_4
XFILLER_20_1388 vddd vssd sg13cmos5l_decap_8
X_5891_ _5910_/D _7226_/Q _5908_/A vddd vssd sg13cmos5l_nor2_1
X_4911_ _7314_/D _4911_/A1 _4918_/C _4910_/Y vddd vssd sg13cmos5l_o21ai_1
X_4842_ _4842_/Y _4839_/B _4841_/X _3647_/B vddd vssd sg13cmos5l_o21ai_1
X_4773_ _4773_/Y _4814_/A1 _3599_/Y _4773_/B1 _4789_/B vddd vssd sg13cmos5l_a22oi_1
X_6512_ _7208_/D _6675_/A1 _6516_/S hold922/X vddd vssd sg13cmos5l_o21ai_1
X_3724_ _3803_/B _3842_/B _3961_/A vddd vssd sg13cmos5l_and2_1
X_6443_ _6449_/S _6443_/A _6459_/B vddd vssd sg13cmos5l_nand2_1
XFILLER_14_1159 vddd vssd sg13cmos5l_decap_8
X_3655_ _3655_/Y _4892_/B _4889_/B _3654_/Y _5285_/A _5999_/S vddd vssd sg13cmos5l_a221oi_1
Xoutbuffers\[82\] io_oe[9] _5262_/X vddd vssd sg13cmos5l_buf_16
X_6374_ _6374_/Y _6374_/A _6374_/B vddd vssd sg13cmos5l_nand2_1
X_3586_ _3586_/Y _3586_/A vddd vssd sg13cmos5l_inv_1
X_5325_ _5345_/A _7144_/Q _7145_/Q vddd vssd sg13cmos5l_nor2_1
X_5256_ _5260_/A _5272_/A _5256_/B vddd vssd sg13cmos5l_nor2_1
XFILLER_9_2186 vddd vssd sg13cmos5l_decap_8
X_4207_ _4207_/Y _7204_/Q _4122_/B _6496_/A vddd vssd sg13cmos5l_o21ai_1
X_5187_ _5188_/D _5187_/A _6112_/B _5187_/C _5187_/D vddd vssd sg13cmos5l_or4_1
XFILLER_25_1255 vddd vssd sg13cmos5l_decap_8
XFILLER_28_225 vddd vssd sg13cmos5l_decap_8
X_4138_ _4138_/Y _5416_/B _6412_/A _4136_/Y _4137_/Y _6406_/A vddd vssd sg13cmos5l_a221oi_1
X_4069_ _4069_/Y _7108_/Q _3695_/Y _3803_/B vddd vssd sg13cmos5l_a21oi_1
Xwire62 wire62/X wire62/A vddd vssd sg13cmos5l_buf_4
XFILLER_24_431 vddd vssd sg13cmos5l_decap_8
XFILLER_0_1972 vddd vssd sg13cmos5l_decap_4
XFILLER_12_604 vddd vssd sg13cmos5l_decap_4
XFILLER_16_1925 vddd vssd sg13cmos5l_decap_4
XFILLER_22_21 vddd vssd sg13cmos5l_decap_8
XFILLER_22_98 vddd vssd sg13cmos5l_decap_8
Xclkbuf_leaf_5_SCK_regs _7199_/CLK clkload2/A vddd vssd sg13cmos5l_buf_8
Xfanout182 _6404_/A _5027_/A vddd vssd sg13cmos5l_buf_1
XFILLER_21_2310 vddd vssd sg13cmos5l_decap_8
Xfanout171 _4308_/A hold900/X vddd vssd sg13cmos5l_buf_1
Xfanout193 _6553_/A _6678_/A1 vddd vssd sg13cmos5l_buf_1
Xclkbuf_4_3__f_clk_regs _7307_/CLK clkbuf_3_1_0_clk_regs/X vddd vssd sg13cmos5l_buf_8
Xtiedowns\[14\] _6226_/A vddd vssd sg13cmos5l_antennanp
XFILLER_27_291 vddd vssd sg13cmos5l_decap_4
XFILLER_30_412 vddd vssd sg13cmos5l_decap_8
XFILLER_19_2272 vddd vssd sg13cmos5l_decap_8
XFILLER_15_1402 vddd vssd sg13cmos5l_decap_8
XFILLER_32_2461 vddd vssd sg13cmos5l_decap_8
XFILLER_19_1593 vddd vssd sg13cmos5l_decap_8
XFILLER_15_2169 vddd vssd sg13cmos5l_decap_8
XFILLER_8_56 vddd vssd sg13cmos5l_decap_8
Xhold608 _3643_/A _7320_/Q vddd vssd sg13cmos5l_dlygate4sd3_1
XFILLER_7_685 vddd vssd sg13cmos5l_decap_8
Xhold619 _7391_/D _3655_/Y vddd vssd sg13cmos5l_dlygate4sd3_1
X_5110_ _5119_/A _5202_/B _7277_/Q _5110_/C vddd vssd sg13cmos5l_nand3_1
X_6090_ _6090_/Y _6048_/A _5168_/B _5172_/B vddd vssd sg13cmos5l_a21oi_1
XFILLER_22_2107 vddd vssd sg13cmos5l_decap_8
X_5041_ _5062_/A _5240_/A _5240_/B _5149_/B _5148_/A vddd vssd sg13cmos5l_nor4_1
Xhold1319 _7070_/D _6738_/X vddd vssd sg13cmos5l_dlygate4sd3_1
XFILLER_26_1575 vddd vssd sg13cmos5l_decap_8
XFILLER_26_1553 vddd vssd sg13cmos5l_decap_8
Xhold1308 _3566_/A _7171_/Q vddd vssd sg13cmos5l_dlygate4sd3_1
XFILLER_6_1636 vddd vssd sg13cmos5l_decap_4
XFILLER_4_2072 vddd vssd sg13cmos5l_decap_8
XFILLER_20_1130 vddd vssd sg13cmos5l_decap_8
X_6992_ _6992_/Q _7341_/CLK _6992_/D _6939_/Y vddd vssd sg13cmos5l_dfrbpq_1
X_5943_ _5943_/Y _5954_/A _5943_/B _5945_/B vddd vssd sg13cmos5l_nor3_1
XFILLER_18_291 vddd vssd sg13cmos5l_decap_8
X_5874_ _5880_/C _5887_/B _5887_/A vddd vssd sg13cmos5l_nand2b_1
X_4825_ _4825_/Y _4489_/X _4825_/A2 _4811_/Y vddd vssd sg13cmos5l_o21ai_1
XFILLER_18_1070 vddd vssd sg13cmos5l_decap_8
XFILLER_11_2512 vddd vssd sg13cmos5l_decap_8
X_4756_ _4756_/Y _4464_/B _4753_/Y _4755_/Y vddd vssd sg13cmos5l_o21ai_1
X_3707_ _3880_/B _3929_/A _3737_/B vddd vssd sg13cmos5l_nor2_1
X_4687_ _4687_/X _4687_/A _4687_/B vddd vssd sg13cmos5l_or2_1
X_3638_ _4288_/A _5024_/A _4970_/A _4276_/A vddd vssd sg13cmos5l_nor3_1
X_6426_ _6426_/Y _5447_/B _6427_/B _6425_/Y vddd vssd sg13cmos5l_a21oi_1
X_6357_ _6357_/Y _6768_/A _6359_/S vddd vssd sg13cmos5l_nand2_1
X_3569_ _3569_/Y _3569_/A vddd vssd sg13cmos5l_inv_1
X_5308_ _5308_/X _7140_/Q _7141_/Q _5607_/A vddd vssd sg13cmos5l_or3_1
X_6288_ _6288_/X _7072_/Q _6288_/B vddd vssd sg13cmos5l_or2_1
XFILLER_0_349 vddd vssd sg13cmos5l_decap_8
X_5239_ _5239_/Y _5240_/A _5240_/B _5274_/A vddd vssd sg13cmos5l_nor3_1
XFILLER_22_1962 vddd vssd sg13cmos5l_decap_8
XFILLER_17_21 vddd vssd sg13cmos5l_decap_8
XFILLER_17_54 vddd vssd sg13cmos5l_decap_8
XFILLER_25_740 vddd vssd sg13cmos5l_decap_4
XFILLER_0_1791 vddd vssd sg13cmos5l_decap_4
XFILLER_24_283 vddd vssd sg13cmos5l_decap_8
XFILLER_16_2434 vddd vssd sg13cmos5l_decap_8
XFILLER_16_1722 vddd vssd sg13cmos5l_decap_8
XFILLER_32_1045 vddd vssd sg13cmos5l_decap_8
XFILLER_3_110 vddd vssd sg13cmos5l_decap_8
XFILLER_4_666 vddd vssd sg13cmos5l_decap_8
XFILLER_27_2530 vddd vssd sg13cmos5l_decap_8
XFILLER_27_1873 vddd vssd sg13cmos5l_decap_8
XFILLER_23_1704 vddd vssd sg13cmos5l_decap_8
XFILLER_7_1989 vddd vssd sg13cmos5l_decap_8
XFILLER_21_1461 vddd vssd sg13cmos5l_decap_8
XFILLER_30_220 vddd vssd sg13cmos5l_decap_8
X_4610_ _4610_/Y _4633_/A _4610_/B _4610_/C vddd vssd sg13cmos5l_nor3_1
X_5590_ _5591_/B _5728_/A _5597_/A _5589_/X vddd vssd sg13cmos5l_o21ai_1
X_4541_ _4541_/X _4526_/B _4811_/B _4540_/Y vddd vssd sg13cmos5l_a21o_1
X_7260_ _7260_/Q _7294_/CLK _7260_/D fanout392/X vddd vssd sg13cmos5l_dfrbpq_1
X_4472_ _4474_/A _4530_/A _4530_/B _4473_/A vddd vssd sg13cmos5l_o21ai_1
Xmax_cap124 _3891_/A _3752_/A vddd vssd sg13cmos5l_buf_4
XFILLER_7_482 vddd vssd sg13cmos5l_decap_8
X_7191_ _7191_/Q _7191_/CLK _7191_/D fanout378/X vddd vssd sg13cmos5l_dfrbpq_1
X_6211_ _6211_/Y _5241_/A _6190_/Y _6210_/Y vddd vssd sg13cmos5l_o21ai_1
X_6142_ _6142_/Y _5204_/C _6140_/Y _6141_/Y vddd vssd sg13cmos5l_o21ai_1
XFILLER_31_0 vddd vssd sg13cmos5l_decap_8
Xhold1105 _7275_/D _6628_/Y vddd vssd sg13cmos5l_dlygate4sd3_1
X_6073_ _6073_/Y _6073_/A _6073_/B vddd vssd sg13cmos5l_nor2_1
Xoutbuffers\[45\] bandgap_trim[6] _6293_/Y vddd vssd sg13cmos5l_buf_16
Xhold1138 _4398_/A _7347_/Q vddd vssd sg13cmos5l_dlygate4sd3_1
Xhold1116 _6567_/A1 _7238_/Q vddd vssd sg13cmos5l_dlygate4sd3_1
X_5024_ sram_idata[0] _5024_/A _5032_/B vddd vssd sg13cmos5l_and2_1
Xhold1127 _6419_/A1 _5408_/B vddd vssd sg13cmos5l_dlygate4sd3_1
Xhold1149 _3534_/A _7245_/Q vddd vssd sg13cmos5l_dlygate4sd3_1
XFILLER_6_1455 vddd vssd sg13cmos5l_decap_4
XFILLER_6_2189 vddd vssd sg13cmos5l_decap_4
XFILLER_6_1466 vddd vssd sg13cmos5l_decap_8
XFILLER_22_1269 vddd vssd sg13cmos5l_decap_8
X_6975_ _6975_/Q _7351_/CLK _6975_/D _6922_/Y vddd vssd sg13cmos5l_dfrbpq_1
X_5926_ _5926_/Y _6970_/Q _3594_/Y _5925_/B _5945_/A vddd vssd sg13cmos5l_a22oi_1
XFILLER_22_754 vddd vssd sg13cmos5l_decap_8
XFILLER_22_765 vddd vssd sg13cmos5l_decap_8
XFILLER_21_264 vddd vssd sg13cmos5l_decap_8
X_5857_ _5857_/Y _7218_/Q _5857_/B _5857_/C vddd vssd sg13cmos5l_nor3_1
X_5788_ _5789_/B _5788_/A _5788_/B vddd vssd sg13cmos5l_nor2_1
X_4808_ _4808_/Y _4807_/A _4794_/Y _4804_/Y _4807_/Y vddd vssd sg13cmos5l_a22oi_1
X_4739_ _4739_/Y _4499_/Y _4732_/Y _4738_/Y vddd vssd sg13cmos5l_o21ai_1
X_6409_ _7153_/D _6686_/A _6409_/A1 _6411_/S vddd vssd sg13cmos5l_mux2_1
Xhold950 hold950/X _6610_/Y vddd vssd sg13cmos5l_dlygate4sd3_1
Xhold972 hold972/X hold972/A vddd vssd sg13cmos5l_dlygate4sd3_1
X_7389_ _7389_/Q _7389_/CLK _7389_/D _6801_/Y vddd vssd sg13cmos5l_dfrbpq_1
Xhold961 _4405_/B _4404_/Y vddd vssd sg13cmos5l_dlygate4sd3_1
Xhold994 hold994/X _6444_/Y vddd vssd sg13cmos5l_dlygate4sd3_1
Xhold983 _7345_/D _4417_/Y vddd vssd sg13cmos5l_dlygate4sd3_1
Xclkbuf_3_5_0_SCK_regs clkload6/A clkbuf_0_SCK_regs/X vddd vssd sg13cmos5l_buf_8
XFILLER_28_86 vddd vssd sg13cmos5l_decap_8
XFILLER_2_1842 vddd vssd sg13cmos5l_decap_8
XFILLER_32_507 vddd vssd sg13cmos5l_decap_8
XFILLER_18_1839 vddd vssd sg13cmos5l_decap_8
XFILLER_13_776 vddd vssd sg13cmos5l_decap_8
XFILLER_16_1574 vddd vssd sg13cmos5l_decap_8
XFILLER_8_268 vddd vssd sg13cmos5l_decap_8
XFILLER_29_1935 vddd vssd sg13cmos5l_decap_8
XFILLER_4_474 vddd vssd sg13cmos5l_decap_8
XFILLER_5_79 vddd vssd sg13cmos5l_decap_8
XFILLER_10_1162 vddd vssd sg13cmos5l_decap_8
XFILLER_27_1692 vddd vssd sg13cmos5l_decap_8
XFILLER_27_1670 vddd vssd sg13cmos5l_decap_4
XFILLER_7_2498 vddd vssd sg13cmos5l_decap_8
XFILLER_23_1567 vddd vssd sg13cmos5l_decap_8
XFILLER_3_1606 vddd vssd sg13cmos5l_decap_8
XFILLER_1_1341 vddd vssd sg13cmos5l_decap_8
XFILLER_23_507 vddd vssd sg13cmos5l_decap_8
XFILLER_1_1385 vddd vssd sg13cmos5l_decap_8
X_6760_ _6760_/Y _6760_/A _6767_/S vddd vssd sg13cmos5l_nor2_1
X_3972_ _3972_/Y _7059_/Q wire78/X _4085_/B vddd vssd sg13cmos5l_a21oi_1
X_5711_ _5711_/Y _7198_/Q _5711_/B _5711_/C vddd vssd sg13cmos5l_nor3_1
X_6691_ _6698_/S _6691_/A _6733_/B vddd vssd sg13cmos5l_nor2_1
X_5642_ _5647_/B _5642_/A _5642_/B _5642_/C _5642_/D vddd vssd sg13cmos5l_nor4_1
X_5573_ _5574_/B _5569_/Y _5570_/Y _5572_/Y vddd vssd sg13cmos5l_o21ai_1
X_4524_ _4524_/Y _4616_/A _4524_/B vddd vssd sg13cmos5l_nor2_1
X_7312_ _7312_/Q _7338_/CLK _7312_/D _6825_/Y vddd vssd sg13cmos5l_dfrbpq_1
XFILLER_28_1412 vddd vssd sg13cmos5l_decap_8
X_4455_ _4456_/B _4492_/A _4492_/B vddd vssd sg13cmos5l_or2_1
X_7243_ _7243_/Q _7285_/CLK _7243_/D fanout388/X vddd vssd sg13cmos5l_dfrbpq_1
X_7174_ _7174_/Q _7187_/CLK _7174_/D fanout366/X vddd vssd sg13cmos5l_dfrbpq_1
X_4386_ _4387_/D _4373_/A _7122_/Q _3529_/Y _4526_/B vddd vssd sg13cmos5l_a22oi_1
XFILLER_8_1506 vddd vssd sg13cmos5l_decap_8
XFILLER_24_1309 vddd vssd sg13cmos5l_decap_8
XFILLER_8_1539 vddd vssd sg13cmos5l_decap_8
X_6125_ _6125_/Y _3512_/Y _7289_/Q _5090_/B vddd vssd sg13cmos5l_a21oi_1
XFILLER_22_1022 vddd vssd sg13cmos5l_decap_8
X_6056_ _6057_/B _6012_/A _5102_/C _5119_/C vddd vssd sg13cmos5l_o21ai_1
X_5007_ _6262_/C _5215_/A _5266_/C vddd vssd sg13cmos5l_nor2_1
XFILLER_22_1055 vddd vssd sg13cmos5l_decap_4
XFILLER_22_1099 vddd vssd sg13cmos5l_decap_8
X_6958_ _6958_/Y _6958_/A _6958_/B_N vddd vssd sg13cmos5l_nor2b_1
X_6889_ _6889_/Y _6909_/A _6892_/B_N vddd vssd sg13cmos5l_nor2b_1
X_5909_ _5913_/B _5910_/D _5909_/B vddd vssd sg13cmos5l_nand2_1
XFILLER_17_2595 vddd vssd sg13cmos5l_decap_8
XFILLER_13_2448 vddd vssd sg13cmos5l_decap_8
XFILLER_14_77 vddd vssd sg13cmos5l_decap_8
XFILLER_13_1725 vddd vssd sg13cmos5l_decap_8
XFILLER_30_21 vddd vssd sg13cmos5l_decap_8
XFILLER_11_1482 vddd vssd sg13cmos5l_decap_4
XFILLER_11_1493 vddd vssd sg13cmos5l_decap_4
Xhold791 _7126_/D _6356_/X vddd vssd sg13cmos5l_dlygate4sd3_1
Xhold780 _7359_/D _4329_/X vddd vssd sg13cmos5l_dlygate4sd3_1
XFILLER_7_1005 vddd vssd sg13cmos5l_decap_8
XFILLER_24_2555 vddd vssd sg13cmos5l_decap_8
XFILLER_24_1832 vddd vssd sg13cmos5l_decap_8
XFILLER_29_172 vddd vssd sg13cmos5l_decap_8
XFILLER_17_301 vddd vssd sg13cmos5l_decap_4
Xhold1491 _7072_/D _6740_/X vddd vssd sg13cmos5l_dlygate4sd3_1
Xhold1480 _7337_/D _4589_/X vddd vssd sg13cmos5l_dlygate4sd3_1
XFILLER_18_857 vddd vssd sg13cmos5l_decap_8
XFILLER_17_323 vddd vssd sg13cmos5l_decap_8
XFILLER_32_315 vddd vssd sg13cmos5l_decap_8
XFILLER_18_1658 vddd vssd sg13cmos5l_decap_8
XFILLER_31_2559 vddd vssd sg13cmos5l_decap_8
XFILLER_29_2422 vddd vssd sg13cmos5l_decap_8
XFILLER_12_1268 vddd vssd sg13cmos5l_decap_8
XFILLER_4_260 vddd vssd sg13cmos5l_decap_4
X_4240_ _4241_/B _7122_/Q _6349_/A _3701_/Y vddd vssd sg13cmos5l_o21ai_1
XFILLER_9_2549 vddd vssd sg13cmos5l_decap_8
XFILLER_29_2499 vddd vssd sg13cmos5l_decap_8
X_4171_ _4171_/Y _4257_/B sram_odata[1] _3753_/X wire3/X _4292_/B vddd vssd sg13cmos5l_a221oi_1
XFILLER_23_1331 vddd vssd sg13cmos5l_decap_8
XFILLER_3_1458 vddd vssd sg13cmos5l_decap_8
X_6812_ _6812_/Y _6837_/A _6867_/B_N vddd vssd sg13cmos5l_nor2b_1
XFILLER_17_890 vddd vssd sg13cmos5l_decap_8
X_6743_ _6743_/Y _6743_/A _6745_/S vddd vssd sg13cmos5l_nand2_1
XFILLER_23_359 vddd vssd sg13cmos5l_decap_8
X_3955_ _3955_/Y _6412_/A vddd vssd sg13cmos5l_inv_1
X_6674_ _6674_/Y _6674_/A _6678_/S vddd vssd sg13cmos5l_nor2_1
X_5625_ _5625_/Y _5732_/A _5623_/B _5623_/Y _5617_/Y _5626_/B vddd vssd sg13cmos5l_a221oi_1
X_3886_ _3889_/B _6615_/A _6315_/B vddd vssd sg13cmos5l_nor2_1
XFILLER_12_2470 vddd vssd sg13cmos5l_decap_8
X_5556_ _5556_/Y _5554_/X _5555_/Y _3569_/Y vddd vssd sg13cmos5l_a21oi_1
X_4507_ _4507_/Y _4507_/A _4507_/B _4507_/C vddd vssd sg13cmos5l_nand3_1
X_5487_ _5507_/A _7168_/Q _7169_/Q vddd vssd sg13cmos5l_nor2_1
X_4438_ _4440_/S _4438_/A _4438_/B vddd vssd sg13cmos5l_nand2_1
X_7226_ _7226_/Q _7295_/CLK _7226_/D fanout377/X vddd vssd sg13cmos5l_dfrbpq_1
Xwire3 wire3/X wire3/A vddd vssd sg13cmos5l_buf_4
X_7157_ _7157_/Q _7206_/CLK _7157_/D fanout364/X vddd vssd sg13cmos5l_dfrbpq_1
X_4369_ _4369_/Y _7125_/Q _4599_/A vddd vssd sg13cmos5l_nand2b_1
X_6108_ _6108_/Y _4107_/Y _5187_/A _6106_/X _6107_/Y _5187_/C vddd vssd sg13cmos5l_a221oi_1
X_7088_ _7088_/Q _7105_/CLK _7088_/D _6863_/B_N vddd vssd sg13cmos5l_dfrbpq_1
X_6039_ _6039_/X _5784_/A _7285_/Q _5090_/B vddd vssd sg13cmos5l_a21o_1
XFILLER_15_805 vddd vssd sg13cmos5l_decap_8
XFILLER_26_175 vddd vssd sg13cmos5l_decap_8
XFILLER_25_65 vddd vssd sg13cmos5l_decap_8
XFILLER_19_1956 vddd vssd sg13cmos5l_decap_4
XFILLER_6_525 vddd vssd sg13cmos5l_decap_4
XFILLER_30_2592 vddd vssd sg13cmos5l_decap_8
XFILLER_9_0 vddd vssd sg13cmos5l_decap_8
Xtiedowns\[44\] mask_rev_in[0] vddd vssd sg13cmos5l_antennanp
XFILLER_24_2352 vddd vssd sg13cmos5l_decap_8
XFILLER_8_2571 vddd vssd sg13cmos5l_decap_8
XFILLER_2_58 vddd vssd sg13cmos5l_decap_8
XFILLER_32_112 vddd vssd sg13cmos5l_decap_8
XFILLER_32_189 vddd vssd sg13cmos5l_decap_8
XANTENNA_19 porb vddd vssd sg13cmos5l_antennanp
XFILLER_18_2189 vddd vssd sg13cmos5l_decap_8
X_3740_ _3740_/Y _3948_/A _4251_/B vddd vssd sg13cmos5l_nor2_1
XFILLER_31_2356 vddd vssd sg13cmos5l_decap_8
XFILLER_16_1190 vddd vssd sg13cmos5l_decap_8
X_3671_ _3929_/A _3750_/C _3750_/D vddd vssd sg13cmos5l_nand2b_1
X_6390_ _6397_/B _6390_/A _6725_/B vddd vssd sg13cmos5l_nand2_1
X_5410_ _5410_/Y _5607_/A _7156_/Q _5416_/B vddd vssd sg13cmos5l_nor3_1
X_5341_ _5345_/B _7146_/Q _7147_/Q vddd vssd sg13cmos5l_nor2_1
Xclkbuf_leaf_29_SCK_regs _7255_/CLK clkload6/A vddd vssd sg13cmos5l_buf_8
X_7011_ _7011_/Q _7341_/CLK _7011_/D _6958_/Y vddd vssd sg13cmos5l_dfrbpq_1
XFILLER_29_1562 vddd vssd sg13cmos5l_decap_4
X_5272_ _6241_/B _5272_/A _5272_/B vddd vssd sg13cmos5l_or2_1
XFILLER_9_1612 vddd vssd sg13cmos5l_decap_4
XFILLER_25_1426 vddd vssd sg13cmos5l_decap_4
X_4223_ _4223_/Y _7152_/Q _6406_/A _6399_/A vddd vssd sg13cmos5l_a21oi_1
X_4154_ wire10/A _7053_/Q _3983_/B _4151_/Y _4152_/Y _4153_/Y vddd vssd sg13cmos5l_a221oi_1
X_4085_ _4085_/Y _7072_/Q _4085_/B vddd vssd sg13cmos5l_nand2b_1
XFILLER_24_624 vddd vssd sg13cmos5l_decap_8
XFILLER_23_112 vddd vssd sg13cmos5l_decap_8
XFILLER_19_1219 vddd vssd sg13cmos5l_decap_4
X_6726_ _6726_/Y _6726_/A _6732_/S vddd vssd sg13cmos5l_nand2_1
XFILLER_23_189 vddd vssd sg13cmos5l_decap_8
X_4987_ _6150_/B _7280_/Q _7281_/Q vddd vssd sg13cmos5l_nand2_1
XFILLER_32_1408 vddd vssd sg13cmos5l_decap_4
X_3938_ _3938_/Y _5620_/B _3934_/Y _3937_/Y vddd vssd sg13cmos5l_o21ai_1
X_3869_ wire99/A _3869_/A _3869_/B _4002_/D _3869_/D vddd vssd sg13cmos5l_nor4_1
XFILLER_20_863 vddd vssd sg13cmos5l_decap_8
X_6657_ _7294_/D _6657_/A0 _6544_/A _6658_/S vddd vssd sg13cmos5l_mux2_1
XFILLER_14_2576 vddd vssd sg13cmos5l_decap_8
X_5608_ _5609_/B _3544_/A _5631_/C _5620_/B vddd vssd sg13cmos5l_o21ai_1
X_6588_ _6588_/X _6588_/A0 _6743_/A _6588_/S vddd vssd sg13cmos5l_mux2_1
X_5539_ _5539_/Y _5540_/A _5540_/B _5539_/C vddd vssd sg13cmos5l_nor3_1
XFILLER_3_506 vddd vssd sg13cmos5l_decap_8
XFILLER_11_56 vddd vssd sg13cmos5l_decap_8
XFILLER_2_7 vddd vssd sg13cmos5l_decap_4
XFILLER_28_1061 vddd vssd sg13cmos5l_decap_8
Xfanout320 _4460_/A hold1415/X vddd vssd sg13cmos5l_buf_1
X_7209_ _7209_/Q _7217_/CLK _7209_/D fanout372/X vddd vssd sg13cmos5l_dfrbpq_1
Xfanout331 _5882_/A _6232_/A vddd vssd sg13cmos5l_buf_1
XFILLER_8_1111 vddd vssd sg13cmos5l_decap_8
Xfanout375 fanout375/X fanout377/X vddd vssd sg13cmos5l_buf_1
Xfanout342 _6910_/B_N _6911_/B_N vddd vssd sg13cmos5l_buf_1
Xfanout353 _6907_/B_N _6906_/B_N vddd vssd sg13cmos5l_buf_1
Xfanout364 fanout364/X fanout366/X vddd vssd sg13cmos5l_buf_1
Xfanout386 fanout386/X fanout387/X vddd vssd sg13cmos5l_buf_1
Xfanout397 _6955_/B_N fanout399/X vddd vssd sg13cmos5l_buf_1
XFILLER_25_1960 vddd vssd sg13cmos5l_decap_4
XFILLER_21_2547 vddd vssd sg13cmos5l_decap_8
XFILLER_19_407 vddd vssd sg13cmos5l_decap_8
Xclkbuf_4_2__f_clk_regs _7393_/CLK clkbuf_3_1_0_clk_regs/X vddd vssd sg13cmos5l_buf_8
XFILLER_28_941 vddd vssd sg13cmos5l_decap_8
XFILLER_19_2443 vddd vssd sg13cmos5l_decap_8
XFILLER_14_123 vddd vssd sg13cmos5l_decap_8
XFILLER_15_1639 vddd vssd sg13cmos5l_decap_4
XFILLER_13_2064 vddd vssd sg13cmos5l_decap_8
XFILLER_11_863 vddd vssd sg13cmos5l_decap_8
XFILLER_11_885 vddd vssd sg13cmos5l_decap_8
XFILLER_26_2469 vddd vssd sg13cmos5l_decap_8
XFILLER_26_1724 vddd vssd sg13cmos5l_decap_4
XFILLER_6_2519 vddd vssd sg13cmos5l_decap_8
XFILLER_4_2221 vddd vssd sg13cmos5l_decap_8
XFILLER_0_2118 vddd vssd sg13cmos5l_decap_8
XFILLER_20_1345 vddd vssd sg13cmos5l_decap_8
XFILLER_4_1586 vddd vssd sg13cmos5l_decap_4
X_5890_ _5890_/Y _5916_/A1 _5861_/Y _5889_/Y vddd vssd sg13cmos5l_a21oi_1
X_4910_ _4910_/Y _4920_/A sram_odata[5] _4918_/C vddd vssd sg13cmos5l_nand3_1
X_4841_ _4841_/X _4841_/A _4841_/B vddd vssd sg13cmos5l_and2_1
X_4772_ _4772_/X _6792_/A _4772_/B vddd vssd sg13cmos5l_xor2_1
XFILLER_18_1285 vddd vssd sg13cmos5l_decap_4
XFILLER_14_1138 vddd vssd sg13cmos5l_decap_8
X_6511_ _6511_/Y _6511_/A _6516_/S vddd vssd sg13cmos5l_nand2_1
X_3723_ _3896_/B _4002_/A _4002_/D vddd vssd sg13cmos5l_nor2_1
X_6442_ _6442_/Y _6442_/A1 _6441_/B _6441_/Y vddd vssd sg13cmos5l_a21oi_1
X_3654_ _3654_/Y _4832_/A _5285_/B _5285_/C vddd vssd sg13cmos5l_nand3_1
X_6373_ _6373_/Y _5029_/A _6376_/B hold716/X vddd vssd sg13cmos5l_o21ai_1
X_3585_ _5815_/B _3585_/A vddd vssd sg13cmos5l_inv_1
XFILLER_9_2110 vddd vssd sg13cmos5l_decap_8
XFILLER_29_2071 vddd vssd sg13cmos5l_decap_8
X_5324_ _5339_/D _7145_/Q _7144_/Q vddd vssd sg13cmos5l_nor2b_1
Xoutbuffers\[75\] io_oe[2] _5121_/Y vddd vssd sg13cmos5l_buf_16
X_5255_ _5261_/C _5255_/A _5255_/B vddd vssd sg13cmos5l_nand2_1
XFILLER_25_1212 vddd vssd sg13cmos5l_decap_4
X_4206_ _4206_/Y _7208_/Q _6510_/A _4204_/Y _4205_/Y _6503_/A vddd vssd sg13cmos5l_a221oi_1
XFILLER_9_1464 vddd vssd sg13cmos5l_decap_4
XFILLER_28_204 vddd vssd sg13cmos5l_decap_8
X_5186_ _5188_/C _5241_/A _5186_/B _6122_/B _6120_/B vddd vssd sg13cmos5l_nand4_1
X_4137_ _4137_/Y _5441_/B _6420_/A _6412_/A vddd vssd sg13cmos5l_a21oi_1
X_4068_ _4068_/Y wire7/X _4066_/Y _4067_/Y vddd vssd sg13cmos5l_o21ai_1
XFILLER_20_2591 vddd vssd sg13cmos5l_decap_8
XFILLER_25_977 vddd vssd sg13cmos5l_decap_8
XFILLER_16_1904 vddd vssd sg13cmos5l_decap_8
X_6709_ _6709_/Y _6709_/A _6745_/S vddd vssd sg13cmos5l_nor2_1
XFILLER_32_1249 vddd vssd sg13cmos5l_decap_8
XFILLER_22_77 vddd vssd sg13cmos5l_decap_8
XFILLER_14_1672 vddd vssd sg13cmos5l_decap_8
XFILLER_10_1525 vddd vssd sg13cmos5l_decap_8
XFILLER_4_837 vddd vssd sg13cmos5l_decap_8
XFILLER_25_2480 vddd vssd sg13cmos5l_decap_8
Xfanout183 _5027_/A _6665_/A0 vddd vssd sg13cmos5l_buf_1
Xfanout161 _4173_/B _3656_/Y vddd vssd sg13cmos5l_buf_1
Xfanout150 _4773_/B1 _4794_/B1 vddd vssd sg13cmos5l_buf_1
Xfanout172 _4336_/A hold900/X vddd vssd sg13cmos5l_buf_1
XFILLER_5_2596 vddd vssd sg13cmos5l_decap_8
Xfanout194 _6455_/A fanout200/X vddd vssd sg13cmos5l_buf_1
XFILLER_21_1676 vddd vssd sg13cmos5l_decap_8
XFILLER_15_443 vddd vssd sg13cmos5l_decap_8
XFILLER_19_1572 vddd vssd sg13cmos5l_decap_8
XFILLER_15_2148 vddd vssd sg13cmos5l_decap_8
XFILLER_32_2440 vddd vssd sg13cmos5l_decap_8
XFILLER_30_479 vddd vssd sg13cmos5l_decap_4
XFILLER_8_35 vddd vssd sg13cmos5l_decap_8
XFILLER_32_1750 vddd vssd sg13cmos5l_decap_8
XFILLER_13_1171 vddd vssd sg13cmos5l_decap_4
Xhold609 hold609/X _3507_/Y vddd vssd sg13cmos5l_dlygate4sd3_1
X_5040_ _5076_/A _5149_/B _5148_/A vddd vssd sg13cmos5l_nor2_1
Xhold1309 _6442_/A1 _5495_/B vddd vssd sg13cmos5l_dlygate4sd3_1
XFILLER_6_1615 vddd vssd sg13cmos5l_decap_8
X_6991_ _6991_/Q _7340_/CLK _6991_/D _6938_/Y vddd vssd sg13cmos5l_dfrbpq_1
XFILLER_19_760 vddd vssd sg13cmos5l_decap_8
XFILLER_0_1203 vddd vssd sg13cmos5l_decap_8
XFILLER_4_1350 vddd vssd sg13cmos5l_decap_8
X_5942_ _5945_/B _5942_/A _5942_/B vddd vssd sg13cmos5l_and2_1
X_5873_ _5873_/Y _5871_/Y _5872_/Y _5884_/C vddd vssd sg13cmos5l_o21ai_1
XFILLER_22_958 vddd vssd sg13cmos5l_decap_8
X_4824_ _4824_/Y _4680_/A _4814_/Y _4824_/B1 vddd vssd sg13cmos5l_o21ai_1
X_4755_ _4755_/Y _4755_/A _4755_/B vddd vssd sg13cmos5l_nand2_1
XFILLER_30_980 vddd vssd sg13cmos5l_decap_8
X_3706_ wire62/A _7137_/Q _4155_/B vddd vssd sg13cmos5l_nor2_1
XFILLER_15_1981 vddd vssd sg13cmos5l_decap_8
X_4686_ _4687_/B _6041_/A _4714_/B vddd vssd sg13cmos5l_nor2_1
X_3637_ _4970_/B _5024_/A _4276_/A vddd vssd sg13cmos5l_nor2_1
X_6425_ _6425_/Y _6455_/A _6427_/B vddd vssd sg13cmos5l_nor2_1
X_6356_ _6356_/X hold790/X _6324_/A _6360_/S vddd vssd sg13cmos5l_mux2_1
X_3568_ _5557_/B _3568_/A vddd vssd sg13cmos5l_inv_1
X_5307_ _5307_/Y _3544_/A _5320_/C _5304_/A vddd vssd sg13cmos5l_o21ai_1
XFILLER_0_328 vddd vssd sg13cmos5l_decap_8
X_6287_ _6288_/B _6287_/A _6290_/A vddd vssd sg13cmos5l_nand2_1
X_3499_ _4373_/A _4670_/A vddd vssd sg13cmos5l_inv_1
X_5238_ _5241_/C _7260_/Q _7261_/Q _5275_/A vddd vssd sg13cmos5l_or3_1
XFILLER_9_1283 vddd vssd sg13cmos5l_decap_8
X_5169_ _5171_/B _5169_/A _5169_/B _5169_/C _5169_/D vddd vssd sg13cmos5l_nor4_1
XFILLER_0_2493 vddd vssd sg13cmos5l_decap_8
XFILLER_25_774 vddd vssd sg13cmos5l_decap_8
XFILLER_13_903 vddd vssd sg13cmos5l_decap_8
XFILLER_13_936 vddd vssd sg13cmos5l_decap_8
XFILLER_9_918 vddd vssd sg13cmos5l_decap_8
XFILLER_12_435 vddd vssd sg13cmos5l_decap_8
XFILLER_32_1024 vddd vssd sg13cmos5l_decap_8
XFILLER_14_2170 vddd vssd sg13cmos5l_decap_8
XFILLER_27_2586 vddd vssd sg13cmos5l_decap_8
XFILLER_23_2439 vddd vssd sg13cmos5l_decap_8
XFILLER_23_1716 vddd vssd sg13cmos5l_decap_8
XFILLER_27_1896 vddd vssd sg13cmos5l_decap_4
XFILLER_21_1440 vddd vssd sg13cmos5l_decap_8
XFILLER_31_722 vddd vssd sg13cmos5l_decap_8
XFILLER_19_1391 vddd vssd sg13cmos5l_decap_8
XFILLER_15_1211 vddd vssd sg13cmos5l_decap_4
XFILLER_30_298 vddd vssd sg13cmos5l_decap_8
XFILLER_12_980 vddd vssd sg13cmos5l_decap_8
X_4540_ _4540_/Y _4633_/A _4540_/B _4540_/C vddd vssd sg13cmos5l_nor3_1
XFILLER_32_1591 vddd vssd sg13cmos5l_decap_8
X_4471_ _4530_/B _6189_/A _4471_/B vddd vssd sg13cmos5l_nand2_1
XFILLER_8_995 vddd vssd sg13cmos5l_decap_8
X_7190_ _7190_/Q _7191_/CLK _7190_/D fanout378/X vddd vssd sg13cmos5l_dfrbpq_1
X_6210_ _6210_/Y _7293_/Q _6208_/Y _6209_/Y vddd vssd sg13cmos5l_o21ai_1
X_6141_ _6141_/Y _6203_/A _5204_/C _5206_/C vddd vssd sg13cmos5l_a21oi_1
XFILLER_24_0 vddd vssd sg13cmos5l_decap_8
X_6072_ _6073_/B _6072_/A _6072_/B vddd vssd sg13cmos5l_nor2_1
Xhold1106 _4398_/B _7346_/Q vddd vssd sg13cmos5l_dlygate4sd3_1
XFILLER_6_2157 vddd vssd sg13cmos5l_decap_8
X_5023_ _5023_/Y _5023_/A _5023_/B vddd vssd sg13cmos5l_xnor2_1
Xhold1117 _7238_/D _6567_/X vddd vssd sg13cmos5l_dlygate4sd3_1
Xhold1128 _7159_/D _6419_/Y vddd vssd sg13cmos5l_dlygate4sd3_1
Xhold1139 _4411_/B1 _4358_/A vddd vssd sg13cmos5l_dlygate4sd3_1
Xoutbuffers\[38\] biasgen_ena _7052_/Q vddd vssd sg13cmos5l_buf_16
XFILLER_22_1248 vddd vssd sg13cmos5l_decap_8
XFILLER_4_1180 vddd vssd sg13cmos5l_decap_8
X_6974_ _6974_/Q _7001_/CLK _6974_/D _6921_/Y vddd vssd sg13cmos5l_dfrbpq_1
XFILLER_0_1022 vddd vssd sg13cmos5l_decap_4
XFILLER_22_700 vddd vssd sg13cmos5l_decap_8
X_5925_ _5925_/Y _5945_/A _5925_/B vddd vssd sg13cmos5l_nor2_1
XFILLER_0_91 vddd vssd sg13cmos5l_decap_8
X_5856_ _5856_/Y _5851_/Y _5852_/X _5855_/Y vddd vssd sg13cmos5l_o21ai_1
X_4807_ _4807_/Y _4807_/A _4807_/B vddd vssd sg13cmos5l_nor2_1
XFILLER_13_1918 vddd vssd sg13cmos5l_decap_8
X_5787_ _5788_/B _5816_/A _7211_/Q _5786_/Y vddd vssd sg13cmos5l_o21ai_1
X_4738_ _4738_/Y _4713_/A _4737_/Y _4735_/Y vddd vssd sg13cmos5l_a21oi_1
X_4669_ _4669_/X _4373_/A _4659_/Y _4668_/Y vddd vssd sg13cmos5l_a21o_1
Xhold940 _5953_/B _5949_/Y vddd vssd sg13cmos5l_dlygate4sd3_1
X_6408_ _7152_/D _6408_/A1 _6411_/S _6407_/Y vddd vssd sg13cmos5l_a21oi_1
XFILLER_11_1664 vddd vssd sg13cmos5l_decap_8
Xhold973 hold973/X _4951_/A vddd vssd sg13cmos5l_dlygate4sd3_1
X_7388_ _7388_/Q _7388_/CLK _7388_/D _6802_/Y vddd vssd sg13cmos5l_dfrbpq_1
Xhold951 _6570_/A _7240_/Q vddd vssd sg13cmos5l_dlygate4sd3_1
Xhold962 _7350_/D _4405_/Y vddd vssd sg13cmos5l_dlygate4sd3_1
XFILLER_27_1126 vddd vssd sg13cmos5l_decap_8
Xhold995 _6726_/A _7061_/Q vddd vssd sg13cmos5l_dlygate4sd3_1
Xclkbuf_1_1__f_clk outbuffers\[18\]/A clkbuf_0_clk/X vddd vssd sg13cmos5l_buf_8
Xhold984 _3604_/A _7105_/Q vddd vssd sg13cmos5l_dlygate4sd3_1
X_6339_ _6339_/Y _6339_/A _6343_/B vddd vssd sg13cmos5l_nand2_1
XFILLER_29_343 vddd vssd sg13cmos5l_decap_8
XFILLER_28_65 vddd vssd sg13cmos5l_decap_8
XFILLER_22_2483 vddd vssd sg13cmos5l_decap_8
XFILLER_29_376 vddd vssd sg13cmos5l_decap_8
XFILLER_2_2599 vddd vssd sg13cmos5l_decap_8
XFILLER_18_1807 vddd vssd sg13cmos5l_decap_4
XFILLER_2_1898 vddd vssd sg13cmos5l_decap_4
XFILLER_25_593 vddd vssd sg13cmos5l_decap_8
XFILLER_9_704 vddd vssd sg13cmos5l_decap_4
XFILLER_9_715 vddd vssd sg13cmos5l_decap_8
XFILLER_12_243 vddd vssd sg13cmos5l_decap_4
XFILLER_16_1553 vddd vssd sg13cmos5l_decap_8
Xtiedowns\[74\] mask_rev_in[30] vddd vssd sg13cmos5l_antennanp
XFILLER_10_1141 vddd vssd sg13cmos5l_decap_8
XFILLER_5_58 vddd vssd sg13cmos5l_decap_8
XFILLER_27_2383 vddd vssd sg13cmos5l_decap_8
XFILLER_7_2466 vddd vssd sg13cmos5l_decap_8
XFILLER_23_1524 vddd vssd sg13cmos5l_decap_8
XFILLER_23_1502 vddd vssd sg13cmos5l_decap_8
XFILLER_21_1270 vddd vssd sg13cmos5l_decap_8
X_3971_ _3971_/Y _7064_/Q _4145_/B vddd vssd sg13cmos5l_nor2_1
X_5710_ _5710_/Y _5705_/Y _5706_/X _5709_/Y vddd vssd sg13cmos5l_o21ai_1
XFILLER_31_563 vddd vssd sg13cmos5l_decap_4
X_6690_ _6690_/X _6690_/A0 _5028_/A _6690_/S vddd vssd sg13cmos5l_mux2_1
X_5641_ _5642_/D _5897_/A _7188_/Q _5651_/A vddd vssd sg13cmos5l_nor3_1
X_5572_ _5572_/Y _5550_/B _5550_/C _5571_/Y vddd vssd sg13cmos5l_a21oi_1
XFILLER_15_1041 vddd vssd sg13cmos5l_decap_8
X_4523_ _4524_/B _4614_/B _3610_/Y _4522_/Y vddd vssd sg13cmos5l_a21oi_1
XFILLER_15_1096 vddd vssd sg13cmos5l_decap_8
X_7311_ _7311_/Q _7396_/CLK _7311_/D _6824_/Y vddd vssd sg13cmos5l_dfrbpq_1
XFILLER_8_770 vddd vssd sg13cmos5l_decap_4
XFILLER_12_1951 vddd vssd sg13cmos5l_decap_8
X_7242_ _7242_/Q _7285_/CLK _7242_/D fanout388/X vddd vssd sg13cmos5l_dfrbpq_1
X_4454_ _4492_/B _4526_/B _4545_/A _4542_/B vddd vssd sg13cmos5l_nand3_1
X_7173_ _7173_/Q _7180_/CLK _7173_/D fanout366/X vddd vssd sg13cmos5l_dfrbpq_1
X_4385_ _4387_/C _4815_/A _7114_/Q _3528_/Y _4614_/A _4372_/X vddd vssd sg13cmos5l_a221oi_1
X_6124_ _6124_/Y _6120_/Y _6121_/Y _6123_/Y vddd vssd sg13cmos5l_o21ai_1
XFILLER_6_1231 vddd vssd sg13cmos5l_decap_8
X_6055_ _6057_/A _5136_/B _5271_/B _5120_/A _6203_/A _6054_/Y vddd vssd sg13cmos5l_a221oi_1
X_5006_ _5266_/C _7278_/Q _7279_/Q vddd vssd sg13cmos5l_nand2b_1
XFILLER_22_1078 vddd vssd sg13cmos5l_decap_8
X_6957_ _6957_/Y _6958_/A _6957_/B_N vddd vssd sg13cmos5l_nor2b_1
XFILLER_17_2574 vddd vssd sg13cmos5l_decap_8
X_5908_ _5911_/B _5908_/A _5908_/B _5908_/C vddd vssd sg13cmos5l_nand3_1
X_6888_ _6888_/Y _6910_/A _6892_/B_N vddd vssd sg13cmos5l_nor2b_1
XFILLER_13_2427 vddd vssd sg13cmos5l_decap_8
X_5839_ _5839_/Y _7312_/Q _5854_/B vddd vssd sg13cmos5l_nor2b_1
XFILLER_14_56 vddd vssd sg13cmos5l_decap_8
XFILLER_30_77 vddd vssd sg13cmos5l_decap_8
Xhold770 hold770/X _3599_/Y vddd vssd sg13cmos5l_dlygate4sd3_1
Xhold781 _6764_/A _7084_/Q vddd vssd sg13cmos5l_dlygate4sd3_1
XFILLER_24_2534 vddd vssd sg13cmos5l_decap_8
Xhold792 hold792/X _7093_/Q vddd vssd sg13cmos5l_dlygate4sd3_1
XFILLER_18_803 vddd vssd sg13cmos5l_decap_8
Xhold1470 _7048_/D _6705_/X vddd vssd sg13cmos5l_dlygate4sd3_1
XFILLER_29_151 vddd vssd sg13cmos5l_decap_8
XFILLER_18_836 vddd vssd sg13cmos5l_decap_8
Xhold1492 _3621_/A _7073_/Q vddd vssd sg13cmos5l_dlygate4sd3_1
Xhold1481 hold1481/X _7380_/Q vddd vssd sg13cmos5l_dlygate4sd3_1
XFILLER_2_1662 vddd vssd sg13cmos5l_decap_4
XFILLER_18_1637 vddd vssd sg13cmos5l_decap_8
XFILLER_31_2538 vddd vssd sg13cmos5l_decap_8
XFILLER_29_2401 vddd vssd sg13cmos5l_decap_8
XFILLER_29_2478 vddd vssd sg13cmos5l_decap_8
XFILLER_9_2528 vddd vssd sg13cmos5l_decap_8
XFILLER_29_1766 vddd vssd sg13cmos5l_decap_8
X_4170_ wire3/A _4168_/Y _4169_/Y _3748_/Y vddd vssd sg13cmos5l_o21ai_1
XFILLER_23_2022 vddd vssd sg13cmos5l_decap_8
XFILLER_23_2077 vddd vssd sg13cmos5l_decap_8
XFILLER_23_1310 vddd vssd sg13cmos5l_decap_8
X_6811_ _6811_/Y _6838_/A _6834_/B_N vddd vssd sg13cmos5l_nor2b_1
XFILLER_23_338 vddd vssd sg13cmos5l_decap_8
X_6742_ _7073_/D _6742_/A1 _6745_/S _6741_/Y vddd vssd sg13cmos5l_o21ai_1
X_3954_ _3954_/Y _3954_/A _3966_/B vddd vssd sg13cmos5l_nor2_1
XFILLER_32_894 vddd vssd sg13cmos5l_decap_8
Xoutbuffers\[1\] reset _6828_/A vddd vssd sg13cmos5l_buf_16
X_6673_ _6678_/S _6673_/A _6673_/B vddd vssd sg13cmos5l_and2_1
XFILLER_17_1158 vddd vssd sg13cmos5l_decap_8
X_3885_ _3885_/Y _3878_/Y _3881_/Y _3884_/Y vddd vssd sg13cmos5l_o21ai_1
X_5624_ _5626_/B _7184_/Q _7185_/Q _5624_/C vddd vssd sg13cmos5l_nor3_1
X_5555_ _5555_/Y _7335_/Q _7179_/Q vddd vssd sg13cmos5l_nand2b_1
X_4506_ _4507_/C _4506_/A1 _4492_/Y _4505_/Y vddd vssd sg13cmos5l_a21o_1
X_5486_ _5486_/X _5485_/X _5683_/A _5486_/S vddd vssd sg13cmos5l_mux2_1
X_4437_ _4438_/B _6973_/D _4437_/B vddd vssd sg13cmos5l_nand2_1
X_7225_ _7225_/Q _7295_/CLK _7225_/D fanout377/X vddd vssd sg13cmos5l_dfrbpq_1
XFILLER_28_1221 vddd vssd sg13cmos5l_decap_4
Xwire4 wire4/X wire5/X vddd vssd sg13cmos5l_buf_4
X_7156_ _7156_/Q _7364_/CLK _7156_/D fanout360/X vddd vssd sg13cmos5l_dfrbpq_1
X_6107_ _6107_/Y _6151_/A _6106_/C _5187_/A vddd vssd sg13cmos5l_a21oi_1
X_4368_ _4368_/Y _6189_/A _7127_/Q vddd vssd sg13cmos5l_nand2_1
Xclkbuf_4_1__f_clk_regs _7396_/CLK clkbuf_3_0_0_clk_regs/X vddd vssd sg13cmos5l_buf_8
X_4299_ _4299_/X _4279_/B _4301_/B _4282_/A vddd vssd sg13cmos5l_a21o_1
X_7087_ _7087_/Q _7105_/CLK _7087_/D _6863_/B_N vddd vssd sg13cmos5l_dfrbpq_1
X_6038_ _6038_/Y _6038_/A _6037_/Y vddd vssd sg13cmos5l_nor2b_1
XFILLER_27_644 vddd vssd sg13cmos5l_decap_4
XFILLER_6_1083 vddd vssd sg13cmos5l_decap_8
XFILLER_26_154 vddd vssd sg13cmos5l_decap_8
X_6901__471 _7389_/CLK _7364_/CLK vddd vssd sg13cmos5l_inv_1
XFILLER_25_44 vddd vssd sg13cmos5l_decap_8
XFILLER_10_500 vddd vssd sg13cmos5l_decap_8
XFILLER_22_393 vddd vssd sg13cmos5l_decap_4
XFILLER_13_1545 vddd vssd sg13cmos5l_decap_8
XFILLER_30_2571 vddd vssd sg13cmos5l_decap_8
XFILLER_11_1280 vddd vssd sg13cmos5l_decap_8
XFILLER_8_2550 vddd vssd sg13cmos5l_decap_8
Xtiedowns\[37\] dbus_in_right[5] vddd vssd sg13cmos5l_antennanp
XFILLER_4_2436 vddd vssd sg13cmos5l_decap_8
XFILLER_8_2594 vddd vssd sg13cmos5l_decap_8
XFILLER_20_1516 vddd vssd sg13cmos5l_decap_8
XFILLER_20_1549 vddd vssd sg13cmos5l_decap_8
XFILLER_18_677 vddd vssd sg13cmos5l_decap_8
XFILLER_18_655 vddd vssd sg13cmos5l_decap_4
XFILLER_32_168 vddd vssd sg13cmos5l_decap_8
XFILLER_31_2335 vddd vssd sg13cmos5l_decap_8
X_3670_ _3708_/A _3750_/C _3750_/D vddd vssd sg13cmos5l_nor2b_1
X_5340_ _5340_/Y _5338_/Y _5340_/B vddd vssd sg13cmos5l_nand2b_1
X_5271_ _6254_/S _5271_/A _5271_/B vddd vssd sg13cmos5l_nand2_1
X_7010_ _7010_/Q _7340_/CLK _7010_/D _6957_/Y vddd vssd sg13cmos5l_dfrbpq_1
X_4222_ _4222_/Y _7156_/Q _3955_/Y _4139_/B vddd vssd sg13cmos5l_o21ai_1
XFILLER_9_2336 vddd vssd sg13cmos5l_decap_8
XFILLER_25_2139 vddd vssd sg13cmos5l_decap_8
XFILLER_9_1635 vddd vssd sg13cmos5l_decap_8
XFILLER_29_1596 vddd vssd sg13cmos5l_decap_8
XFILLER_25_1449 vddd vssd sg13cmos5l_decap_8
X_4153_ _4153_/Y _7139_/Q _6378_/A vddd vssd sg13cmos5l_nor2_1
XFILLER_7_2071 vddd vssd sg13cmos5l_decap_4
X_4084_ _4084_/Y _4081_/Y _4082_/Y hold586/X vddd vssd sg13cmos5l_o21ai_1
Xoutbuffers\[20\] voltgen_source[1] _7068_/Q vddd vssd sg13cmos5l_buf_16
X_4986_ _6270_/A _5220_/A _5255_/A vddd vssd sg13cmos5l_nand2b_1
X_6725_ _6732_/S _6725_/A _6725_/B vddd vssd sg13cmos5l_nand2_1
XFILLER_23_168 vddd vssd sg13cmos5l_decap_8
X_3937_ _3937_/Y _3937_/A _3937_/B vddd vssd sg13cmos5l_nand2_1
XFILLER_32_691 vddd vssd sg13cmos5l_decap_8
XFILLER_14_2555 vddd vssd sg13cmos5l_decap_8
X_3868_ _3868_/Y _6622_/A _6622_/B vddd vssd sg13cmos5l_nor2_1
X_6656_ _6656_/Y _6656_/A1 _6658_/S _6655_/Y vddd vssd sg13cmos5l_o21ai_1
X_5607_ _5609_/A _5607_/A _7184_/Q _7185_/Q vddd vssd sg13cmos5l_nor3_1
X_3799_ _3799_/Y _7049_/Q _6699_/A wire59/X vddd vssd sg13cmos5l_a21oi_1
X_6587_ _6587_/X _6587_/A0 _6599_/A _6588_/S vddd vssd sg13cmos5l_mux2_1
X_5538_ _5538_/X _5626_/A _5538_/B vddd vssd sg13cmos5l_and2_1
XFILLER_11_35 vddd vssd sg13cmos5l_decap_8
X_7208_ _7208_/Q _7217_/CLK _7208_/D fanout372/X vddd vssd sg13cmos5l_dfrbpq_1
X_5469_ _5470_/D _3544_/A _5483_/B _7167_/Q vddd vssd sg13cmos5l_o21ai_1
Xfanout332 _6693_/A1 _6505_/A1 vddd vssd sg13cmos5l_buf_1
Xfanout321 _6048_/A _4196_/X vddd vssd sg13cmos5l_buf_1
Xfanout310 _5393_/B hold1408/X vddd vssd sg13cmos5l_buf_1
X_7139_ _7139_/Q _7180_/CLK _7139_/D fanout357/X vddd vssd sg13cmos5l_dfrbpq_1
Xfanout365 fanout365/X fanout366/X vddd vssd sg13cmos5l_buf_1
Xfanout343 _6909_/B_N _6911_/B_N vddd vssd sg13cmos5l_buf_1
Xfanout354 _6906_/B_N fanout363/X vddd vssd sg13cmos5l_buf_1
Xfanout387 fanout387/X fanout418/X vddd vssd sg13cmos5l_buf_1
Xfanout398 fanout398/X fanout400/X vddd vssd sg13cmos5l_buf_1
Xfanout376 fanout376/X fanout377/X vddd vssd sg13cmos5l_buf_1
XFILLER_21_2526 vddd vssd sg13cmos5l_decap_8
XFILLER_21_1858 vddd vssd sg13cmos5l_decap_8
XFILLER_19_2499 vddd vssd sg13cmos5l_decap_8
XFILLER_32_1943 vddd vssd sg13cmos5l_decap_8
XFILLER_13_2043 vddd vssd sg13cmos5l_decap_8
XFILLER_7_824 vddd vssd sg13cmos5l_decap_8
XFILLER_7_835 vddd vssd sg13cmos5l_decap_4
XFILLER_32_1987 vddd vssd sg13cmos5l_decap_8
XFILLER_7_879 vddd vssd sg13cmos5l_decap_8
XFILLER_26_2448 vddd vssd sg13cmos5l_decap_8
XFILLER_26_1714 vddd vssd sg13cmos5l_decap_4
XFILLER_28_7 vddd vssd sg13cmos5l_decap_4
XFILLER_26_1769 vddd vssd sg13cmos5l_decap_8
XFILLER_20_2025 vddd vssd sg13cmos5l_decap_8
XFILLER_24_1460 vddd vssd sg13cmos5l_decap_8
XFILLER_24_1482 vddd vssd sg13cmos5l_decap_8
XFILLER_19_920 vddd vssd sg13cmos5l_decap_4
XFILLER_8_1690 vddd vssd sg13cmos5l_decap_8
X_4840_ _4840_/Y _4839_/B _4838_/Y hold657/X vddd vssd sg13cmos5l_o21ai_1
Xoutbuffers\[110\] dbus_out[13] _5684_/Y vddd vssd sg13cmos5l_buf_16
XFILLER_18_1264 vddd vssd sg13cmos5l_decap_8
X_4771_ _4771_/Y _4771_/A _4771_/B vddd vssd sg13cmos5l_nand2_1
X_6510_ _6516_/S _6510_/A _6660_/B vddd vssd sg13cmos5l_nand2_1
X_3722_ _3722_/Y _3718_/Y _6241_/A _3712_/Y vddd vssd sg13cmos5l_a21oi_1
XFILLER_9_161 vddd vssd sg13cmos5l_decap_8
XFILLER_9_150 vddd vssd sg13cmos5l_decap_8
XFILLER_14_1117 vddd vssd sg13cmos5l_decap_8
X_6441_ _6441_/Y _6465_/A _6441_/B vddd vssd sg13cmos5l_nor2_1
X_3653_ _5285_/C _4835_/A _4833_/B vddd vssd sg13cmos5l_nor2b_1
X_6372_ _6372_/Y _6372_/A _6376_/B vddd vssd sg13cmos5l_nand2_1
X_5323_ _5323_/Y _5604_/A1 _5296_/Y _5322_/Y vddd vssd sg13cmos5l_a21oi_1
X_3584_ _5812_/A _3584_/A vddd vssd sg13cmos5l_inv_1
Xoutbuffers\[68\] idac1_value[0] _7034_/Q vddd vssd sg13cmos5l_buf_16
X_5254_ _6204_/A _5271_/A _5254_/B vddd vssd sg13cmos5l_nand2_1
X_5185_ _5188_/B _5246_/B _5215_/B _5176_/Y vddd vssd sg13cmos5l_o21ai_1
X_4205_ _4205_/Y _5812_/A _6517_/A _6510_/A vddd vssd sg13cmos5l_a21oi_1
XFILLER_25_1268 vddd vssd sg13cmos5l_decap_8
XFILLER_3_80 vddd vssd sg13cmos5l_decap_4
XFILLER_9_1487 vddd vssd sg13cmos5l_decap_8
X_4136_ _4136_/Y _4133_/Y _4134_/Y _4135_/Y vddd vssd sg13cmos5l_o21ai_1
XFILLER_20_2570 vddd vssd sg13cmos5l_decap_8
X_4067_ _4067_/Y _7116_/Q _4242_/A2 _4067_/B1 vddd vssd sg13cmos5l_a21oi_1
XFILLER_3_1053 vddd vssd sg13cmos5l_decap_4
Xwire31 wire31/X wire31/A vddd vssd sg13cmos5l_buf_4
XFILLER_25_956 vddd vssd sg13cmos5l_decap_8
XFILLER_19_1017 vddd vssd sg13cmos5l_decap_8
XFILLER_0_1996 vddd vssd sg13cmos5l_decap_8
XFILLER_24_499 vddd vssd sg13cmos5l_decap_8
X_4969_ _4969_/Y _4965_/B _4968_/Y _4967_/Y vddd vssd sg13cmos5l_o21ai_1
XFILLER_12_639 vddd vssd sg13cmos5l_decap_8
XFILLER_32_1228 vddd vssd sg13cmos5l_decap_8
X_6708_ _6746_/B _6708_/A _6759_/C vddd vssd sg13cmos5l_nor2_1
XFILLER_22_56 vddd vssd sg13cmos5l_decap_8
X_6639_ _6639_/X hold923/X _6632_/A _6641_/S vddd vssd sg13cmos5l_mux2_1
XFILLER_20_694 vddd vssd sg13cmos5l_decap_8
XFILLER_14_1640 vddd vssd sg13cmos5l_decap_4
XFILLER_10_2227 vddd vssd sg13cmos5l_decap_4
Xfanout140 _4782_/A _4460_/X vddd vssd sg13cmos5l_buf_1
XFILLER_23_1909 vddd vssd sg13cmos5l_decap_8
Xfanout151 _4794_/B1 _4485_/Y vddd vssd sg13cmos5l_buf_1
Xfanout173 _6330_/A _7381_/Q vddd vssd sg13cmos5l_buf_1
Xfanout195 _6678_/A1 fanout200/X vddd vssd sg13cmos5l_buf_1
XFILLER_5_2575 vddd vssd sg13cmos5l_decap_8
Xfanout184 _6465_/A _6501_/A vddd vssd sg13cmos5l_buf_1
XFILLER_21_1644 vddd vssd sg13cmos5l_decap_8
XFILLER_15_422 vddd vssd sg13cmos5l_decap_8
XFILLER_30_447 vddd vssd sg13cmos5l_decap_4
XFILLER_8_14 vddd vssd sg13cmos5l_decap_8
XFILLER_15_1437 vddd vssd sg13cmos5l_decap_8
XFILLER_32_2496 vddd vssd sg13cmos5l_decap_8
XFILLER_7_643 vddd vssd sg13cmos5l_decap_4
XFILLER_13_1150 vddd vssd sg13cmos5l_decap_8
XFILLER_13_1194 vddd vssd sg13cmos5l_decap_8
XFILLER_28_1809 vddd vssd sg13cmos5l_decap_8
XFILLER_3_882 vddd vssd sg13cmos5l_decap_8
X_6990_ _6990_/Q _7341_/CLK _6990_/D _6937_/Y vddd vssd sg13cmos5l_dfrbpq_1
XFILLER_25_219 vddd vssd sg13cmos5l_decap_8
X_5941_ _5941_/Y _5942_/A _5942_/B vddd vssd sg13cmos5l_nor2_1
XFILLER_4_1373 vddd vssd sg13cmos5l_decap_8
XFILLER_20_1176 vddd vssd sg13cmos5l_decap_8
X_5872_ _5872_/Y _3546_/A _5887_/B _5870_/Y vddd vssd sg13cmos5l_o21ai_1
X_4823_ _4823_/Y _4818_/Y _4823_/A2 _4822_/Y vddd vssd sg13cmos5l_o21ai_1
X_4754_ _4754_/Y _4733_/B _4753_/Y _4696_/A vddd vssd sg13cmos5l_o21ai_1
X_3705_ _3705_/Y _3842_/B _3876_/B vddd vssd sg13cmos5l_nand2_1
XFILLER_15_1971 vddd vssd sg13cmos5l_decap_8
X_4685_ _4685_/Y _4814_/A1 _3603_/Y _4773_/B1 _4684_/X vddd vssd sg13cmos5l_a22oi_1
XFILLER_11_2547 vddd vssd sg13cmos5l_decap_8
X_3636_ _4289_/B _4298_/A _4282_/A _4279_/B vddd vssd sg13cmos5l_nand3_1
X_6424_ _7161_/D _6424_/A1 _6427_/B _6423_/Y vddd vssd sg13cmos5l_a21oi_1
Xclkbuf_leaf_13_SCK_regs _7187_/CLK clkload4/A vddd vssd sg13cmos5l_buf_8
X_3567_ _5527_/B _3567_/A vddd vssd sg13cmos5l_inv_1
X_6355_ _6355_/X hold890/X _6743_/A _6360_/S vddd vssd sg13cmos5l_mux2_1
X_6286_ _6286_/Y _6290_/A vddd vssd sg13cmos5l_inv_1
X_5306_ _5320_/C _7140_/Q _5306_/B vddd vssd sg13cmos5l_nand2_1
XFILLER_0_307 vddd vssd sg13cmos5l_decap_8
X_5237_ _5241_/B _5237_/A _5237_/B vddd vssd sg13cmos5l_nand2_1
X_3498_ _4624_/A _7336_/Q vddd vssd sg13cmos5l_inv_1
X_5168_ _5171_/A _5168_/A _5168_/B _5168_/C _5168_/D vddd vssd sg13cmos5l_nor4_1
X_5099_ _5102_/B _5099_/A _5270_/B vddd vssd sg13cmos5l_nand2_1
X_4119_ _4119_/Y _7217_/Q _6525_/A _6517_/A vddd vssd sg13cmos5l_a21oi_1
XFILLER_9_908 vddd vssd sg13cmos5l_decap_4
XFILLER_32_1003 vddd vssd sg13cmos5l_decap_8
XFILLER_16_2469 vddd vssd sg13cmos5l_decap_8
XFILLER_12_469 vddd vssd sg13cmos5l_decap_4
XFILLER_21_970 vddd vssd sg13cmos5l_decap_8
XFILLER_10_1334 vddd vssd sg13cmos5l_decap_4
XFILLER_3_178 vddd vssd sg13cmos5l_decap_4
XFILLER_27_2565 vddd vssd sg13cmos5l_decap_8
XFILLER_23_2418 vddd vssd sg13cmos5l_decap_8
XFILLER_21_2131 vddd vssd sg13cmos5l_decap_8
XFILLER_21_2186 vddd vssd sg13cmos5l_decap_8
XFILLER_19_2071 vddd vssd sg13cmos5l_decap_8
XFILLER_15_274 vddd vssd sg13cmos5l_decap_4
XFILLER_8_963 vddd vssd sg13cmos5l_decap_4
XFILLER_8_974 vddd vssd sg13cmos5l_decap_8
XFILLER_32_1570 vddd vssd sg13cmos5l_decap_8
X_4470_ _4471_/B _4545_/A _4599_/A _4599_/B vddd vssd sg13cmos5l_nor3_1
XFILLER_10_2580 vddd vssd sg13cmos5l_decap_8
XFILLER_28_1617 vddd vssd sg13cmos5l_decap_8
X_6140_ _6140_/Y _3819_/Y _6139_/A _6139_/Y vddd vssd sg13cmos5l_o21ai_1
X_6071_ _6072_/B _3768_/X _5141_/A _5137_/B vddd vssd sg13cmos5l_o21ai_1
XFILLER_6_1402 vddd vssd sg13cmos5l_decap_8
Xhold1129 _6626_/A0 _7274_/Q vddd vssd sg13cmos5l_dlygate4sd3_1
XFILLER_26_1352 vddd vssd sg13cmos5l_decap_8
X_5022_ _5022_/Y _5022_/A _5022_/B _5022_/C vddd vssd sg13cmos5l_nand3_1
Xhold1107 _4414_/A _3492_/Y vddd vssd sg13cmos5l_dlygate4sd3_1
Xhold1118 _3589_/A _7220_/Q vddd vssd sg13cmos5l_dlygate4sd3_1
XFILLER_17_0 vddd vssd sg13cmos5l_decap_8
XFILLER_26_539 vddd vssd sg13cmos5l_decap_8
X_6973_ _6973_/Q _7001_/CLK _6973_/D _6920_/Y vddd vssd sg13cmos5l_dfrbpq_1
XFILLER_0_70 vddd vssd sg13cmos5l_decap_8
X_5924_ _5924_/Y _5942_/A _3596_/Y _5923_/Y vddd vssd sg13cmos5l_a21oi_1
XFILLER_0_1078 vddd vssd sg13cmos5l_decap_4
X_5855_ _5855_/Y _6233_/A _5853_/Y _5854_/Y vddd vssd sg13cmos5l_a21oi_1
X_4806_ _4807_/B _4806_/A1 _4801_/Y _4805_/Y vddd vssd sg13cmos5l_a21oi_1
X_5786_ _5786_/Y _5899_/A _5786_/B _5786_/C vddd vssd sg13cmos5l_nand3b_1
Xtiedowns\[3\] sram_odata[3] vddd vssd sg13cmos5l_antennanp
X_4737_ _4737_/Y _4737_/A _4737_/B vddd vssd sg13cmos5l_xnor2_1
XFILLER_11_1621 vddd vssd sg13cmos5l_decap_8
X_4668_ _4668_/Y _4373_/A _4659_/Y _4713_/A vddd vssd sg13cmos5l_o21ai_1
X_3619_ _3619_/Y _3619_/A vddd vssd sg13cmos5l_inv_1
Xhold930 _6965_/D _5934_/Y vddd vssd sg13cmos5l_dlygate4sd3_1
X_6407_ _6407_/Y _6518_/A _6411_/S vddd vssd sg13cmos5l_nor2_1
Xhold941 _5954_/B _5953_/Y vddd vssd sg13cmos5l_dlygate4sd3_1
Xhold952 hold952/X _6570_/Y vddd vssd sg13cmos5l_dlygate4sd3_1
Xhold963 _3514_/A _7312_/Q vddd vssd sg13cmos5l_dlygate4sd3_1
X_7387_ _7387_/Q _7387_/CLK _7387_/D _6803_/Y vddd vssd sg13cmos5l_dfrbpq_1
X_4599_ _4599_/Y _4599_/A _4599_/B _4599_/C vddd vssd sg13cmos5l_nand3_1
Xhold996 hold996/X _6726_/Y vddd vssd sg13cmos5l_dlygate4sd3_1
Xhold974 _6577_/A _7244_/Q vddd vssd sg13cmos5l_dlygate4sd3_1
X_6338_ _7116_/D _6599_/A _6343_/B hold714/X vddd vssd sg13cmos5l_o21ai_1
XFILLER_0_126 vddd vssd sg13cmos5l_decap_8
Xhold985 hold985/X _3604_/Y vddd vssd sg13cmos5l_dlygate4sd3_1
X_6269_ _6270_/B _5021_/C _6267_/Y _6268_/Y vddd vssd sg13cmos5l_o21ai_1
XFILLER_9_1081 vddd vssd sg13cmos5l_decap_8
XFILLER_28_44 vddd vssd sg13cmos5l_decap_8
XFILLER_22_2462 vddd vssd sg13cmos5l_decap_8
XFILLER_28_99 vddd vssd sg13cmos5l_decap_8
XFILLER_2_2578 vddd vssd sg13cmos5l_decap_8
XFILLER_18_2509 vddd vssd sg13cmos5l_decap_8
XFILLER_25_572 vddd vssd sg13cmos5l_decap_8
XFILLER_16_1532 vddd vssd sg13cmos5l_decap_8
XFILLER_12_277 vddd vssd sg13cmos5l_decap_8
XFILLER_12_1418 vddd vssd sg13cmos5l_decap_8
Xtiedowns\[67\] mask_rev_in[23] vddd vssd sg13cmos5l_antennanp
XFILLER_5_37 vddd vssd sg13cmos5l_decap_8
XFILLER_5_966 vddd vssd sg13cmos5l_decap_4
XFILLER_27_2362 vddd vssd sg13cmos5l_decap_8
XFILLER_7_2445 vddd vssd sg13cmos5l_decap_8
XFILLER_7_1744 vddd vssd sg13cmos5l_decap_8
XFILLER_7_1788 vddd vssd sg13cmos5l_decap_4
XFILLER_10_7 vddd vssd sg13cmos5l_decap_4
X_3970_ _3970_/Y _5304_/A _3966_/Y _3968_/Y _3965_/Y _3969_/X vddd vssd sg13cmos5l_a221oi_1
X_5640_ _5657_/B _7188_/Q _5651_/A vddd vssd sg13cmos5l_nor2_1
X_5571_ _5571_/Y _5571_/A _5571_/B _5571_/C vddd vssd sg13cmos5l_nor3_1
X_4522_ _4522_/Y _4526_/B _4614_/B vddd vssd sg13cmos5l_nor2_1
X_7310_ _7310_/Q _7396_/CLK _7310_/D _6823_/Y vddd vssd sg13cmos5l_dfrbpq_1
XFILLER_12_1930 vddd vssd sg13cmos5l_decap_8
X_4453_ _4520_/B _4545_/A _4542_/B vddd vssd sg13cmos5l_nand2_1
X_7241_ _7241_/Q _7285_/CLK _7241_/D fanout388/X vddd vssd sg13cmos5l_dfrbpq_1
XFILLER_7_292 vddd vssd sg13cmos5l_decap_4
XFILLER_12_1985 vddd vssd sg13cmos5l_decap_8
X_7172_ _7172_/Q _7187_/CLK _7172_/D fanout366/X vddd vssd sg13cmos5l_dfrbpq_1
X_4384_ _4387_/B _4384_/A _4384_/B _4384_/C _4384_/D vddd vssd sg13cmos5l_nor4_1
Xclkbuf_4_0__f_clk_regs _7395_/CLK clkbuf_3_0_0_clk_regs/X vddd vssd sg13cmos5l_buf_8
X_6123_ _6123_/Y _7289_/Q _6123_/B vddd vssd sg13cmos5l_nor2_1
Xoutbuffers\[50\] bandgap_trim[11] _6297_/Y vddd vssd sg13cmos5l_buf_16
X_6054_ _6054_/Y _3820_/X _5095_/Y _6052_/Y _6053_/Y _5120_/A vddd vssd sg13cmos5l_a221oi_1
X_5005_ _5215_/A _5228_/A _7277_/Q vddd vssd sg13cmos5l_nand2_1
XFILLER_6_1287 vddd vssd sg13cmos5l_decap_8
X_6956_ _6956_/Y _6956_/A _6957_/B_N vddd vssd sg13cmos5l_nor2b_1
X_5907_ _5908_/C _5907_/A _5907_/B _5907_/C vddd vssd sg13cmos5l_nor3_1
XFILLER_17_2553 vddd vssd sg13cmos5l_decap_8
X_6887_ _6887_/Y _6911_/A _6909_/B_N vddd vssd sg13cmos5l_nor2b_1
XFILLER_14_35 vddd vssd sg13cmos5l_decap_8
XFILLER_22_564 vddd vssd sg13cmos5l_decap_8
X_5838_ _5853_/C _7216_/Q _7217_/Q vddd vssd sg13cmos5l_nand2_1
X_5769_ _5769_/Y _5769_/A _5769_/B _5769_/C vddd vssd sg13cmos5l_nor3_1
XFILLER_30_56 vddd vssd sg13cmos5l_decap_8
Xhold760 hold760/X _3529_/Y vddd vssd sg13cmos5l_dlygate4sd3_1
Xhold771 _7100_/D _6791_/Y vddd vssd sg13cmos5l_dlygate4sd3_1
Xhold782 hold782/X _6764_/Y vddd vssd sg13cmos5l_dlygate4sd3_1
XFILLER_24_2513 vddd vssd sg13cmos5l_decap_8
Xhold793 _7093_/D _6780_/X vddd vssd sg13cmos5l_dlygate4sd3_1
XFILLER_29_130 vddd vssd sg13cmos5l_decap_8
Xhold1460 _7047_/D _6704_/X vddd vssd sg13cmos5l_dlygate4sd3_1
XFILLER_20_1709 vddd vssd sg13cmos5l_decap_8
Xhold1493 _6742_/A1 _6287_/A vddd vssd sg13cmos5l_dlygate4sd3_1
Xhold1471 hold1471/X _7329_/Q vddd vssd sg13cmos5l_dlygate4sd3_1
Xhold1482 _7381_/D _4265_/X vddd vssd sg13cmos5l_dlygate4sd3_1
XFILLER_22_1591 vddd vssd sg13cmos5l_decap_8
XFILLER_31_2517 vddd vssd sg13cmos5l_decap_8
XFILLER_13_564 vddd vssd sg13cmos5l_decap_8
XFILLER_16_2085 vddd vssd sg13cmos5l_decap_8
XFILLER_9_2507 vddd vssd sg13cmos5l_decap_8
XFILLER_29_2457 vddd vssd sg13cmos5l_decap_8
XFILLER_23_2001 vddd vssd sg13cmos5l_decap_4
XFILLER_7_1563 vddd vssd sg13cmos5l_decap_8
XFILLER_7_2286 vddd vssd sg13cmos5l_decap_8
X_6810_ _6810_/Y _6837_/A _6877_/B_N vddd vssd sg13cmos5l_nor2b_1
X_6741_ _6741_/Y _6790_/A _6745_/S vddd vssd sg13cmos5l_nand2_1
XFILLER_16_391 vddd vssd sg13cmos5l_decap_8
X_3953_ _3953_/Y _3947_/Y _3950_/Y _3952_/Y vddd vssd sg13cmos5l_o21ai_1
XFILLER_32_873 vddd vssd sg13cmos5l_decap_8
X_6672_ _6672_/X _6672_/A0 _6678_/A1 _6681_/S vddd vssd sg13cmos5l_mux2_1
X_3884_ _3884_/Y _7259_/Q _3879_/Y _3882_/Y vddd vssd sg13cmos5l_a21oi_1
X_5623_ _5623_/Y _5623_/A _5623_/B _5623_/C vddd vssd sg13cmos5l_nor3_1
XFILLER_30_1315 vddd vssd sg13cmos5l_decap_8
Xoutbuffers\[98\] dbus_out[1] _5349_/Y vddd vssd sg13cmos5l_buf_16
X_5554_ _5554_/X _7176_/Q _7177_/Q vddd vssd sg13cmos5l_and2_1
X_4505_ _4505_/Y _4506_/A1 _4492_/Y _4713_/A vddd vssd sg13cmos5l_o21ai_1
X_5485_ _5485_/X _5571_/A _5483_/Y _5484_/Y vddd vssd sg13cmos5l_a21o_1
XFILLER_28_1200 vddd vssd sg13cmos5l_decap_8
X_4436_ _4438_/A _4436_/A _4436_/B vddd vssd sg13cmos5l_nor2_1
X_7224_ _7224_/Q _7295_/CLK _7224_/D _6825_/B_N vddd vssd sg13cmos5l_dfrbpq_1
X_7155_ _7155_/Q _7171_/CLK _7155_/D fanout360/X vddd vssd sg13cmos5l_dfrbpq_1
Xwire5 wire5/X wire5/A vddd vssd sg13cmos5l_buf_4
XFILLER_8_1316 vddd vssd sg13cmos5l_decap_8
XFILLER_8_2028 vddd vssd sg13cmos5l_decap_4
XFILLER_8_2039 vddd vssd sg13cmos5l_decap_8
X_4367_ _4367_/Y _4452_/A _7125_/Q vddd vssd sg13cmos5l_nand2_1
X_6106_ _6106_/X _6243_/A _6106_/B _6106_/C vddd vssd sg13cmos5l_or3_1
XFILLER_8_1349 vddd vssd sg13cmos5l_decap_8
XFILLER_28_1288 vddd vssd sg13cmos5l_decap_8
X_4298_ _4298_/Y _4298_/A _4300_/A vddd vssd sg13cmos5l_xnor2_1
X_7086_ _7086_/Q _7105_/CLK _7086_/D _6863_/B_N vddd vssd sg13cmos5l_dfrbpq_1
X_6037_ _6037_/Y _4194_/X _5089_/A _7285_/Q vddd vssd sg13cmos5l_a21oi_1
XFILLER_26_133 vddd vssd sg13cmos5l_decap_8
XFILLER_15_818 vddd vssd sg13cmos5l_decap_4
XFILLER_25_23 vddd vssd sg13cmos5l_decap_8
XFILLER_19_1903 vddd vssd sg13cmos5l_decap_8
X_6939_ _6939_/Y _6959_/A _6958_/B_N vddd vssd sg13cmos5l_nor2b_1
XFILLER_19_1925 vddd vssd sg13cmos5l_decap_8
XFILLER_23_862 vddd vssd sg13cmos5l_decap_8
XFILLER_17_2350 vddd vssd sg13cmos5l_decap_8
XFILLER_30_2550 vddd vssd sg13cmos5l_decap_8
XFILLER_10_589 vddd vssd sg13cmos5l_decap_8
Xhold590 _7387_/D _3857_/Y vddd vssd sg13cmos5l_dlygate4sd3_1
XFILLER_28_2490 vddd vssd sg13cmos5l_decap_8
XFILLER_2_16 vddd vssd sg13cmos5l_decap_8
XFILLER_24_1631 vddd vssd sg13cmos5l_decap_8
XFILLER_24_2387 vddd vssd sg13cmos5l_decap_8
XFILLER_8_1894 vddd vssd sg13cmos5l_decap_4
Xhold1290 _4922_/A1 _3518_/Y vddd vssd sg13cmos5l_dlygate4sd3_1
XFILLER_2_1471 vddd vssd sg13cmos5l_decap_8
XFILLER_32_147 vddd vssd sg13cmos5l_decap_8
XFILLER_14_895 vddd vssd sg13cmos5l_decap_8
XFILLER_16_1170 vddd vssd sg13cmos5l_decap_4
X_5270_ _5270_/Y _6194_/B _5270_/B vddd vssd sg13cmos5l_nand2_1
X_4221_ _4221_/Y _7160_/Q _3951_/Y _4219_/Y _4220_/Y _3954_/Y vddd vssd sg13cmos5l_a221oi_1
XFILLER_7_2050 vddd vssd sg13cmos5l_decap_4
X_4152_ _4152_/Y _3615_/Y _3828_/Y _3983_/B vddd vssd sg13cmos5l_a21oi_1
X_4083_ _4083_/Y _4083_/A _4173_/B vddd vssd sg13cmos5l_nand2_1
XFILLER_7_1360 vddd vssd sg13cmos5l_decap_8
Xclkbuf_leaf_38_SCK_regs _7171_/CLK clkload2/A vddd vssd sg13cmos5l_buf_8
Xoutbuffers\[13\] proj_sel[0] _7018_/Q vddd vssd sg13cmos5l_buf_16
XFILLER_23_147 vddd vssd sg13cmos5l_decap_8
X_4985_ _5274_/A _5149_/B _5148_/A vddd vssd sg13cmos5l_nand2b_1
X_6724_ _6724_/X _5028_/A _6724_/A1 _6724_/S vddd vssd sg13cmos5l_mux2_1
X_3936_ _6459_/A _3937_/A _3937_/B vddd vssd sg13cmos5l_and2_1
XFILLER_32_670 vddd vssd sg13cmos5l_decap_8
XFILLER_20_832 vddd vssd sg13cmos5l_decap_8
XFILLER_14_2534 vddd vssd sg13cmos5l_decap_8
XFILLER_31_191 vddd vssd sg13cmos5l_decap_8
X_3867_ _3872_/C _7024_/Q _4176_/A2 _6652_/A _4979_/A vddd vssd sg13cmos5l_a22oi_1
X_6655_ _6655_/Y _6655_/A _6658_/S vddd vssd sg13cmos5l_nand2_1
XFILLER_14_1833 vddd vssd sg13cmos5l_decap_4
X_5606_ _5631_/C _7184_/Q _5615_/B vddd vssd sg13cmos5l_nand2_1
XFILLER_20_898 vddd vssd sg13cmos5l_decap_4
X_3798_ wire59/A _7135_/Q _4155_/B _6349_/A vddd vssd sg13cmos5l_o21ai_1
X_6586_ _6586_/X _6586_/A0 _6605_/A _6588_/S vddd vssd sg13cmos5l_mux2_1
XFILLER_11_14 vddd vssd sg13cmos5l_decap_8
XFILLER_30_1178 vddd vssd sg13cmos5l_decap_8
X_5537_ _5537_/Y _5594_/A _5535_/B _5535_/Y _5529_/Y _5538_/B vddd vssd sg13cmos5l_a221oi_1
X_7207_ _7207_/Q _7217_/CLK _7207_/D fanout371/X vddd vssd sg13cmos5l_dfrbpq_1
X_5468_ _5470_/C _5607_/A _7164_/Q _7165_/Q vddd vssd sg13cmos5l_nor3_1
XFILLER_28_1030 vddd vssd sg13cmos5l_decap_4
Xfanout300 _5620_/B hold1425/X vddd vssd sg13cmos5l_buf_1
Xfanout322 _6144_/A _6278_/A vddd vssd sg13cmos5l_buf_1
X_4419_ _4419_/Y _4419_/A _4419_/B vddd vssd sg13cmos5l_nand2_1
X_5399_ _5399_/Y _7154_/Q _5396_/X _5401_/B _7152_/Q _5398_/Y vddd vssd sg13cmos5l_a221oi_1
Xfanout311 _5363_/B hold1379/X vddd vssd sg13cmos5l_buf_1
Xfanout366 fanout366/X fanout370/X vddd vssd sg13cmos5l_buf_1
Xfanout333 _6735_/A1 _6505_/A1 vddd vssd sg13cmos5l_buf_1
Xfanout355 _6820_/B_N fanout358/X vddd vssd sg13cmos5l_buf_1
XFILLER_21_2505 vddd vssd sg13cmos5l_decap_8
X_7138_ _7138_/Q _7378_/CLK _7138_/D fanout357/X vddd vssd sg13cmos5l_dfrbpq_1
Xfanout344 _6911_/B_N fanout346/X vddd vssd sg13cmos5l_buf_1
Xfanout388 fanout388/X fanout394/X vddd vssd sg13cmos5l_buf_1
Xfanout399 fanout399/X fanout400/X vddd vssd sg13cmos5l_buf_1
X_7069_ _7069_/Q _7069_/CLK _7069_/D fanout361/X vddd vssd sg13cmos5l_dfrbpq_1
Xfanout377 fanout377/X fanout378/X vddd vssd sg13cmos5l_buf_1
XFILLER_27_486 vddd vssd sg13cmos5l_decap_8
XFILLER_15_637 vddd vssd sg13cmos5l_decap_8
XFILLER_32_2601 vddd vssd sg13cmos5l_decap_4
XFILLER_19_2478 vddd vssd sg13cmos5l_decap_8
XFILLER_14_158 vddd vssd sg13cmos5l_decap_4
XFILLER_23_670 vddd vssd sg13cmos5l_decap_8
XFILLER_11_843 vddd vssd sg13cmos5l_decap_4
XFILLER_32_1922 vddd vssd sg13cmos5l_decap_8
XFILLER_7_803 vddd vssd sg13cmos5l_decap_8
XFILLER_10_397 vddd vssd sg13cmos5l_decap_8
XFILLER_26_2427 vddd vssd sg13cmos5l_decap_8
XFILLER_26_1748 vddd vssd sg13cmos5l_decap_8
XFILLER_8_1680 vddd vssd sg13cmos5l_decap_4
XFILLER_8_2392 vddd vssd sg13cmos5l_decap_4
XFILLER_4_1544 vddd vssd sg13cmos5l_decap_8
XFILLER_18_420 vddd vssd sg13cmos5l_decap_8
XFILLER_21_629 vddd vssd sg13cmos5l_decap_8
XFILLER_21_607 vddd vssd sg13cmos5l_decap_8
Xoutbuffers\[103\] dbus_out[6] _5486_/X vddd vssd sg13cmos5l_buf_16
X_4770_ _4770_/Y _4681_/A _4769_/Y _4750_/Y vddd vssd sg13cmos5l_o21ai_1
XFILLER_14_681 vddd vssd sg13cmos5l_decap_8
X_3721_ _6241_/A dbus_in_left[7] dbus_in_right[7] vddd vssd sg13cmos5l_or2_1
X_6440_ _6440_/X _6455_/A _6440_/A1 _6441_/B vddd vssd sg13cmos5l_mux2_1
X_3652_ _5285_/B _3652_/A vddd vssd sg13cmos5l_inv_1
X_6371_ _7134_/D _5028_/A _6370_/B hold755/X vddd vssd sg13cmos5l_o21ai_1
X_3583_ _5786_/C _3583_/A vddd vssd sg13cmos5l_inv_1
X_5322_ _5322_/Y _5428_/A _5320_/Y _5321_/Y _5319_/Y _5296_/Y vddd vssd sg13cmos5l_a221oi_1
XFILLER_29_2095 vddd vssd sg13cmos5l_decap_4
X_5253_ _6206_/S _5265_/A _5253_/B vddd vssd sg13cmos5l_nand2_1
X_5184_ _5187_/D _5256_/B _5219_/B vddd vssd sg13cmos5l_nor2_1
X_4204_ _4204_/Y _4202_/Y _4204_/B vddd vssd sg13cmos5l_nand2b_1
X_4135_ _4135_/Y _7165_/Q _6429_/A _6420_/A vddd vssd sg13cmos5l_a21oi_1
Xwire10 wire9/A wire10/A vddd vssd sg13cmos5l_buf_2
X_4066_ _4066_/Y _7132_/Q _3705_/Y _4065_/Y vddd vssd sg13cmos5l_o21ai_1
XFILLER_25_913 vddd vssd sg13cmos5l_decap_8
Xwire21 wire21/X wire22/X vddd vssd sg13cmos5l_buf_4
XFILLER_3_1098 vddd vssd sg13cmos5l_decap_8
XFILLER_24_467 vddd vssd sg13cmos5l_decap_8
XFILLER_11_128 vddd vssd sg13cmos5l_decap_4
X_4968_ _4968_/Y _4968_/A _4968_/B vddd vssd sg13cmos5l_xnor2_1
XFILLER_32_1207 vddd vssd sg13cmos5l_decap_8
X_6707_ _6707_/X _6328_/A _6707_/A1 _6707_/S vddd vssd sg13cmos5l_mux2_1
X_3919_ _3919_/X _3919_/A _3919_/B vddd vssd sg13cmos5l_or2_1
X_4899_ _4899_/Y _4899_/A _4899_/B _4899_/C vddd vssd sg13cmos5l_nor3_1
XFILLER_22_35 vddd vssd sg13cmos5l_decap_8
X_6638_ _7280_/D _6701_/A1 _6641_/S hold836/X vddd vssd sg13cmos5l_a21oi_1
XFILLER_10_2206 vddd vssd sg13cmos5l_decap_8
X_6569_ _6575_/S _6569_/A _6615_/C vddd vssd sg13cmos5l_nor2_1
Xfanout130 _6459_/B _6673_/B vddd vssd sg13cmos5l_buf_1
Xfanout152 _4609_/A _4433_/Y vddd vssd sg13cmos5l_buf_1
Xfanout141 _4713_/A _4460_/X vddd vssd sg13cmos5l_buf_1
XFILLER_5_2554 vddd vssd sg13cmos5l_decap_8
Xfanout163 _5994_/S _5999_/S vddd vssd sg13cmos5l_buf_1
Xfanout196 _6544_/A _6703_/A0 vddd vssd sg13cmos5l_buf_1
Xfanout185 _6501_/A _6665_/A0 vddd vssd sg13cmos5l_buf_1
XFILLER_21_1623 vddd vssd sg13cmos5l_decap_8
XFILLER_21_1667 vddd vssd sg13cmos5l_decap_4
XFILLER_19_1541 vddd vssd sg13cmos5l_decap_8
XFILLER_15_1416 vddd vssd sg13cmos5l_decap_8
XFILLER_32_2475 vddd vssd sg13cmos5l_decap_8
XFILLER_11_673 vddd vssd sg13cmos5l_decap_4
XFILLER_11_684 vddd vssd sg13cmos5l_decap_8
XFILLER_32_1796 vddd vssd sg13cmos5l_decap_8
XFILLER_7_699 vddd vssd sg13cmos5l_decap_8
XFILLER_4_2086 vddd vssd sg13cmos5l_decap_4
X_5940_ _5940_/Y _5954_/A _5942_/B _5940_/C vddd vssd sg13cmos5l_nor3_1
X_5871_ _5871_/Y _5899_/A _5871_/B _5887_/A vddd vssd sg13cmos5l_nor3_1
X_4822_ _4822_/Y _4482_/B _4813_/A _4484_/C vddd vssd sg13cmos5l_a21oi_1
XFILLER_18_1051 vddd vssd sg13cmos5l_decap_8
X_4753_ _4753_/Y _4778_/A _4776_/A vddd vssd sg13cmos5l_nor2b_1
X_3704_ _3948_/A _3737_/B _4002_/D vddd vssd sg13cmos5l_or2_1
XFILLER_11_2526 vddd vssd sg13cmos5l_decap_8
X_4684_ _4684_/X _6797_/A _7004_/D vddd vssd sg13cmos5l_xor2_1
X_6423_ _6423_/Y _6470_/A _6427_/B vddd vssd sg13cmos5l_nor2_1
Xoutbuffers\[80\] io_oe[7] _5226_/Y vddd vssd sg13cmos5l_buf_16
X_3635_ _4308_/B _4298_/A _4282_/A _4279_/B vddd vssd sg13cmos5l_and3_1
X_6354_ _6354_/X hold799/X _6599_/A _6360_/S vddd vssd sg13cmos5l_mux2_1
X_3566_ _5495_/B _3566_/A vddd vssd sg13cmos5l_inv_1
X_6285_ _6290_/A _7074_/Q _6285_/B vddd vssd sg13cmos5l_nor2_1
X_5305_ _5305_/Y _5532_/A _5317_/B _5316_/A vddd vssd sg13cmos5l_o21ai_1
X_3497_ _4452_/A _4599_/A vddd vssd sg13cmos5l_inv_1
X_5236_ _5236_/Y _5244_/C vddd vssd sg13cmos5l_inv_1
XFILLER_9_1252 vddd vssd sg13cmos5l_decap_8
XFILLER_25_1055 vddd vssd sg13cmos5l_decap_8
XFILLER_5_1127 vddd vssd sg13cmos5l_decap_4
X_5167_ _5169_/D _7240_/Q _7241_/Q _5208_/B vddd vssd sg13cmos5l_nor3_1
X_5098_ _5270_/B _7272_/Q _7273_/Q vddd vssd sg13cmos5l_nor2b_1
X_4118_ _4118_/Y _4115_/Y _4116_/X _4117_/Y vddd vssd sg13cmos5l_o21ai_1
XFILLER_17_35 vddd vssd sg13cmos5l_decap_8
X_4049_ _4049_/Y _7158_/Q _6412_/A _4047_/Y _4048_/Y _6406_/A vddd vssd sg13cmos5l_a221oi_1
XFILLER_17_68 vddd vssd sg13cmos5l_decap_8
XFILLER_0_2462 vddd vssd sg13cmos5l_decap_8
XFILLER_16_2448 vddd vssd sg13cmos5l_decap_8
XFILLER_24_297 vddd vssd sg13cmos5l_decap_8
XFILLER_16_1736 vddd vssd sg13cmos5l_decap_8
XFILLER_12_448 vddd vssd sg13cmos5l_decap_8
XFILLER_32_1059 vddd vssd sg13cmos5l_decap_8
XFILLER_27_2544 vddd vssd sg13cmos5l_decap_8
XFILLER_0_864 vddd vssd sg13cmos5l_decap_8
Xtiedowns\[12\] io_in[4] vddd vssd sg13cmos5l_antennanp
XFILLER_21_1475 vddd vssd sg13cmos5l_decap_8
XFILLER_1_1547 vddd vssd sg13cmos5l_decap_4
XFILLER_19_2050 vddd vssd sg13cmos5l_decap_8
XFILLER_30_256 vddd vssd sg13cmos5l_decap_8
XFILLER_15_1279 vddd vssd sg13cmos5l_decap_8
XFILLER_7_441 vddd vssd sg13cmos5l_decap_4
XFILLER_7_496 vddd vssd sg13cmos5l_decap_8
X_6070_ _6072_/A _5139_/C _6068_/X _6069_/Y vddd vssd sg13cmos5l_a21oi_1
XFILLER_6_2137 vddd vssd sg13cmos5l_decap_8
X_5021_ _5022_/C _6276_/B _5021_/B _5021_/C _6279_/A vddd vssd sg13cmos5l_nor4_1
Xhold1108 _4415_/B _4414_/Y vddd vssd sg13cmos5l_dlygate4sd3_1
Xhold1119 _6535_/A1 _5867_/A vddd vssd sg13cmos5l_dlygate4sd3_1
X_6972_ _6972_/Q _7351_/CLK _6972_/D _6919_/Y vddd vssd sg13cmos5l_dfrbpq_1
X_5923_ _5923_/Y _5919_/Y _5920_/Y _5922_/Y vddd vssd sg13cmos5l_a21oi_1
X_5854_ _5854_/Y _5854_/A _5854_/B _5854_/C vddd vssd sg13cmos5l_nor3_1
X_4805_ _4805_/Y _4780_/B _4796_/Y _4805_/B1 vddd vssd sg13cmos5l_o21ai_1
XFILLER_22_779 vddd vssd sg13cmos5l_decap_8
X_5785_ _5788_/A _5783_/X _5784_/Y _5786_/C vddd vssd sg13cmos5l_a21oi_1
XFILLER_30_790 vddd vssd sg13cmos5l_decap_4
X_4736_ _4737_/B _4740_/A _4736_/B vddd vssd sg13cmos5l_or2_1
X_4667_ _4667_/Y _4755_/A _4643_/C _4552_/A vddd vssd sg13cmos5l_a21oi_1
Xhold920 hold920/X _6623_/Y vddd vssd sg13cmos5l_dlygate4sd3_1
X_3618_ _3618_/Y _3618_/A vddd vssd sg13cmos5l_inv_1
X_7386_ _7386_/Q _7386_/CLK _7386_/D _6804_/Y vddd vssd sg13cmos5l_dfrbpq_1
X_6406_ _6411_/S _6406_/A _6725_/B vddd vssd sg13cmos5l_nand2_1
Xhold931 _3511_/A _7315_/Q vddd vssd sg13cmos5l_dlygate4sd3_1
Xhold942 _3606_/A _7107_/Q vddd vssd sg13cmos5l_dlygate4sd3_1
Xhold953 _6596_/A _7256_/Q vddd vssd sg13cmos5l_dlygate4sd3_1
X_6337_ _6337_/Y _6337_/A _6343_/B vddd vssd sg13cmos5l_nand2_1
Xhold964 hold964/X _3514_/Y vddd vssd sg13cmos5l_dlygate4sd3_1
X_4598_ _4601_/B _4452_/A _4590_/X _4597_/Y vddd vssd sg13cmos5l_a21oi_1
Xhold975 hold975/X _6577_/Y vddd vssd sg13cmos5l_dlygate4sd3_1
XFILLER_0_105 vddd vssd sg13cmos5l_decap_8
X_3549_ _6232_/A _5674_/A vddd vssd sg13cmos5l_inv_1
Xhold997 _4261_/A _7382_/Q vddd vssd sg13cmos5l_dlygate4sd3_1
Xhold986 _7105_/D _6314_/Y vddd vssd sg13cmos5l_dlygate4sd3_1
X_6268_ _6268_/Y _6112_/A _5021_/C _4997_/B vddd vssd sg13cmos5l_a21oi_1
XFILLER_28_23 vddd vssd sg13cmos5l_decap_8
X_5219_ _6156_/B _5219_/A _5219_/B vddd vssd sg13cmos5l_nor2_1
X_6199_ _6199_/Y _6112_/A _5252_/C _6198_/Y vddd vssd sg13cmos5l_o21ai_1
XFILLER_22_2441 vddd vssd sg13cmos5l_decap_8
XFILLER_2_1856 vddd vssd sg13cmos5l_decap_8
XFILLER_25_551 vddd vssd sg13cmos5l_decap_8
XFILLER_16_2223 vddd vssd sg13cmos5l_decap_4
XFILLER_16_2234 vddd vssd sg13cmos5l_decap_4
XFILLER_16_1511 vddd vssd sg13cmos5l_decap_8
XFILLER_8_205 vddd vssd sg13cmos5l_decap_8
XFILLER_8_227 vddd vssd sg13cmos5l_decap_8
XFILLER_16_1588 vddd vssd sg13cmos5l_decap_8
XFILLER_4_433 vddd vssd sg13cmos5l_decap_8
XFILLER_5_16 vddd vssd sg13cmos5l_decap_8
XFILLER_5_945 vddd vssd sg13cmos5l_decap_8
XFILLER_27_2341 vddd vssd sg13cmos5l_decap_8
XFILLER_4_488 vddd vssd sg13cmos5l_decap_8
XFILLER_23_2249 vddd vssd sg13cmos5l_decap_8
XFILLER_7_1723 vddd vssd sg13cmos5l_decap_8
XFILLER_7_1756 vddd vssd sg13cmos5l_decap_8
X_5570_ _5570_/Y _5571_/C _5566_/Y _5571_/B vddd vssd sg13cmos5l_a21oi_1
X_4521_ _4521_/Y _4492_/B _4520_/Y _4806_/A1 vddd vssd sg13cmos5l_a21oi_1
X_7240_ _7240_/Q _7285_/CLK _7240_/D fanout388/X vddd vssd sg13cmos5l_dfrbpq_1
X_4452_ _4542_/B _4452_/A _4624_/A _4590_/B vddd vssd sg13cmos5l_nor3_1
XFILLER_28_1426 vddd vssd sg13cmos5l_decap_8
X_7171_ _7171_/Q _7171_/CLK _7171_/D fanout365/X vddd vssd sg13cmos5l_dfrbpq_1
X_4383_ _4384_/D _4712_/A _7120_/Q vddd vssd sg13cmos5l_xnor2_1
X_6122_ _6123_/B _6122_/A _6122_/B vddd vssd sg13cmos5l_nor2_1
X_6053_ _6053_/Y _6138_/A _5120_/B _5095_/Y vddd vssd sg13cmos5l_a21oi_1
Xoutbuffers\[43\] bandgap_trim[4] _6292_/X vddd vssd sg13cmos5l_buf_16
X_5004_ _5008_/B _5004_/A _7274_/Q _5127_/A vddd vssd sg13cmos5l_nor3_1
X_6955_ _6955_/Y _6956_/A _6955_/B_N vddd vssd sg13cmos5l_nor2b_1
X_5906_ _5911_/A _5901_/Y _5905_/Y _3591_/Y vddd vssd sg13cmos5l_a21o_1
XFILLER_22_543 vddd vssd sg13cmos5l_decap_8
XFILLER_17_2532 vddd vssd sg13cmos5l_decap_8
X_6886_ _6886_/Y _6911_/A _6909_/B_N vddd vssd sg13cmos5l_nor2b_1
XFILLER_14_14 vddd vssd sg13cmos5l_decap_8
X_5837_ _5854_/C _7216_/Q _7217_/Q vddd vssd sg13cmos5l_nand2b_1
XFILLER_22_598 vddd vssd sg13cmos5l_decap_8
X_5768_ _5768_/Y _5763_/Y _5764_/X _5767_/Y vddd vssd sg13cmos5l_o21ai_1
XFILLER_13_1739 vddd vssd sg13cmos5l_decap_8
X_4719_ _4721_/B _4696_/A _4718_/Y _4716_/Y vddd vssd sg13cmos5l_o21ai_1
XFILLER_30_35 vddd vssd sg13cmos5l_decap_8
X_5699_ _5703_/B _5711_/C _5704_/C vddd vssd sg13cmos5l_nor2_1
XFILLER_11_2175 vddd vssd sg13cmos5l_decap_8
XFILLER_11_2164 vddd vssd sg13cmos5l_decap_8
Xhold750 _7095_/D _6782_/X vddd vssd sg13cmos5l_dlygate4sd3_1
X_7369_ _7369_/Q _7372_/CLK _7369_/D _6882_/Y vddd vssd sg13cmos5l_dfrbpq_1
Xhold761 _4890_/A hold824/X vddd vssd sg13cmos5l_dlygate4sd3_1
Xhold772 _4343_/A _7353_/Q vddd vssd sg13cmos5l_dlygate4sd3_1
Xhold783 _7084_/D _6765_/Y vddd vssd sg13cmos5l_dlygate4sd3_1
Xhold794 _3541_/A _7087_/Q vddd vssd sg13cmos5l_dlygate4sd3_1
XFILLER_7_1019 vddd vssd sg13cmos5l_decap_4
XFILLER_24_2569 vddd vssd sg13cmos5l_decap_8
Xhold1450 _4592_/A _7336_/Q vddd vssd sg13cmos5l_dlygate4sd3_1
Xhold1461 hold1461/X _7376_/Q vddd vssd sg13cmos5l_dlygate4sd3_1
XFILLER_29_186 vddd vssd sg13cmos5l_decap_8
XFILLER_22_1570 vddd vssd sg13cmos5l_decap_8
Xhold1483 hold1483/X _7199_/Q vddd vssd sg13cmos5l_dlygate4sd3_1
Xhold1472 _7329_/D _4770_/Y vddd vssd sg13cmos5l_dlygate4sd3_1
Xhold1494 hold488/A _7300_/Q vddd vssd sg13cmos5l_dlygate4sd3_1
XFILLER_32_329 vddd vssd sg13cmos5l_decap_8
XFILLER_18_1617 vddd vssd sg13cmos5l_decap_8
XFILLER_16_1330 vddd vssd sg13cmos5l_decap_4
XFILLER_9_525 vddd vssd sg13cmos5l_decap_8
XFILLER_12_1205 vddd vssd sg13cmos5l_decap_8
XFILLER_29_2436 vddd vssd sg13cmos5l_decap_8
XFILLER_5_742 vddd vssd sg13cmos5l_decap_8
XFILLER_7_2265 vddd vssd sg13cmos5l_decap_8
XFILLER_23_2046 vddd vssd sg13cmos5l_decap_8
XFILLER_3_2118 vddd vssd sg13cmos5l_decap_8
XFILLER_23_1345 vddd vssd sg13cmos5l_decap_8
XFILLER_7_1575 vddd vssd sg13cmos5l_decap_4
XFILLER_7_1586 vddd vssd sg13cmos5l_decap_8
X_6740_ _6740_/X _6740_/A0 _6788_/A _6745_/S vddd vssd sg13cmos5l_mux2_1
XFILLER_32_852 vddd vssd sg13cmos5l_decap_8
X_3952_ _3952_/Y _7167_/Q _6429_/A _6420_/A vddd vssd sg13cmos5l_a21oi_1
Xclkbuf_3_4_0_SCK_regs clkload5/A clkbuf_0_SCK_regs/X vddd vssd sg13cmos5l_buf_8
X_6671_ _6671_/X _6671_/A0 _6632_/A _6681_/S vddd vssd sg13cmos5l_mux2_1
X_3883_ _6589_/A _3896_/A _3883_/B vddd vssd sg13cmos5l_nand2_1
X_5622_ _5623_/C _5620_/X _5621_/X _5628_/C vddd vssd sg13cmos5l_a21oi_1
X_5553_ _5553_/Y _7176_/Q _5557_/B vddd vssd sg13cmos5l_nor2_1
X_4504_ _4507_/B _3530_/Y _4474_/X _4503_/X vddd vssd sg13cmos5l_o21ai_1
XFILLER_12_2484 vddd vssd sg13cmos5l_decap_8
XFILLER_6_70 vddd vssd sg13cmos5l_decap_8
X_5484_ _5484_/Y _5632_/A1 _5482_/A _5482_/Y _5477_/Y _5483_/Y vddd vssd sg13cmos5l_a221oi_1
XFILLER_12_1761 vddd vssd sg13cmos5l_decap_8
X_4435_ _4436_/B _4435_/A _4489_/A _4435_/C vddd vssd sg13cmos5l_nor3_1
X_7223_ _7223_/Q _7287_/CLK _7223_/D _6828_/B_N vddd vssd sg13cmos5l_dfrbpq_1
X_4366_ _4393_/C _4786_/B _4435_/A vddd vssd sg13cmos5l_nand2b_1
Xwire6 wire6/X wire6/A vddd vssd sg13cmos5l_buf_8
X_7154_ _7154_/Q _7399_/CLK _7154_/D fanout360/X vddd vssd sg13cmos5l_dfrbpq_1
X_6105_ _6105_/Y _4737_/A _6063_/B _6104_/Y vddd vssd sg13cmos5l_a21oi_1
X_4297_ _4300_/A _4273_/C _4301_/B vddd vssd sg13cmos5l_nand2b_1
X_7085_ _7085_/Q _7120_/CLK _7085_/D _6863_/B_N vddd vssd sg13cmos5l_dfrbpq_1
X_6036_ _6038_/A _6144_/A _5090_/C _6034_/Y _6035_/Y _5089_/A vddd vssd sg13cmos5l_a221oi_1
XFILLER_26_112 vddd vssd sg13cmos5l_decap_8
XFILLER_27_657 vddd vssd sg13cmos5l_decap_8
XFILLER_26_189 vddd vssd sg13cmos5l_decap_8
X_6938_ _6938_/Y _6958_/A _6958_/B_N vddd vssd sg13cmos5l_nor2b_1
XFILLER_25_79 vddd vssd sg13cmos5l_decap_8
XFILLER_23_841 vddd vssd sg13cmos5l_decap_8
X_6869_ _6869_/Y _6881_/A _6909_/B_N vddd vssd sg13cmos5l_nor2b_1
XFILLER_17_1661 vddd vssd sg13cmos5l_decap_4
XFILLER_10_535 vddd vssd sg13cmos5l_decap_8
XFILLER_17_1683 vddd vssd sg13cmos5l_decap_8
XFILLER_13_1514 vddd vssd sg13cmos5l_decap_8
XFILLER_30_1861 vddd vssd sg13cmos5l_decap_4
XFILLER_11_1260 vddd vssd sg13cmos5l_decap_4
XFILLER_29_1009 vddd vssd sg13cmos5l_decap_8
Xclkbuf_leaf_8_SCK_regs _7379_/CLK clkload3/A vddd vssd sg13cmos5l_buf_8
Xhold580 hold580/X _4173_/Y vddd vssd sg13cmos5l_dlygate4sd3_1
Xhold591 _6541_/A _7224_/Q vddd vssd sg13cmos5l_dlygate4sd3_1
XFILLER_24_2366 vddd vssd sg13cmos5l_decap_8
XFILLER_24_1687 vddd vssd sg13cmos5l_decap_8
Xhold1280 _6722_/A1 _7058_/Q vddd vssd sg13cmos5l_dlygate4sd3_1
Xhold1291 _7308_/D _4922_/Y vddd vssd sg13cmos5l_dlygate4sd3_1
XFILLER_18_2115 vddd vssd sg13cmos5l_decap_8
XFILLER_32_126 vddd vssd sg13cmos5l_decap_8
XFILLER_18_2159 vddd vssd sg13cmos5l_decap_4
XFILLER_12_1035 vddd vssd sg13cmos5l_decap_8
XFILLER_29_2200 vddd vssd sg13cmos5l_decap_4
XFILLER_29_2277 vddd vssd sg13cmos5l_decap_8
XFILLER_29_1543 vddd vssd sg13cmos5l_decap_8
XFILLER_25_2119 vddd vssd sg13cmos5l_decap_4
X_4220_ _4220_/Y _5463_/A _6429_/A _6420_/A vddd vssd sg13cmos5l_a21oi_1
X_4151_ _4151_/Y _4148_/Y _4149_/Y _4150_/Y vddd vssd sg13cmos5l_o21ai_1
X_4082_ _4082_/Y _4173_/A _4258_/B _7017_/D vddd vssd sg13cmos5l_o21ai_1
XFILLER_3_1236 vddd vssd sg13cmos5l_decap_4
XFILLER_23_1197 vddd vssd sg13cmos5l_decap_8
XFILLER_24_638 vddd vssd sg13cmos5l_decap_8
XFILLER_23_126 vddd vssd sg13cmos5l_decap_8
X_4984_ _5255_/A _5149_/B _5148_/A vddd vssd sg13cmos5l_nor2b_1
X_6723_ _6723_/X _6404_/A _6723_/A1 _6724_/S vddd vssd sg13cmos5l_mux2_1
X_3935_ _3935_/Y _3934_/A _3937_/B _4212_/A2 _5651_/B _3932_/Y vddd vssd sg13cmos5l_a221oi_1
XFILLER_14_2513 vddd vssd sg13cmos5l_decap_8
XFILLER_31_170 vddd vssd sg13cmos5l_decap_8
XFILLER_20_811 vddd vssd sg13cmos5l_decap_8
X_6654_ _7292_/D _6701_/A1 _6658_/S _6654_/B1 vddd vssd sg13cmos5l_a21oi_1
X_5605_ _5605_/Y _7184_/Q _7185_/Q _5621_/B _5620_/B vddd vssd sg13cmos5l_nor4_1
X_3866_ _3866_/Y _3929_/A _4002_/C _3929_/B _3869_/B vddd vssd sg13cmos5l_nor4_1
XFILLER_20_877 vddd vssd sg13cmos5l_decap_8
XFILLER_14_1812 vddd vssd sg13cmos5l_decap_8
X_3797_ _3797_/Y _7076_/Q _6708_/A _3796_/Y vddd vssd sg13cmos5l_o21ai_1
X_6585_ _7248_/D _6333_/A _6588_/S _6585_/B1 vddd vssd sg13cmos5l_a21oi_1
XFILLER_30_1168 vddd vssd sg13cmos5l_decap_4
X_5536_ _5538_/B _7172_/Q _7173_/Q _5536_/C vddd vssd sg13cmos5l_nor3_1
X_5467_ _5483_/B _7165_/Q _7164_/Q vddd vssd sg13cmos5l_nand2b_1
X_4418_ _4418_/X _4403_/A _4421_/A _4397_/A vddd vssd sg13cmos5l_a21o_1
X_7206_ _7206_/Q _7206_/CLK _7206_/D fanout371/X vddd vssd sg13cmos5l_dfrbpq_1
Xfanout301 _5621_/B hold1440/X vddd vssd sg13cmos5l_buf_1
Xfanout312 _5304_/A hold1410/X vddd vssd sg13cmos5l_buf_1
Xfanout323 _6012_/A _6276_/A vddd vssd sg13cmos5l_buf_1
X_5398_ _5398_/Y _5398_/A _7154_/Q _7155_/Q _5398_/D vddd vssd sg13cmos5l_nor4_1
Xfanout334 _6482_/A1 _6505_/A1 vddd vssd sg13cmos5l_buf_1
Xfanout356 fanout356/X fanout358/X vddd vssd sg13cmos5l_buf_1
Xfanout345 _6892_/B_N fanout346/X vddd vssd sg13cmos5l_buf_1
XFILLER_8_1158 vddd vssd sg13cmos5l_decap_8
X_4349_ _4349_/Y _3487_/Y _4342_/B _4343_/B _3667_/Y vddd vssd sg13cmos5l_a22oi_1
X_7137_ _7137_/Q _7355_/CLK _7137_/D _6907_/B_N vddd vssd sg13cmos5l_dfrbpq_1
X_7068_ _7068_/Q _7143_/CLK _7068_/D fanout361/X vddd vssd sg13cmos5l_dfrbpq_1
Xfanout378 fanout378/X fanout379/X vddd vssd sg13cmos5l_buf_1
Xfanout389 fanout389/X fanout391/X vddd vssd sg13cmos5l_buf_1
Xfanout367 _6822_/B_N fanout368/X vddd vssd sg13cmos5l_buf_1
X_6019_ _6019_/Y _4464_/A _6041_/B _6018_/Y vddd vssd sg13cmos5l_o21ai_1
XFILLER_3_2460 vddd vssd sg13cmos5l_decap_8
XFILLER_28_955 vddd vssd sg13cmos5l_decap_8
XFILLER_27_443 vddd vssd sg13cmos5l_decap_8
XFILLER_19_2457 vddd vssd sg13cmos5l_decap_8
XFILLER_19_1723 vddd vssd sg13cmos5l_decap_4
XFILLER_32_1901 vddd vssd sg13cmos5l_decap_8
XFILLER_32_1967 vddd vssd sg13cmos5l_decap_4
XFILLER_13_2078 vddd vssd sg13cmos5l_decap_8
XFILLER_6_358 vddd vssd sg13cmos5l_decap_8
XFILLER_26_2406 vddd vssd sg13cmos5l_decap_8
XFILLER_7_0 vddd vssd sg13cmos5l_decap_8
Xtiedowns\[42\] dbus_in_right[10] vddd vssd sg13cmos5l_antennanp
XFILLER_4_2246 vddd vssd sg13cmos5l_decap_8
XFILLER_20_2049 vddd vssd sg13cmos5l_decap_8
XFILLER_19_977 vddd vssd sg13cmos5l_decap_8
XFILLER_0_1409 vddd vssd sg13cmos5l_decap_8
X_3720_ _6156_/A dbus_in_left[7] dbus_in_right[7] vddd vssd sg13cmos5l_nor2_1
X_3651_ _3651_/Y _5956_/B _3651_/B _5937_/A _3651_/D vddd vssd sg13cmos5l_nand4_1
X_6370_ _6370_/Y _6370_/A _6370_/B vddd vssd sg13cmos5l_nand2_1
X_3582_ _5753_/B _3582_/A vddd vssd sg13cmos5l_inv_1
X_5321_ _5321_/Y _5632_/A1 _5317_/Y _5320_/Y vddd vssd sg13cmos5l_a21oi_1
XFILLER_29_2041 vddd vssd sg13cmos5l_decap_4
X_5252_ _5262_/A _5252_/A _5252_/B _5252_/C _6191_/B vddd vssd sg13cmos5l_nand4_1
XFILLER_9_1412 vddd vssd sg13cmos5l_decap_4
X_5183_ _6120_/B _7243_/Q _5253_/B _7242_/Q vddd vssd sg13cmos5l_nand3b_1
X_4203_ _4204_/B _7216_/Q _6525_/A _6517_/A vddd vssd sg13cmos5l_a21oi_1
XFILLER_9_2179 vddd vssd sg13cmos5l_decap_8
X_4134_ _4134_/Y _7169_/Q _3946_/Y _3949_/Y vddd vssd sg13cmos5l_o21ai_1
XFILLER_28_218 vddd vssd sg13cmos5l_decap_8
XFILLER_7_1180 vddd vssd sg13cmos5l_decap_8
Xwire11 wire11/X wire11/A vddd vssd sg13cmos5l_buf_4
X_4065_ _4065_/Y _7124_/Q _4156_/A _4242_/A2 vddd vssd sg13cmos5l_a21oi_1
Xwire22 wire22/X wire22/A vddd vssd sg13cmos5l_buf_4
XFILLER_0_1965 vddd vssd sg13cmos5l_decap_8
Xwire99 wire99/X wire99/A vddd vssd sg13cmos5l_buf_2
XFILLER_16_1918 vddd vssd sg13cmos5l_decap_8
X_4967_ _4967_/Y _4968_/A _4967_/B vddd vssd sg13cmos5l_nand2_1
X_6706_ _6706_/X _6768_/A _6706_/A1 _6707_/S vddd vssd sg13cmos5l_mux2_1
XFILLER_22_14 vddd vssd sg13cmos5l_decap_8
X_3918_ _3918_/Y _3919_/A _3919_/B vddd vssd sg13cmos5l_nor2_1
X_4898_ _4899_/C _4898_/A _4898_/B vddd vssd sg13cmos5l_nand2_1
X_6637_ _6637_/Y _6637_/A _6641_/S vddd vssd sg13cmos5l_nor2_1
X_3849_ _3849_/Y _3627_/Y _4250_/A _4077_/B vddd vssd sg13cmos5l_a21oi_1
X_6568_ _6568_/X _6704_/A0 _6568_/A1 _6568_/S vddd vssd sg13cmos5l_mux2_1
X_5519_ _5521_/A _5607_/A _7172_/Q _7173_/Q vddd vssd sg13cmos5l_nor3_1
X_6499_ _6499_/X _6499_/A0 _6520_/A _6501_/B vddd vssd sg13cmos5l_mux2_1
XFILLER_0_7 vddd vssd sg13cmos5l_decap_8
Xfanout120 _6622_/A _3686_/X vddd vssd sg13cmos5l_buf_1
Xfanout131 _6660_/B _6673_/B vddd vssd sg13cmos5l_buf_1
XFILLER_5_2511 vddd vssd sg13cmos5l_decap_8
Xfanout142 _4002_/C _3869_/A vddd vssd sg13cmos5l_buf_1
Xfanout153 _4680_/A _4433_/Y vddd vssd sg13cmos5l_buf_1
XFILLER_5_2544 vddd vssd sg13cmos5l_decap_8
Xfanout164 _5999_/S _4489_/A vddd vssd sg13cmos5l_buf_1
XFILLER_25_2494 vddd vssd sg13cmos5l_decap_8
XFILLER_25_1760 vddd vssd sg13cmos5l_decap_8
Xfanout186 _6546_/A _6704_/A0 vddd vssd sg13cmos5l_buf_1
Xfanout175 _6328_/A _5030_/A vddd vssd sg13cmos5l_buf_1
Xfanout197 _6703_/A0 fanout200/X vddd vssd sg13cmos5l_buf_1
XFILLER_27_262 vddd vssd sg13cmos5l_decap_4
XFILLER_27_284 vddd vssd sg13cmos5l_decap_8
XFILLER_16_958 vddd vssd sg13cmos5l_decap_4
XFILLER_19_2265 vddd vssd sg13cmos5l_decap_8
XFILLER_19_1520 vddd vssd sg13cmos5l_decap_8
XFILLER_15_2107 vddd vssd sg13cmos5l_decap_4
XFILLER_19_2298 vddd vssd sg13cmos5l_decap_8
XFILLER_19_1586 vddd vssd sg13cmos5l_decap_8
XFILLER_8_49 vddd vssd sg13cmos5l_decap_8
XFILLER_32_2454 vddd vssd sg13cmos5l_decap_8
XFILLER_7_678 vddd vssd sg13cmos5l_decap_8
XFILLER_26_1546 vddd vssd sg13cmos5l_decap_8
XFILLER_6_1629 vddd vssd sg13cmos5l_decap_8
XFILLER_8_2190 vddd vssd sg13cmos5l_decap_4
XFILLER_24_1281 vddd vssd sg13cmos5l_decap_4
XFILLER_4_2065 vddd vssd sg13cmos5l_decap_8
XFILLER_0_1217 vddd vssd sg13cmos5l_decap_8
XFILLER_0_1239 vddd vssd sg13cmos5l_decap_8
X_5870_ _5870_/Y _5883_/C _5869_/Y _5887_/A vddd vssd sg13cmos5l_o21ai_1
X_4821_ _4821_/Y _4460_/B _4819_/Y _4820_/Y _4427_/Y vddd vssd sg13cmos5l_a22oi_1
X_4752_ _4752_/Y _4814_/A1 _3600_/Y _4773_/B1 _4751_/Y vddd vssd sg13cmos5l_a22oi_1
X_3703_ _6361_/B _3737_/B _4002_/D vddd vssd sg13cmos5l_nor2_1
X_4683_ _4683_/Y _4712_/A _4771_/B vddd vssd sg13cmos5l_nand2_1
XFILLER_11_2505 vddd vssd sg13cmos5l_decap_8
XFILLER_31_1241 vddd vssd sg13cmos5l_decap_8
X_3634_ _3634_/Y _4282_/A _4279_/B vddd vssd sg13cmos5l_nand2_1
X_6422_ _7160_/D _6482_/A1 _6427_/B hold893/X vddd vssd sg13cmos5l_o21ai_1
XFILLER_31_1285 vddd vssd sg13cmos5l_decap_8
X_3565_ _5497_/B _3565_/A vddd vssd sg13cmos5l_inv_1
X_6353_ _6353_/Y hold752/X _6360_/S _6352_/Y vddd vssd sg13cmos5l_o21ai_1
X_6284_ _6294_/B _7073_/Q _7074_/Q _7076_/Q vddd vssd sg13cmos5l_nor3_1
X_3496_ _3496_/Y _4577_/A vddd vssd sg13cmos5l_inv_1
X_5304_ _5317_/B _5304_/A _5304_/B vddd vssd sg13cmos5l_or2_1
Xoutbuffers\[73\] io_oe[0] _5063_/Y vddd vssd sg13cmos5l_buf_16
X_5235_ _5244_/C _7268_/Q _7269_/Q _5264_/A vddd vssd sg13cmos5l_nor3_1
XFILLER_29_1170 vddd vssd sg13cmos5l_decap_8
X_5166_ _5208_/B _7243_/Q _7242_/Q vddd vssd sg13cmos5l_nand2b_1
XFILLER_9_1297 vddd vssd sg13cmos5l_decap_8
X_5097_ _5102_/A _6043_/B _6130_/B _5095_/Y vddd vssd sg13cmos5l_a21oi_1
XFILLER_17_14 vddd vssd sg13cmos5l_decap_8
X_4117_ _4117_/Y _5871_/B _6533_/A _6525_/A vddd vssd sg13cmos5l_a21oi_1
Xclkbuf_leaf_22_SCK_regs _7127_/CLK clkload8/A vddd vssd sg13cmos5l_buf_8
XFILLER_0_2441 vddd vssd sg13cmos5l_decap_8
X_4048_ _4048_/Y _5447_/B _6420_/A _6412_/A vddd vssd sg13cmos5l_a21oi_1
XFILLER_24_210 vddd vssd sg13cmos5l_decap_8
XFILLER_22_1999 vddd vssd sg13cmos5l_decap_8
XFILLER_25_788 vddd vssd sg13cmos5l_decap_8
X_5999_ _5999_/X _5999_/A0 _5998_/Y _5999_/S vddd vssd sg13cmos5l_mux2_1
XFILLER_16_2427 vddd vssd sg13cmos5l_decap_8
XFILLER_16_1715 vddd vssd sg13cmos5l_decap_8
XFILLER_32_1038 vddd vssd sg13cmos5l_decap_8
XFILLER_14_2195 vddd vssd sg13cmos5l_decap_8
XFILLER_14_1461 vddd vssd sg13cmos5l_decap_8
XFILLER_3_103 vddd vssd sg13cmos5l_decap_8
XFILLER_27_2523 vddd vssd sg13cmos5l_decap_8
XFILLER_25_1590 vddd vssd sg13cmos5l_decap_8
XFILLER_5_1640 vddd vssd sg13cmos5l_decap_8
XFILLER_21_1454 vddd vssd sg13cmos5l_decap_8
XFILLER_1_2238 vddd vssd sg13cmos5l_decap_8
XFILLER_5_1695 vddd vssd sg13cmos5l_decap_4
XFILLER_30_213 vddd vssd sg13cmos5l_decap_8
XFILLER_11_482 vddd vssd sg13cmos5l_decap_8
XFILLER_12_994 vddd vssd sg13cmos5l_decap_8
XFILLER_6_2149 vddd vssd sg13cmos5l_decap_4
X_5020_ _6279_/A _5214_/A _5269_/A vddd vssd sg13cmos5l_nor2_1
Xhold1109 _7346_/D _4415_/Y vddd vssd sg13cmos5l_dlygate4sd3_1
XFILLER_26_519 vddd vssd sg13cmos5l_decap_4
X_6971_ _6971_/Q _7001_/CLK _6971_/D _6918_/Y vddd vssd sg13cmos5l_dfrbpq_1
X_5922_ _5922_/Y _5942_/A _3596_/Y _5921_/X vddd vssd sg13cmos5l_o21ai_1
X_5853_ _5853_/Y _5854_/A _5854_/B _5853_/C vddd vssd sg13cmos5l_nor3_1
XFILLER_22_747 vddd vssd sg13cmos5l_decap_8
X_5784_ _5784_/Y _5784_/A _7211_/Q vddd vssd sg13cmos5l_nand2_1
X_4804_ _4804_/Y _4803_/Y _4804_/B vddd vssd sg13cmos5l_nand2b_1
XFILLER_21_257 vddd vssd sg13cmos5l_decap_8
X_4735_ _4735_/Y _4755_/A _4710_/A _4734_/Y vddd vssd sg13cmos5l_a21oi_1
XFILLER_9_70 vddd vssd sg13cmos5l_decap_8
X_4666_ _4666_/Y _4670_/B _4670_/C vddd vssd sg13cmos5l_nand2_1
XFILLER_11_2368 vddd vssd sg13cmos5l_decap_8
XFILLER_31_1082 vddd vssd sg13cmos5l_decap_8
Xhold910 hold910/X _5585_/B vddd vssd sg13cmos5l_dlygate4sd3_1
X_3617_ _5967_/B _3617_/A vddd vssd sg13cmos5l_inv_1
Xhold921 _6511_/A _7208_/Q vddd vssd sg13cmos5l_dlygate4sd3_1
X_7385_ _7385_/Q _7385_/CLK _7385_/D _6805_/Y vddd vssd sg13cmos5l_dfrbpq_1
X_4597_ _4597_/Y _4452_/A _4590_/X _4782_/A vddd vssd sg13cmos5l_o21ai_1
X_6405_ _6405_/Y _6405_/A1 _6404_/B _6404_/Y vddd vssd sg13cmos5l_a21oi_1
Xhold943 hold943/X _3606_/Y vddd vssd sg13cmos5l_dlygate4sd3_1
Xhold954 hold954/X _6596_/Y vddd vssd sg13cmos5l_dlygate4sd3_1
X_6336_ _6336_/Y _6605_/A _6347_/B hold669/X vddd vssd sg13cmos5l_o21ai_1
X_3548_ _5903_/A _3548_/A vddd vssd sg13cmos5l_inv_1
Xhold932 hold932/X _6219_/A vddd vssd sg13cmos5l_dlygate4sd3_1
XFILLER_11_1678 vddd vssd sg13cmos5l_decap_8
Xhold987 _6661_/A _7018_/Q vddd vssd sg13cmos5l_dlygate4sd3_1
Xhold976 _6674_/A _7027_/Q vddd vssd sg13cmos5l_dlygate4sd3_1
Xhold965 _3603_/A _7104_/Q vddd vssd sg13cmos5l_dlygate4sd3_1
Xhold998 _4262_/C _4261_/Y vddd vssd sg13cmos5l_dlygate4sd3_1
X_3479_ _3479_/Y _4772_/B vddd vssd sg13cmos5l_inv_1
X_6267_ _6267_/Y _6156_/A _5008_/A _6265_/Y _6266_/Y vddd vssd sg13cmos5l_a22oi_1
XFILLER_22_2420 vddd vssd sg13cmos5l_decap_8
X_5218_ _5223_/D _6150_/B _6150_/C vddd vssd sg13cmos5l_nor2_1
X_6198_ _6198_/Y _5252_/C _6197_/X _5260_/D vddd vssd sg13cmos5l_a21oi_1
X_5149_ _5220_/B _5148_/A _5149_/B vddd vssd sg13cmos5l_nand2b_1
XFILLER_29_357 vddd vssd sg13cmos5l_decap_8
XFILLER_28_79 vddd vssd sg13cmos5l_decap_8
XFILLER_22_2497 vddd vssd sg13cmos5l_decap_8
XFILLER_22_1741 vddd vssd sg13cmos5l_decap_4
XFILLER_22_1785 vddd vssd sg13cmos5l_decap_8
XFILLER_2_1835 vddd vssd sg13cmos5l_decap_8
XFILLER_9_729 vddd vssd sg13cmos5l_decap_8
XFILLER_10_1133 vddd vssd sg13cmos5l_decap_4
XFILLER_10_1155 vddd vssd sg13cmos5l_decap_8
XFILLER_29_1928 vddd vssd sg13cmos5l_decap_8
XFILLER_27_2320 vddd vssd sg13cmos5l_decap_8
XFILLER_7_1702 vddd vssd sg13cmos5l_decap_8
XFILLER_27_2397 vddd vssd sg13cmos5l_decap_8
XFILLER_27_1663 vddd vssd sg13cmos5l_decap_8
XFILLER_1_2079 vddd vssd sg13cmos5l_decap_4
XFILLER_5_1492 vddd vssd sg13cmos5l_decap_4
XFILLER_1_1378 vddd vssd sg13cmos5l_decap_8
XFILLER_19_1180 vddd vssd sg13cmos5l_decap_8
XFILLER_15_1011 vddd vssd sg13cmos5l_decap_8
X_4520_ _4520_/Y _6189_/A _4520_/B vddd vssd sg13cmos5l_nand2_1
XFILLER_32_1380 vddd vssd sg13cmos5l_decap_8
X_4451_ _4568_/B _4624_/A _4590_/B vddd vssd sg13cmos5l_nor2_1
XFILLER_7_261 vddd vssd sg13cmos5l_decap_4
XFILLER_12_1965 vddd vssd sg13cmos5l_decap_8
X_7170_ _7170_/Q _7206_/CLK _7170_/D fanout365/X vddd vssd sg13cmos5l_dfrbpq_1
X_6121_ _6121_/Y _6118_/Y _6119_/Y _6122_/B vddd vssd sg13cmos5l_o21ai_1
X_4382_ _4384_/C _7331_/Q _7119_/Q _4369_/Y vddd vssd sg13cmos5l_o21ai_1
XFILLER_22_0 vddd vssd sg13cmos5l_decap_8
X_6052_ _6052_/Y _5120_/C _6050_/Y _6051_/Y vddd vssd sg13cmos5l_o21ai_1
X_5003_ _6194_/B _5004_/A _7274_/Q vddd vssd sg13cmos5l_nor2_1
XFILLER_22_1015 vddd vssd sg13cmos5l_decap_8
XFILLER_6_1245 vddd vssd sg13cmos5l_decap_8
XFILLER_22_1048 vddd vssd sg13cmos5l_decap_8
Xoutbuffers\[36\] biasgen_fine _7054_/Q vddd vssd sg13cmos5l_buf_16
X_6954_ _6954_/Y _6959_/A _6958_/B_N vddd vssd sg13cmos5l_nor2b_1
XFILLER_17_2511 vddd vssd sg13cmos5l_decap_8
X_5905_ _5905_/Y _5909_/B _5902_/X _5904_/Y _5674_/A _5903_/Y vddd vssd sg13cmos5l_a221oi_1
X_6885_ _6885_/Y _6885_/A _6885_/B_N vddd vssd sg13cmos5l_nor2b_1
XFILLER_17_2588 vddd vssd sg13cmos5l_decap_8
X_5836_ _5849_/A _5854_/A _5836_/B vddd vssd sg13cmos5l_nor2_1
X_5767_ _5767_/Y _5737_/A _5765_/Y _5766_/Y vddd vssd sg13cmos5l_a21oi_1
XFILLER_30_14 vddd vssd sg13cmos5l_decap_8
X_5698_ _5704_/C _5711_/B _5701_/B vddd vssd sg13cmos5l_nand2b_1
X_4718_ _4718_/Y _4740_/B _3602_/Y _4717_/Y vddd vssd sg13cmos5l_a21oi_1
X_4649_ _4649_/Y _4819_/A _4639_/Y _4648_/Y vddd vssd sg13cmos5l_o21ai_1
XFILLER_11_1475 vddd vssd sg13cmos5l_decap_8
Xhold740 _7351_/D _4395_/Y vddd vssd sg13cmos5l_dlygate4sd3_1
X_7368_ _7368_/Q _7372_/CLK _7368_/D _6881_/Y vddd vssd sg13cmos5l_dfrbpq_1
Xhold762 hold762/X _3539_/Y vddd vssd sg13cmos5l_dlygate4sd3_1
Xhold751 _3528_/A _7123_/Q vddd vssd sg13cmos5l_dlygate4sd3_1
Xhold773 _4345_/A _4343_/Y vddd vssd sg13cmos5l_dlygate4sd3_1
X_6319_ _6319_/Y hold943/X _6324_/B _6318_/Y vddd vssd sg13cmos5l_o21ai_1
Xhold784 _6762_/A _7083_/Q vddd vssd sg13cmos5l_dlygate4sd3_1
X_7299_ _7299_/Q _7393_/CLK _7299_/D _6812_/Y vddd vssd sg13cmos5l_dfrbpq_1
Xhold795 hold795/X _4360_/B vddd vssd sg13cmos5l_dlygate4sd3_1
XFILLER_28_1961 vddd vssd sg13cmos5l_decap_8
XFILLER_24_2548 vddd vssd sg13cmos5l_decap_8
Xhold1440 hold1440/X _7186_/Q vddd vssd sg13cmos5l_dlygate4sd3_1
Xhold1451 _7336_/D _4611_/X vddd vssd sg13cmos5l_dlygate4sd3_1
Xhold1462 _6703_/A1 _7046_/Q vddd vssd sg13cmos5l_dlygate4sd3_1
XFILLER_29_165 vddd vssd sg13cmos5l_decap_8
Xhold1484 hold1484/X _5711_/B vddd vssd sg13cmos5l_dlygate4sd3_1
Xhold1473 _4661_/A _7333_/Q vddd vssd sg13cmos5l_dlygate4sd3_1
Xhold1495 _5989_/A0 _4962_/A vddd vssd sg13cmos5l_dlygate4sd3_1
XFILLER_32_308 vddd vssd sg13cmos5l_decap_8
XFILLER_0_2090 vddd vssd sg13cmos5l_decap_8
XFILLER_16_2065 vddd vssd sg13cmos5l_decap_8
XFILLER_16_2043 vddd vssd sg13cmos5l_decap_8
Xtiedowns\[72\] mask_rev_in[28] vddd vssd sg13cmos5l_antennanp
XFILLER_5_710 vddd vssd sg13cmos5l_decap_8
XFILLER_29_2415 vddd vssd sg13cmos5l_decap_8
XFILLER_4_242 vddd vssd sg13cmos5l_decap_4
XFILLER_20_91 vddd vssd sg13cmos5l_decap_8
XFILLER_4_297 vddd vssd sg13cmos5l_decap_8
XFILLER_9_1808 vddd vssd sg13cmos5l_decap_8
XFILLER_27_2172 vddd vssd sg13cmos5l_decap_4
XFILLER_23_1324 vddd vssd sg13cmos5l_decap_8
XFILLER_0_492 vddd vssd sg13cmos5l_decap_8
XFILLER_24_809 vddd vssd sg13cmos5l_decap_4
XFILLER_21_1092 vddd vssd sg13cmos5l_decap_8
X_3951_ _3951_/Y _3951_/A _3966_/B vddd vssd sg13cmos5l_nor2_1
XFILLER_32_831 vddd vssd sg13cmos5l_decap_8
XFILLER_17_1106 vddd vssd sg13cmos5l_decap_4
X_6670_ _6670_/X _6670_/A0 _6546_/A _6681_/S vddd vssd sg13cmos5l_mux2_1
X_3882_ _3882_/Y _6615_/A _3911_/A vddd vssd sg13cmos5l_nor2_1
X_5621_ _5621_/X _5728_/A _5621_/B vddd vssd sg13cmos5l_or2_1
X_5552_ _5567_/C _7178_/Q _5552_/B vddd vssd sg13cmos5l_nand2_1
X_4503_ _4503_/X _4734_/A _4503_/B vddd vssd sg13cmos5l_and2_1
XFILLER_12_2463 vddd vssd sg13cmos5l_decap_8
X_5483_ _5483_/Y _5483_/A _5483_/B vddd vssd sg13cmos5l_nor2_1
X_4434_ _4435_/C _4427_/Y _4498_/A _4774_/B _4628_/A vddd vssd sg13cmos5l_a22oi_1
X_7222_ _7222_/Q _7287_/CLK _7222_/D _6828_/B_N vddd vssd sg13cmos5l_dfrbpq_1
XFILLER_6_93 vddd vssd sg13cmos5l_decap_8
X_4365_ _4393_/B hold738/X _4432_/A vddd vssd sg13cmos5l_nand2b_1
Xwire7 wire7/X wire8/X vddd vssd sg13cmos5l_buf_2
X_7153_ _7153_/Q _7364_/CLK _7153_/D fanout360/X vddd vssd sg13cmos5l_dfrbpq_1
X_7084_ _7084_/Q _7120_/CLK _7084_/D _6860_/B_N vddd vssd sg13cmos5l_dfrbpq_1
X_6104_ _6104_/Y _6104_/A1 _4979_/A _6063_/B vddd vssd sg13cmos5l_a21oi_1
X_6035_ _6035_/Y _4023_/X _5089_/C _5090_/C vddd vssd sg13cmos5l_a21oi_1
X_4296_ _4301_/B _4296_/A _4296_/B vddd vssd sg13cmos5l_nand2_1
XFILLER_6_1097 vddd vssd sg13cmos5l_decap_8
XFILLER_26_168 vddd vssd sg13cmos5l_decap_8
X_6937_ _6937_/Y _6958_/A _6957_/B_N vddd vssd sg13cmos5l_nor2b_1
XFILLER_25_58 vddd vssd sg13cmos5l_decap_8
X_6868_ _6868_/Y _6881_/A _6909_/B_N vddd vssd sg13cmos5l_nor2b_1
XFILLER_23_897 vddd vssd sg13cmos5l_decap_4
X_5819_ _5819_/X _5902_/A _7215_/Q vddd vssd sg13cmos5l_or2_1
X_6799_ _6799_/X _6799_/A vddd vssd sg13cmos5l_buf_1
XFILLER_30_2585 vddd vssd sg13cmos5l_decap_8
XFILLER_11_1250 vddd vssd sg13cmos5l_decap_4
Xhold581 _7384_/D _4174_/Y vddd vssd sg13cmos5l_dlygate4sd3_1
Xhold570 hold570/X _3786_/Y vddd vssd sg13cmos5l_dlygate4sd3_1
XFILLER_11_1294 vddd vssd sg13cmos5l_decap_8
Xhold592 hold592/X _6541_/Y vddd vssd sg13cmos5l_dlygate4sd3_1
XFILLER_8_2564 vddd vssd sg13cmos5l_decap_8
XFILLER_24_2345 vddd vssd sg13cmos5l_decap_8
XFILLER_4_1749 vddd vssd sg13cmos5l_decap_8
Xhold1270 _3581_/A _7203_/Q vddd vssd sg13cmos5l_dlygate4sd3_1
Xhold1281 _7058_/D _6722_/X vddd vssd sg13cmos5l_dlygate4sd3_1
Xhold1292 _3582_/A _7205_/Q vddd vssd sg13cmos5l_dlygate4sd3_1
XFILLER_32_105 vddd vssd sg13cmos5l_decap_8
XFILLER_18_1437 vddd vssd sg13cmos5l_decap_8
XFILLER_15_91 vddd vssd sg13cmos5l_decap_4
XFILLER_31_2349 vddd vssd sg13cmos5l_decap_8
XFILLER_5_562 vddd vssd sg13cmos5l_decap_8
XFILLER_9_1605 vddd vssd sg13cmos5l_decap_8
X_4150_ _4150_/Y _7040_/Q _3831_/X _3828_/Y vddd vssd sg13cmos5l_a21oi_1
X_4081_ _4081_/Y _4257_/B sram_odata[2] _3755_/A wire4/X _4292_/B vddd vssd sg13cmos5l_a221oi_1
XFILLER_23_105 vddd vssd sg13cmos5l_decap_8
X_4983_ _5220_/A _5240_/A _5240_/B vddd vssd sg13cmos5l_nand2_1
X_6722_ _6722_/X _6715_/A _6722_/A1 _6724_/S vddd vssd sg13cmos5l_mux2_1
X_3934_ _3934_/Y _3934_/A _3937_/B vddd vssd sg13cmos5l_nand2_1
X_3865_ _3872_/B _7287_/Q _6642_/A vddd vssd sg13cmos5l_nand2_1
X_6653_ _6653_/Y _6653_/A _6658_/S vddd vssd sg13cmos5l_nor2_1
X_5604_ _5604_/Y _5604_/A1 _5577_/X _5603_/Y vddd vssd sg13cmos5l_a21oi_1
XFILLER_14_2569 vddd vssd sg13cmos5l_decap_8
X_3796_ _3796_/Y _3796_/A _3796_/B _3796_/C vddd vssd sg13cmos5l_nand3_1
X_6584_ _6584_/Y _6584_/A _6588_/S vddd vssd sg13cmos5l_nor2_1
X_5535_ _5535_/Y _5535_/A _5535_/B _5535_/C vddd vssd sg13cmos5l_nor3_1
XFILLER_11_49 vddd vssd sg13cmos5l_decap_8
X_5466_ _5470_/B _5753_/A _5481_/C vddd vssd sg13cmos5l_nor2_1
XFILLER_12_1592 vddd vssd sg13cmos5l_decap_8
X_7205_ _7205_/Q _7206_/CLK _7205_/D _6822_/B_N vddd vssd sg13cmos5l_dfrbpq_1
X_4417_ _4417_/Y _4420_/A _4417_/B vddd vssd sg13cmos5l_nor2_1
Xfanout313 _5316_/A hold1396/X vddd vssd sg13cmos5l_buf_1
Xfanout302 _5597_/A _7182_/Q vddd vssd sg13cmos5l_buf_1
XFILLER_8_1104 vddd vssd sg13cmos5l_decap_8
X_5397_ _5401_/B _7153_/Q _7154_/Q _7155_/Q vddd vssd sg13cmos5l_nor3_1
Xfanout357 fanout357/X fanout358/X vddd vssd sg13cmos5l_buf_1
XFILLER_25_1920 vddd vssd sg13cmos5l_decap_8
Xfanout346 fanout346/X fanout379/X vddd vssd sg13cmos5l_buf_1
Xfanout335 _6505_/A1 fanout340/X vddd vssd sg13cmos5l_buf_1
Xfanout324 _6151_/A _4020_/X vddd vssd sg13cmos5l_buf_1
X_7136_ _7136_/Q _7378_/CLK _7136_/D fanout361/X vddd vssd sg13cmos5l_dfrbpq_1
X_4348_ _4348_/Y _4317_/A hold870/X _4346_/Y vddd vssd sg13cmos5l_o21ai_1
X_7067_ _7067_/Q _7143_/CLK _7067_/D fanout361/X vddd vssd sg13cmos5l_dfrbpq_1
Xfanout379 fanout379/X porb vddd vssd sg13cmos5l_buf_1
Xfanout368 fanout368/X fanout369/X vddd vssd sg13cmos5l_buf_1
X_4279_ _4280_/B _4282_/A _4279_/B _4282_/C vddd vssd sg13cmos5l_nand3_1
XFILLER_28_934 vddd vssd sg13cmos5l_decap_8
X_6018_ _6018_/Y _6018_/A _6041_/B vddd vssd sg13cmos5l_nand2_1
XFILLER_3_2494 vddd vssd sg13cmos5l_decap_8
XFILLER_19_2414 vddd vssd sg13cmos5l_decap_4
XFILLER_19_2436 vddd vssd sg13cmos5l_decap_8
XFILLER_19_1702 vddd vssd sg13cmos5l_decap_8
XFILLER_14_116 vddd vssd sg13cmos5l_decap_8
XFILLER_23_694 vddd vssd sg13cmos5l_decap_8
XFILLER_11_856 vddd vssd sg13cmos5l_decap_8
XFILLER_13_2057 vddd vssd sg13cmos5l_decap_8
XFILLER_13_1323 vddd vssd sg13cmos5l_decap_8
XFILLER_30_2382 vddd vssd sg13cmos5l_decap_8
XFILLER_2_598 vddd vssd sg13cmos5l_decap_8
Xtiedowns\[35\] dbus_in_right[3] vddd vssd sg13cmos5l_antennanp
XFILLER_24_1496 vddd vssd sg13cmos5l_decap_8
XFILLER_20_1338 vddd vssd sg13cmos5l_decap_8
XFILLER_20_1327 vddd vssd sg13cmos5l_decap_4
XFILLER_4_1568 vddd vssd sg13cmos5l_decap_4
XFILLER_4_1579 vddd vssd sg13cmos5l_decap_8
XFILLER_2_1281 vddd vssd sg13cmos5l_decap_4
XFILLER_18_1278 vddd vssd sg13cmos5l_decap_8
XFILLER_31_1401 vddd vssd sg13cmos5l_decap_8
X_3650_ _3651_/D _4861_/B _6968_/Q _5939_/A _6970_/Q vddd vssd sg13cmos5l_nor4_1
XFILLER_9_175 vddd vssd sg13cmos5l_decap_8
X_3581_ _3581_/Y _3581_/A vddd vssd sg13cmos5l_inv_1
X_5320_ _5320_/Y _7142_/Q _7143_/Q _5320_/C vddd vssd sg13cmos5l_nor3_1
X_5251_ _6191_/B _5268_/A _6023_/C vddd vssd sg13cmos5l_nand2_1
XFILLER_6_893 vddd vssd sg13cmos5l_decap_4
XFILLER_9_2103 vddd vssd sg13cmos5l_decap_8
XFILLER_29_2064 vddd vssd sg13cmos5l_decap_8
X_4202_ _4202_/Y _5867_/A _3911_/Y _4200_/Y _4201_/Y _6525_/A vddd vssd sg13cmos5l_a221oi_1
XFILLER_9_2136 vddd vssd sg13cmos5l_decap_4
X_5182_ _5187_/C _5248_/B _5210_/B vddd vssd sg13cmos5l_nor2_1
XFILLER_9_1457 vddd vssd sg13cmos5l_decap_8
X_4133_ _4133_/Y _7173_/Q _3942_/Y _4131_/Y _4132_/Y _6435_/A vddd vssd sg13cmos5l_a221oi_1
X_4064_ wire8/A _3619_/Y _3983_/B _4062_/Y _4063_/Y _3982_/Y vddd vssd sg13cmos5l_a221oi_1
XFILLER_20_2584 vddd vssd sg13cmos5l_decap_8
Xwire12 wire12/X wire12/A vddd vssd sg13cmos5l_buf_2
Xwire78 wire78/X wire78/A vddd vssd sg13cmos5l_buf_4
X_6705_ _6705_/X _6324_/A _6705_/A1 _6707_/S vddd vssd sg13cmos5l_mux2_1
X_4966_ _7299_/D _4964_/A _4958_/B _4965_/Y vddd vssd sg13cmos5l_a21o_1
X_3917_ _3925_/B _7211_/Q _6510_/A vddd vssd sg13cmos5l_nand2_1
X_4897_ _4898_/B _4932_/A _7137_/Q _7130_/Q _4968_/A vddd vssd sg13cmos5l_a22oi_1
X_6636_ _6641_/S _6636_/A _6667_/B vddd vssd sg13cmos5l_and2_1
X_3848_ _3848_/Y _3840_/Y _3846_/Y _3847_/Y vddd vssd sg13cmos5l_o21ai_1
XFILLER_14_1665 vddd vssd sg13cmos5l_decap_8
X_3779_ _3779_/Y mask_rev_in[22] _4168_/B1 _3777_/Y _3778_/Y _3852_/A vddd vssd sg13cmos5l_a221oi_1
X_6567_ _6567_/X _6703_/A0 _6567_/A1 _6568_/S vddd vssd sg13cmos5l_mux2_1
X_5518_ _5543_/C _7172_/Q _5527_/B vddd vssd sg13cmos5l_nand2_1
XFILLER_10_1518 vddd vssd sg13cmos5l_decap_8
X_6498_ _7200_/D _6505_/A1 _6501_/B hold956/X vddd vssd sg13cmos5l_a21oi_1
X_5449_ _5449_/Y _5449_/A _5449_/B _5449_/C vddd vssd sg13cmos5l_nor3_1
Xfanout121 _6615_/A _3686_/X vddd vssd sg13cmos5l_buf_1
XFILLER_25_2473 vddd vssd sg13cmos5l_decap_8
Xfanout132 _6673_/B _6748_/B vddd vssd sg13cmos5l_buf_1
Xfanout143 _7017_/D _4258_/A vddd vssd sg13cmos5l_buf_1
X_7119_ _7119_/Q _7120_/CLK _7119_/D fanout395/X vddd vssd sg13cmos5l_dfrbpq_1
Xfanout154 _4769_/A1 _4774_/B vddd vssd sg13cmos5l_buf_1
Xfanout165 _4489_/A _3488_/Y vddd vssd sg13cmos5l_buf_1
Xfanout187 _6704_/A0 _6627_/A vddd vssd sg13cmos5l_buf_1
Xfanout198 _6599_/A _6790_/A vddd vssd sg13cmos5l_buf_1
XFILLER_5_2589 vddd vssd sg13cmos5l_decap_8
Xfanout176 _5030_/A hold1481/X vddd vssd sg13cmos5l_buf_1
XFILLER_15_436 vddd vssd sg13cmos5l_decap_8
XFILLER_32_2433 vddd vssd sg13cmos5l_decap_8
XFILLER_19_1565 vddd vssd sg13cmos5l_decap_8
XFILLER_8_28 vddd vssd sg13cmos5l_decap_8
XFILLER_11_653 vddd vssd sg13cmos5l_decap_8
XFILLER_32_1743 vddd vssd sg13cmos5l_decap_8
XFILLER_13_1164 vddd vssd sg13cmos5l_decap_8
XFILLER_12_70 vddd vssd sg13cmos5l_decap_8
XFILLER_3_896 vddd vssd sg13cmos5l_decap_8
XFILLER_26_7 vddd vssd sg13cmos5l_decap_8
XFILLER_6_1608 vddd vssd sg13cmos5l_decap_8
XFILLER_19_753 vddd vssd sg13cmos5l_decap_8
XFILLER_4_1387 vddd vssd sg13cmos5l_decap_8
X_4820_ _4820_/Y _6018_/A _4819_/A _4460_/B vddd vssd sg13cmos5l_a21oi_1
XFILLER_18_1020 vddd vssd sg13cmos5l_decap_8
X_4751_ _4751_/Y _4751_/A _4751_/B vddd vssd sg13cmos5l_xnor2_1
XFILLER_30_973 vddd vssd sg13cmos5l_decap_8
X_4682_ _4682_/X _4661_/A _4771_/B _4681_/Y vddd vssd sg13cmos5l_a21o_1
X_3702_ _4002_/D _3750_/D _3750_/C vddd vssd sg13cmos5l_nand2b_1
X_3633_ _3633_/Y _4480_/A _3633_/B vddd vssd sg13cmos5l_xnor2_1
X_6421_ _6421_/Y _6421_/A _6427_/B vddd vssd sg13cmos5l_nand2_1
X_3564_ _5463_/A _3564_/A vddd vssd sg13cmos5l_inv_1
X_6352_ _6352_/Y _6605_/A _6360_/S vddd vssd sg13cmos5l_nand2_1
X_6283_ _6285_/B _6294_/A vddd vssd sg13cmos5l_inv_1
X_5303_ _5303_/Y _5301_/Y _5302_/Y _5304_/B vddd vssd sg13cmos5l_o21ai_1
X_3495_ _6189_/A _4526_/B vddd vssd sg13cmos5l_inv_1
Xoutbuffers\[66\] idac2_value[3] _7042_/Q vddd vssd sg13cmos5l_buf_16
X_5234_ _5242_/C _5265_/A _5234_/B vddd vssd sg13cmos5l_and2_1
XFILLER_9_1210 vddd vssd sg13cmos5l_decap_8
XFILLER_22_2602 vddd vssd sg13cmos5l_decap_4
X_5165_ _5168_/D _7260_/Q _7261_/Q _5216_/B vddd vssd sg13cmos5l_nor3_1
XFILLER_9_1276 vddd vssd sg13cmos5l_decap_8
X_4116_ _4116_/X _5910_/C _6540_/A _6533_/A vddd vssd sg13cmos5l_a21o_1
XFILLER_22_1945 vddd vssd sg13cmos5l_decap_4
X_5096_ _6130_/B _7280_/Q _7281_/Q vddd vssd sg13cmos5l_nor2b_1
XFILLER_25_701 vddd vssd sg13cmos5l_decap_8
X_4047_ _4047_/Y _4044_/Y _4045_/Y _4046_/Y vddd vssd sg13cmos5l_o21ai_1
XFILLER_0_1730 vddd vssd sg13cmos5l_decap_8
XFILLER_25_767 vddd vssd sg13cmos5l_decap_8
XFILLER_0_2486 vddd vssd sg13cmos5l_decap_8
X_5998_ _5998_/Y _3484_/Y _4336_/C _4324_/B vddd vssd sg13cmos5l_a21oi_1
XFILLER_12_428 vddd vssd sg13cmos5l_decap_8
XFILLER_13_929 vddd vssd sg13cmos5l_decap_8
X_4949_ _4949_/Y _4949_/A _4952_/A vddd vssd sg13cmos5l_xnor2_1
XFILLER_32_1017 vddd vssd sg13cmos5l_decap_8
XFILLER_14_2163 vddd vssd sg13cmos5l_decap_8
X_6619_ _6619_/Y _6619_/A1 _6621_/S _6618_/Y vddd vssd sg13cmos5l_o21ai_1
XFILLER_27_2502 vddd vssd sg13cmos5l_decap_8
XFILLER_0_822 vddd vssd sg13cmos5l_decap_8
XFILLER_27_2579 vddd vssd sg13cmos5l_decap_8
XFILLER_27_1889 vddd vssd sg13cmos5l_decap_8
XFILLER_16_734 vddd vssd sg13cmos5l_decap_8
XFILLER_19_2041 vddd vssd sg13cmos5l_decap_4
XFILLER_15_244 vddd vssd sg13cmos5l_decap_8
XFILLER_31_715 vddd vssd sg13cmos5l_decap_8
XFILLER_15_1204 vddd vssd sg13cmos5l_decap_8
XFILLER_12_973 vddd vssd sg13cmos5l_decap_8
XFILLER_23_91 vddd vssd sg13cmos5l_decap_8
XFILLER_32_1584 vddd vssd sg13cmos5l_decap_8
XFILLER_32_1551 vddd vssd sg13cmos5l_decap_8
XFILLER_8_988 vddd vssd sg13cmos5l_decap_8
XFILLER_10_2594 vddd vssd sg13cmos5l_decap_8
XFILLER_6_2117 vddd vssd sg13cmos5l_decap_8
XFILLER_26_1366 vddd vssd sg13cmos5l_decap_8
XFILLER_6_1416 vddd vssd sg13cmos5l_decap_8
XFILLER_6_1438 vddd vssd sg13cmos5l_decap_8
X_6970_ _6970_/Q _7001_/CLK _6970_/D _6917_/Y vddd vssd sg13cmos5l_dfrbpq_1
X_5921_ _5921_/X _7092_/Q _5939_/A vddd vssd sg13cmos5l_or2_1
XFILLER_4_1173 vddd vssd sg13cmos5l_decap_8
XFILLER_0_84 vddd vssd sg13cmos5l_decap_8
X_5852_ _5852_/X _5882_/A _5852_/B vddd vssd sg13cmos5l_and2_1
X_5783_ _5783_/X _7208_/Q _5786_/B vddd vssd sg13cmos5l_and2_1
X_4803_ _4803_/Y _4789_/A _4793_/X _4511_/Y vddd vssd sg13cmos5l_o21ai_1
X_4734_ _4734_/Y _4734_/A _4755_/B vddd vssd sg13cmos5l_nand2_1
XFILLER_9_93 vddd vssd sg13cmos5l_decap_8
X_4665_ _4670_/C _4687_/A _7333_/Q vddd vssd sg13cmos5l_nand2b_1
Xhold911 _3610_/A _7111_/Q vddd vssd sg13cmos5l_dlygate4sd3_1
X_3616_ _6221_/B _3616_/A vddd vssd sg13cmos5l_inv_1
X_7384_ _7384_/Q _7384_/CLK _7384_/D _6806_/Y vddd vssd sg13cmos5l_dfrbpq_1
Xhold922 hold922/X _6511_/Y vddd vssd sg13cmos5l_dlygate4sd3_1
X_4596_ _4601_/A _4641_/A _4575_/Y _4599_/C _4599_/B _4552_/A vddd vssd sg13cmos5l_a221oi_1
XFILLER_11_1635 vddd vssd sg13cmos5l_decap_8
XFILLER_11_1657 vddd vssd sg13cmos5l_decap_8
Xhold900 hold900/X _7397_/Q vddd vssd sg13cmos5l_dlygate4sd3_1
X_6404_ _6404_/Y _6404_/A _6404_/B vddd vssd sg13cmos5l_nor2_1
Xhold944 _7107_/D _6319_/Y vddd vssd sg13cmos5l_dlygate4sd3_1
X_3547_ _3547_/Y _5532_/A vddd vssd sg13cmos5l_inv_1
Xhold933 _3565_/A _7169_/Q vddd vssd sg13cmos5l_dlygate4sd3_1
X_6335_ _6335_/Y _6335_/A _6347_/B vddd vssd sg13cmos5l_nand2_1
Xhold955 _6497_/A _7200_/Q vddd vssd sg13cmos5l_dlygate4sd3_1
Xhold988 hold988/X _6661_/Y vddd vssd sg13cmos5l_dlygate4sd3_1
Xhold977 hold977/X _6674_/Y vddd vssd sg13cmos5l_dlygate4sd3_1
Xhold966 hold966/X _3603_/Y vddd vssd sg13cmos5l_dlygate4sd3_1
X_3478_ _3478_/Y _4751_/B vddd vssd sg13cmos5l_inv_1
X_6266_ _6266_/Y _4196_/X _5021_/B _5008_/A vddd vssd sg13cmos5l_a21oi_1
Xhold999 _6413_/A _7156_/Q vddd vssd sg13cmos5l_dlygate4sd3_1
X_6197_ _6197_/X _6241_/A _5260_/A _6196_/Y vddd vssd sg13cmos5l_a21o_1
X_5217_ _5217_/Y _5217_/A vddd vssd sg13cmos5l_inv_1
XFILLER_29_336 vddd vssd sg13cmos5l_decap_8
XFILLER_22_1720 vddd vssd sg13cmos5l_decap_8
X_5148_ _5190_/B _5148_/A _5149_/B vddd vssd sg13cmos5l_nor2b_1
XFILLER_29_369 vddd vssd sg13cmos5l_decap_8
XFILLER_28_58 vddd vssd sg13cmos5l_decap_8
XFILLER_22_2476 vddd vssd sg13cmos5l_decap_8
XFILLER_2_2548 vddd vssd sg13cmos5l_decap_4
X_5079_ _5254_/B _7245_/Q _7244_/Q vddd vssd sg13cmos5l_nor2b_1
XFILLER_25_586 vddd vssd sg13cmos5l_decap_8
XFILLER_0_1582 vddd vssd sg13cmos5l_decap_4
XFILLER_12_203 vddd vssd sg13cmos5l_decap_8
XFILLER_16_1546 vddd vssd sg13cmos5l_decap_8
XFILLER_27_2376 vddd vssd sg13cmos5l_decap_8
XFILLER_27_1631 vddd vssd sg13cmos5l_decap_8
XFILLER_7_2459 vddd vssd sg13cmos5l_decap_8
XFILLER_23_1517 vddd vssd sg13cmos5l_decap_8
XFILLER_5_2194 vddd vssd sg13cmos5l_decap_8
XFILLER_18_80 vddd vssd sg13cmos5l_decap_4
XFILLER_12_792 vddd vssd sg13cmos5l_decap_4
XFILLER_32_2071 vddd vssd sg13cmos5l_decap_8
XFILLER_15_1089 vddd vssd sg13cmos5l_decap_8
XFILLER_8_763 vddd vssd sg13cmos5l_decap_8
Xwire160 _4258_/B _3658_/Y vddd vssd sg13cmos5l_buf_4
XFILLER_8_796 vddd vssd sg13cmos5l_decap_8
X_4450_ _4590_/B _4614_/A _4670_/A _4450_/C vddd vssd sg13cmos5l_nand3_1
XFILLER_12_1944 vddd vssd sg13cmos5l_decap_8
X_4381_ _4384_/B _4815_/A _7114_/Q _4367_/Y vddd vssd sg13cmos5l_o21ai_1
X_6120_ _6120_/Y _6120_/A _6120_/B vddd vssd sg13cmos5l_nor2_1
XFILLER_3_490 vddd vssd sg13cmos5l_decap_4
X_6051_ _6051_/Y _3768_/X _5120_/C _5120_/B vddd vssd sg13cmos5l_a21oi_1
X_5002_ _5127_/A _7272_/Q _7273_/Q vddd vssd sg13cmos5l_nand2_1
XFILLER_15_0 vddd vssd sg13cmos5l_decap_8
XFILLER_27_829 vddd vssd sg13cmos5l_decap_8
Xoutbuffers\[29\] voltgen_sink1[2] _7063_/Q vddd vssd sg13cmos5l_buf_16
X_6953_ _6953_/Y _6959_/A _6959_/B_N vddd vssd sg13cmos5l_nor2b_1
X_6884_ _6884_/Y _6885_/A _6885_/B_N vddd vssd sg13cmos5l_nor2b_1
X_5904_ _5904_/Y _5910_/B _5910_/C _5908_/A vddd vssd sg13cmos5l_nor3_1
X_5835_ _5836_/B _5835_/A _5835_/B vddd vssd sg13cmos5l_nor2_1
XFILLER_22_578 vddd vssd sg13cmos5l_decap_8
XFILLER_17_2567 vddd vssd sg13cmos5l_decap_8
XFILLER_14_49 vddd vssd sg13cmos5l_decap_8
X_5766_ _5766_/Y _5769_/A _5769_/B _5766_/C vddd vssd sg13cmos5l_nor3_1
Xtiedowns\[1\] sram_odata[1] vddd vssd sg13cmos5l_antennanp
X_5697_ _5697_/Y _5695_/Y _5696_/Y _5708_/C vddd vssd sg13cmos5l_o21ai_1
X_4717_ _4717_/Y _4726_/A _4740_/B vddd vssd sg13cmos5l_nor2_1
X_4648_ _4648_/Y _4648_/A _4648_/B _4648_/C vddd vssd sg13cmos5l_nand3_1
Xhold730 _3593_/A _7097_/Q vddd vssd sg13cmos5l_dlygate4sd3_1
XFILLER_11_1443 vddd vssd sg13cmos5l_decap_4
Xhold741 hold741/X _7182_/Q vddd vssd sg13cmos5l_dlygate4sd3_1
X_4579_ _4579_/Y _4579_/A _4579_/B vddd vssd sg13cmos5l_nand2_1
X_7367_ _7367_/Q _7372_/CLK _7367_/D _6880_/Y vddd vssd sg13cmos5l_dfrbpq_1
Xhold763 _7394_/D _5286_/Y vddd vssd sg13cmos5l_dlygate4sd3_1
Xhold752 hold752/X _3528_/Y vddd vssd sg13cmos5l_dlygate4sd3_1
X_6318_ _6318_/Y _6605_/A _6324_/B vddd vssd sg13cmos5l_nand2_1
Xhold796 _6374_/A _7136_/Q vddd vssd sg13cmos5l_dlygate4sd3_1
Xhold774 _7354_/D _4345_/X vddd vssd sg13cmos5l_dlygate4sd3_1
Xhold785 hold785/X _6762_/Y vddd vssd sg13cmos5l_dlygate4sd3_1
X_7298_ _7298_/Q _7393_/CLK _7298_/D _6811_/Y vddd vssd sg13cmos5l_dfrbpq_1
XFILLER_24_2527 vddd vssd sg13cmos5l_decap_8
X_6249_ _6249_/Y _3768_/X _6248_/A _6248_/Y vddd vssd sg13cmos5l_a21oi_1
Xhold1441 _6472_/A1 _5621_/B vddd vssd sg13cmos5l_dlygate4sd3_1
XFILLER_29_144 vddd vssd sg13cmos5l_decap_8
Xhold1452 _6702_/A1 _7045_/Q vddd vssd sg13cmos5l_dlygate4sd3_1
Xhold1430 _7170_/D _6440_/X vddd vssd sg13cmos5l_dlygate4sd3_1
Xhold1463 _7046_/D _6703_/X vddd vssd sg13cmos5l_dlygate4sd3_1
Xhold1485 hold1485/X _7078_/Q vddd vssd sg13cmos5l_dlygate4sd3_1
Xhold1474 _7333_/D _4682_/X vddd vssd sg13cmos5l_dlygate4sd3_1
Xhold1496 hold489/A _5989_/X vddd vssd sg13cmos5l_dlygate4sd3_1
XFILLER_2_1655 vddd vssd sg13cmos5l_decap_8
XFILLER_26_873 vddd vssd sg13cmos5l_decap_8
XFILLER_2_1677 vddd vssd sg13cmos5l_decap_8
XFILLER_16_2022 vddd vssd sg13cmos5l_decap_8
Xtiedowns\[65\] mask_rev_in[21] vddd vssd sg13cmos5l_antennanp
XFILLER_4_210 vddd vssd sg13cmos5l_decap_8
XFILLER_20_70 vddd vssd sg13cmos5l_decap_8
XFILLER_7_2212 vddd vssd sg13cmos5l_decap_8
XFILLER_23_1303 vddd vssd sg13cmos5l_decap_8
X_3950_ _3950_/Y _7171_/Q _3946_/Y _3949_/Y vddd vssd sg13cmos5l_o21ai_1
XFILLER_32_810 vddd vssd sg13cmos5l_decap_8
Xoutbuffers\[119\] dbus_out[22] _6240_/Y vddd vssd sg13cmos5l_buf_16
X_3881_ _3881_/Y _7263_/Q _6602_/A _6595_/A vddd vssd sg13cmos5l_o21ai_1
XFILLER_32_887 vddd vssd sg13cmos5l_decap_8
X_5620_ _5620_/X _5727_/A _5620_/B vddd vssd sg13cmos5l_or2_1
X_5551_ _5571_/C _7176_/Q _5557_/B vddd vssd sg13cmos5l_nand2_1
XFILLER_12_2442 vddd vssd sg13cmos5l_decap_8
X_4502_ _4503_/B _4530_/A _4530_/B vddd vssd sg13cmos5l_xnor2_1
XFILLER_12_1730 vddd vssd sg13cmos5l_decap_8
X_7221_ _7221_/Q _7287_/CLK _7221_/D _6828_/B_N vddd vssd sg13cmos5l_dfrbpq_1
X_5482_ _5482_/Y _5482_/A _5482_/B _5482_/C _5482_/D vddd vssd sg13cmos5l_nor4_1
X_4433_ _4433_/Y _4432_/A _5956_/B vddd vssd sg13cmos5l_nand2b_1
XFILLER_8_2009 vddd vssd sg13cmos5l_decap_8
XFILLER_28_1214 vddd vssd sg13cmos5l_decap_8
Xwire8 wire8/X wire8/A vddd vssd sg13cmos5l_buf_2
X_7152_ _7152_/Q _7171_/CLK _7152_/D fanout360/X vddd vssd sg13cmos5l_dfrbpq_1
X_4364_ _4436_/A _4403_/A _4396_/B vddd vssd sg13cmos5l_and2_1
X_6103_ _6103_/Y _6101_/Y _6102_/X _6086_/Y vddd vssd sg13cmos5l_o21ai_1
X_4295_ _4295_/Y _6693_/A1 _4293_/B hold810/X _4976_/C vddd vssd sg13cmos5l_a22oi_1
X_7083_ _7083_/Q _7120_/CLK _7083_/D _6860_/B_N vddd vssd sg13cmos5l_dfrbpq_1
X_6034_ _6034_/Y _6032_/Y _6034_/B vddd vssd sg13cmos5l_nand2b_1
XFILLER_6_1032 vddd vssd sg13cmos5l_decap_4
XFILLER_23_2593 vddd vssd sg13cmos5l_decap_8
XFILLER_6_1076 vddd vssd sg13cmos5l_decap_8
X_6936_ _6936_/Y _6956_/A _6957_/B_N vddd vssd sg13cmos5l_nor2b_1
XFILLER_26_147 vddd vssd sg13cmos5l_decap_8
XFILLER_25_37 vddd vssd sg13cmos5l_decap_8
X_6867_ _6867_/Y _6881_/A _6867_/B_N vddd vssd sg13cmos5l_nor2b_1
X_6798_ _6798_/X _6798_/A vddd vssd sg13cmos5l_buf_1
XFILLER_22_386 vddd vssd sg13cmos5l_decap_8
X_5818_ _5818_/Y _5818_/A _5818_/B vddd vssd sg13cmos5l_nor2_1
X_5749_ _5766_/C _7204_/Q _7205_/Q vddd vssd sg13cmos5l_nand2b_1
XFILLER_30_2564 vddd vssd sg13cmos5l_decap_8
Xhold560 _6796_/A _6988_/Q vddd vssd sg13cmos5l_dlygate4sd3_1
Xhold571 _7388_/D _3812_/Y vddd vssd sg13cmos5l_dlygate4sd3_1
Xhold593 _7224_/D _6542_/Y vddd vssd sg13cmos5l_dlygate4sd3_1
Xhold582 _4336_/B _7355_/Q vddd vssd sg13cmos5l_dlygate4sd3_1
XFILLER_8_2543 vddd vssd sg13cmos5l_decap_8
XFILLER_28_1781 vddd vssd sg13cmos5l_decap_8
XFILLER_8_1842 vddd vssd sg13cmos5l_decap_8
XFILLER_8_2587 vddd vssd sg13cmos5l_decap_8
XFILLER_4_1728 vddd vssd sg13cmos5l_decap_4
Xhold1260 _7291_/D _6651_/X vddd vssd sg13cmos5l_dlygate4sd3_1
XFILLER_18_648 vddd vssd sg13cmos5l_decap_8
Xhold1293 _6507_/A1 _5753_/B vddd vssd sg13cmos5l_dlygate4sd3_1
Xhold1271 _6502_/A1 _3581_/Y vddd vssd sg13cmos5l_dlygate4sd3_1
Xhold1282 _3563_/A _7163_/Q vddd vssd sg13cmos5l_dlygate4sd3_1
XFILLER_26_692 vddd vssd sg13cmos5l_decap_8
XFILLER_25_191 vddd vssd sg13cmos5l_decap_8
XFILLER_15_70 vddd vssd sg13cmos5l_decap_8
XFILLER_9_302 vddd vssd sg13cmos5l_decap_8
XFILLER_9_1628 vddd vssd sg13cmos5l_decap_8
XFILLER_7_2064 vddd vssd sg13cmos5l_decap_8
X_4080_ wire5/A _4078_/Y _4079_/Y wire81/X vddd vssd sg13cmos5l_o21ai_1
XFILLER_7_1374 vddd vssd sg13cmos5l_decap_8
X_4982_ _4997_/B _5212_/A _5273_/A vddd vssd sg13cmos5l_nor2_1
X_6721_ _6721_/X _6393_/A _6721_/A1 _6724_/S vddd vssd sg13cmos5l_mux2_1
X_3933_ _6467_/A _3934_/A _3937_/B vddd vssd sg13cmos5l_and2_1
XFILLER_32_684 vddd vssd sg13cmos5l_decap_8
X_3864_ _3872_/A _7021_/Q _6660_/A _6636_/A _7283_/Q vddd vssd sg13cmos5l_a22oi_1
X_6652_ _6658_/S _6652_/A _6699_/B vddd vssd sg13cmos5l_and2_1
X_5603_ _5603_/Y _5595_/A _5601_/A _5601_/X _5571_/A _5602_/Y vddd vssd sg13cmos5l_a221oi_1
XFILLER_20_846 vddd vssd sg13cmos5l_decap_8
XFILLER_14_2548 vddd vssd sg13cmos5l_decap_8
X_3795_ _3796_/C _7066_/Q _6725_/A _4085_/B vddd vssd sg13cmos5l_a21oi_1
XFILLER_14_1869 vddd vssd sg13cmos5l_decap_4
X_6583_ _6588_/S _6583_/A _6615_/C vddd vssd sg13cmos5l_nor2_1
XFILLER_9_880 vddd vssd sg13cmos5l_decap_8
Xoutbuffers\[96\] io_out[11] _6281_/X vddd vssd sg13cmos5l_buf_16
X_5534_ _5535_/C _5532_/X _5533_/X _5540_/C vddd vssd sg13cmos5l_a21oi_1
XFILLER_11_28 vddd vssd sg13cmos5l_decap_8
X_5465_ _5481_/C _7164_/Q _7165_/Q vddd vssd sg13cmos5l_nand2_1
XFILLER_12_1571 vddd vssd sg13cmos5l_decap_8
X_4416_ _4416_/X _4416_/A _4419_/A vddd vssd sg13cmos5l_xor2_1
X_7204_ _7204_/Q _7206_/CLK _7204_/D _6822_/B_N vddd vssd sg13cmos5l_dfrbpq_1
Xfanout303 _5540_/B _5543_/B vddd vssd sg13cmos5l_buf_1
Xclkbuf_leaf_16_SCK_regs _7233_/CLK clkload7/A vddd vssd sg13cmos5l_buf_8
X_7135_ _7135_/Q _7378_/CLK _7135_/D fanout357/X vddd vssd sg13cmos5l_dfrbpq_1
Xfanout314 _4430_/B hold1466/X vddd vssd sg13cmos5l_buf_1
X_5396_ _5396_/X _5396_/A _5396_/B vddd vssd sg13cmos5l_or2_1
Xfanout336 _6675_/A1 fanout340/X vddd vssd sg13cmos5l_buf_1
Xfanout325 _6243_/A _6262_/A vddd vssd sg13cmos5l_buf_1
Xfanout347 _6877_/B_N _6834_/B_N vddd vssd sg13cmos5l_buf_1
X_4347_ _4347_/Y _3486_/Y _3669_/S _4315_/C vddd vssd sg13cmos5l_o21ai_1
Xfanout358 fanout358/X fanout363/X vddd vssd sg13cmos5l_buf_1
Xfanout369 fanout369/X fanout370/X vddd vssd sg13cmos5l_buf_1
X_7066_ _7066_/Q _7066_/CLK _7066_/D fanout358/X vddd vssd sg13cmos5l_dfrbpq_1
XFILLER_21_2519 vddd vssd sg13cmos5l_decap_8
X_4278_ _4282_/C _4308_/A _4298_/A vddd vssd sg13cmos5l_nor2_1
X_6017_ _6017_/Y _3517_/Y _7284_/Q _6015_/Y _6016_/Y _5090_/B vddd vssd sg13cmos5l_a221oi_1
XFILLER_3_2440 vddd vssd sg13cmos5l_decap_4
X_6919_ _6919_/Y _6919_/A _6919_/B_N vddd vssd sg13cmos5l_nor2b_1
XFILLER_23_684 vddd vssd sg13cmos5l_decap_4
XFILLER_11_824 vddd vssd sg13cmos5l_decap_8
XFILLER_17_2194 vddd vssd sg13cmos5l_decap_8
XFILLER_13_2036 vddd vssd sg13cmos5l_decap_8
XFILLER_32_1936 vddd vssd sg13cmos5l_decap_8
XFILLER_7_817 vddd vssd sg13cmos5l_decap_8
XFILLER_30_2361 vddd vssd sg13cmos5l_decap_8
XFILLER_13_1357 vddd vssd sg13cmos5l_decap_4
XFILLER_11_1092 vddd vssd sg13cmos5l_decap_8
XFILLER_26_1707 vddd vssd sg13cmos5l_decap_8
XFILLER_2_566 vddd vssd sg13cmos5l_decap_4
Xtiedowns\[28\] dbus_in_left[8] vddd vssd sg13cmos5l_antennanp
XFILLER_24_1453 vddd vssd sg13cmos5l_decap_8
XFILLER_19_913 vddd vssd sg13cmos5l_decap_8
Xhold1090 _4407_/B _4406_/X vddd vssd sg13cmos5l_dlygate4sd3_1
XFILLER_26_91 vddd vssd sg13cmos5l_decap_8
XFILLER_13_2581 vddd vssd sg13cmos5l_decap_8
XFILLER_10_890 vddd vssd sg13cmos5l_decap_8
X_3580_ _5695_/B _3580_/A vddd vssd sg13cmos5l_inv_1
X_5250_ _5252_/C _5275_/A _5250_/B vddd vssd sg13cmos5l_or2_1
XFILLER_9_2159 vddd vssd sg13cmos5l_decap_4
X_4201_ _4201_/Y _6233_/B _6548_/A _6540_/A _5910_/B _6533_/A vddd vssd sg13cmos5l_a221oi_1
X_5181_ _6112_/B _5250_/B _5216_/B vddd vssd sg13cmos5l_nor2_1
X_4132_ _4132_/Y _5557_/B _6450_/A _6443_/A vddd vssd sg13cmos5l_a21oi_1
XFILLER_3_73 vddd vssd sg13cmos5l_decap_8
X_4063_ _4063_/Y _7036_/Q _3828_/Y _3983_/B vddd vssd sg13cmos5l_a21oi_1
XFILLER_20_2563 vddd vssd sg13cmos5l_decap_8
XFILLER_3_1046 vddd vssd sg13cmos5l_decap_8
Xwire13 wire13/X wire13/A vddd vssd sg13cmos5l_buf_8
Xoutbuffers\[11\] proj_dig_ena _7024_/Q vddd vssd sg13cmos5l_buf_16
XFILLER_0_1989 vddd vssd sg13cmos5l_decap_8
X_4965_ _4965_/Y _4965_/A _4965_/B _4965_/C vddd vssd sg13cmos5l_nor3_1
X_6704_ _6704_/X _6704_/A0 _6704_/A1 _6707_/S vddd vssd sg13cmos5l_mux2_1
XFILLER_18_2481 vddd vssd sg13cmos5l_decap_8
X_3916_ _3925_/A _7215_/Q _3859_/Y _3914_/Y vddd vssd sg13cmos5l_o21ai_1
X_4896_ _4899_/B _4873_/Y _4896_/B vddd vssd sg13cmos5l_nand2b_1
X_6635_ _6635_/X _6635_/A0 _6546_/A _6635_/S vddd vssd sg13cmos5l_mux2_1
XFILLER_22_49 vddd vssd sg13cmos5l_decap_8
X_3847_ _3847_/Y _7086_/Q _4073_/A _3990_/A _7094_/Q _4250_/A vddd vssd sg13cmos5l_a221oi_1
XFILLER_20_687 vddd vssd sg13cmos5l_decap_8
X_3778_ _3778_/Y _3629_/Y _4077_/B _4168_/B1 vddd vssd sg13cmos5l_a21oi_1
X_6566_ _6566_/X _6655_/A _6566_/A1 _6568_/S vddd vssd sg13cmos5l_mux2_1
X_5517_ _5517_/Y _7172_/Q _7173_/Q _5540_/A _5540_/B vddd vssd sg13cmos5l_nor4_1
X_6497_ _6497_/Y _6497_/A _6501_/B vddd vssd sg13cmos5l_nor2_1
X_5448_ _5449_/C _5446_/X _5447_/Y _5454_/C vddd vssd sg13cmos5l_a21oi_1
X_5379_ _5379_/Y _5393_/B _7155_/Q _5379_/C vddd vssd sg13cmos5l_nand3_1
XFILLER_25_2452 vddd vssd sg13cmos5l_decap_8
Xfanout155 _4774_/B _4807_/A vddd vssd sg13cmos5l_buf_1
X_7118_ _7118_/Q _7255_/CLK _7118_/D fanout400/X vddd vssd sg13cmos5l_dfrbpq_1
Xfanout133 _6667_/B _6699_/B vddd vssd sg13cmos5l_buf_1
X_7049_ _7049_/Q _7279_/CLK _7049_/D fanout387/X vddd vssd sg13cmos5l_dfrbpq_1
Xfanout199 _6790_/A fanout200/X vddd vssd sg13cmos5l_buf_1
XFILLER_19_209 vddd vssd sg13cmos5l_decap_8
Xfanout188 _6743_/A _6627_/A vddd vssd sg13cmos5l_buf_1
XFILLER_5_2568 vddd vssd sg13cmos5l_decap_8
Xfanout166 _4323_/B hold1227/X vddd vssd sg13cmos5l_buf_1
XFILLER_9_1992 vddd vssd sg13cmos5l_decap_8
Xfanout177 _6768_/A _5029_/A vddd vssd sg13cmos5l_buf_1
XFILLER_21_1637 vddd vssd sg13cmos5l_decap_8
XFILLER_27_231 vddd vssd sg13cmos5l_decap_8
XFILLER_16_905 vddd vssd sg13cmos5l_decap_8
XFILLER_24_982 vddd vssd sg13cmos5l_decap_8
XFILLER_32_2412 vddd vssd sg13cmos5l_decap_8
XFILLER_23_481 vddd vssd sg13cmos5l_decap_4
XFILLER_32_2489 vddd vssd sg13cmos5l_decap_8
XFILLER_11_698 vddd vssd sg13cmos5l_decap_8
XFILLER_19_7 vddd vssd sg13cmos5l_decap_8
XFILLER_20_1114 vddd vssd sg13cmos5l_decap_4
XFILLER_4_1366 vddd vssd sg13cmos5l_decap_8
XFILLER_20_1169 vddd vssd sg13cmos5l_decap_8
Xoutbuffers\[101\] dbus_out[4] _5430_/X vddd vssd sg13cmos5l_buf_16
X_4750_ _4750_/Y _4776_/A _4771_/B vddd vssd sg13cmos5l_nand2_1
XFILLER_18_1098 vddd vssd sg13cmos5l_decap_8
XFILLER_15_1931 vddd vssd sg13cmos5l_decap_8
X_3701_ _3701_/Y _3842_/B _3883_/B vddd vssd sg13cmos5l_nand2_1
X_4681_ _4681_/Y _4681_/A _4681_/B _4681_/C vddd vssd sg13cmos5l_nor3_1
XFILLER_15_1964 vddd vssd sg13cmos5l_decap_8
X_3632_ _3632_/Y _6806_/A _6877_/B_N vddd vssd sg13cmos5l_nor2b_1
X_6420_ _6427_/B _6420_/A _6725_/B vddd vssd sg13cmos5l_nand2_1
X_6351_ _7122_/D _6333_/A _6360_/S hold877/X vddd vssd sg13cmos5l_a21oi_1
XFILLER_11_1839 vddd vssd sg13cmos5l_decap_4
X_5302_ _5302_/Y _5304_/A _5649_/A1 _5300_/Y vddd vssd sg13cmos5l_o21ai_1
X_3563_ _5444_/B _3563_/A vddd vssd sg13cmos5l_inv_1
X_6282_ _6294_/A _7075_/Q _7076_/Q vddd vssd sg13cmos5l_nor2_1
X_3494_ _4492_/A _4388_/A vddd vssd sg13cmos5l_inv_1
X_5233_ _5243_/B _7236_/Q _7237_/Q _5269_/A vddd vssd sg13cmos5l_nor3_1
Xoutbuffers\[59\] voltgen_high _7047_/Q vddd vssd sg13cmos5l_buf_16
X_5164_ _5216_/B _7263_/Q _7262_/Q vddd vssd sg13cmos5l_nand2b_1
XFILLER_9_1244 vddd vssd sg13cmos5l_decap_4
XFILLER_25_1047 vddd vssd sg13cmos5l_decap_4
X_4115_ _4115_/Y _6221_/B _6548_/A _4113_/Y _4114_/Y _6540_/A vddd vssd sg13cmos5l_a221oi_1
X_5095_ _5095_/Y _5149_/B _5148_/A _5274_/B vddd vssd sg13cmos5l_nor3_1
X_4046_ _4046_/Y _7166_/Q _6429_/A _6420_/A vddd vssd sg13cmos5l_a21oi_1
X_6896__466 _7384_/CLK _7171_/CLK vddd vssd sg13cmos5l_inv_1
XFILLER_25_757 vddd vssd sg13cmos5l_decap_4
X_5997_ _5997_/X _5996_/A _5997_/A2 _5996_/Y vddd vssd sg13cmos5l_a21o_1
XFILLER_0_1775 vddd vssd sg13cmos5l_decap_8
XFILLER_14_2120 vddd vssd sg13cmos5l_decap_8
X_4948_ _4948_/Y _4949_/A _4948_/B vddd vssd sg13cmos5l_nand2_1
XFILLER_21_963 vddd vssd sg13cmos5l_decap_8
XFILLER_20_451 vddd vssd sg13cmos5l_decap_4
XFILLER_14_2142 vddd vssd sg13cmos5l_decap_8
X_4879_ _4879_/X _4964_/A _7131_/Q vddd vssd sg13cmos5l_or2_1
X_6618_ _6618_/Y _6655_/A _6621_/S vddd vssd sg13cmos5l_nand2_1
XFILLER_21_985 vddd vssd sg13cmos5l_decap_4
XFILLER_14_2186 vddd vssd sg13cmos5l_decap_4
XFILLER_10_2006 vddd vssd sg13cmos5l_decap_4
XFILLER_20_495 vddd vssd sg13cmos5l_decap_8
Xclkbuf_leaf_31_SCK_regs _7285_/CLK clkload5/A vddd vssd sg13cmos5l_buf_8
X_6549_ _6549_/Y _6549_/A _6555_/S vddd vssd sg13cmos5l_nand2_1
XFILLER_14_1496 vddd vssd sg13cmos5l_decap_8
XFILLER_10_1327 vddd vssd sg13cmos5l_decap_4
XFILLER_27_2558 vddd vssd sg13cmos5l_decap_8
XFILLER_21_2102 vddd vssd sg13cmos5l_decap_8
XFILLER_0_878 vddd vssd sg13cmos5l_decap_4
XFILLER_21_1489 vddd vssd sg13cmos5l_decap_8
XFILLER_19_2064 vddd vssd sg13cmos5l_decap_8
XFILLER_15_267 vddd vssd sg13cmos5l_decap_8
XFILLER_32_2264 vddd vssd sg13cmos5l_decap_8
XFILLER_32_1530 vddd vssd sg13cmos5l_decap_8
XFILLER_23_70 vddd vssd sg13cmos5l_decap_8
XFILLER_15_1249 vddd vssd sg13cmos5l_decap_4
XFILLER_10_2573 vddd vssd sg13cmos5l_decap_8
XFILLER_26_2057 vddd vssd sg13cmos5l_decap_4
X_5920_ _5920_/Y _7091_/Q _6966_/Q _5939_/A _7092_/Q vddd vssd sg13cmos5l_a22oi_1
XFILLER_0_63 vddd vssd sg13cmos5l_decap_8
X_5851_ _5851_/Y _3548_/A _5849_/B _5849_/Y _5843_/Y _5852_/B vddd vssd sg13cmos5l_a221oi_1
X_5782_ _5789_/A _7208_/Q _5786_/B vddd vssd sg13cmos5l_nor2b_1
X_4802_ _4804_/B _4671_/A _4801_/Y _4799_/Y vddd vssd sg13cmos5l_o21ai_1
XFILLER_15_2451 vddd vssd sg13cmos5l_decap_8
X_4733_ _4755_/B _4707_/B _4733_/B vddd vssd sg13cmos5l_nand2b_1
XFILLER_11_1614 vddd vssd sg13cmos5l_decap_8
X_6403_ _7150_/D _6715_/A _6403_/A1 _6404_/B vddd vssd sg13cmos5l_mux2_1
X_4664_ _4664_/Y _4819_/A _4663_/B _4660_/Y vddd vssd sg13cmos5l_o21ai_1
X_3615_ _3615_/Y _3615_/A vddd vssd sg13cmos5l_inv_1
Xhold912 hold912/X _3610_/Y vddd vssd sg13cmos5l_dlygate4sd3_1
X_7383_ _7383_/Q _7383_/CLK _7383_/D _6807_/Y vddd vssd sg13cmos5l_dfrbpq_1
X_4595_ _4599_/C _4469_/B _7336_/Q vddd vssd sg13cmos5l_nand2b_1
Xhold901 _4312_/B _4336_/A vddd vssd sg13cmos5l_dlygate4sd3_1
Xhold923 hold923/X _7281_/Q vddd vssd sg13cmos5l_dlygate4sd3_1
Xhold945 _6504_/A _7204_/Q vddd vssd sg13cmos5l_dlygate4sd3_1
Xhold934 hold934/X _5497_/B vddd vssd sg13cmos5l_dlygate4sd3_1
X_6334_ _7114_/D hold709/X _6343_/B _6333_/Y vddd vssd sg13cmos5l_a21oi_1
X_3546_ _3546_/Y _3546_/A vddd vssd sg13cmos5l_inv_1
Xhold978 _7027_/D _6675_/Y vddd vssd sg13cmos5l_dlygate4sd3_1
X_6265_ _6265_/Y _6262_/Y _6263_/X _6264_/Y vddd vssd sg13cmos5l_o21ai_1
Xhold989 _6603_/A _7260_/Q vddd vssd sg13cmos5l_dlygate4sd3_1
Xhold967 hold967/X hold967/A vddd vssd sg13cmos5l_dlygate4sd3_1
Xhold956 hold956/X _6497_/Y vddd vssd sg13cmos5l_dlygate4sd3_1
X_3477_ _3477_/Y _4729_/A vddd vssd sg13cmos5l_inv_1
X_5216_ _5217_/A _5216_/A _5216_/B vddd vssd sg13cmos5l_or2_1
XFILLER_0_119 vddd vssd sg13cmos5l_decap_8
X_6196_ _6196_/Y _4195_/Y _6195_/A _6193_/Y _6195_/Y _5260_/A vddd vssd sg13cmos5l_a221oi_1
XFILLER_9_1074 vddd vssd sg13cmos5l_decap_8
XFILLER_28_37 vddd vssd sg13cmos5l_decap_8
XFILLER_22_2455 vddd vssd sg13cmos5l_decap_8
X_5147_ _5168_/A _7256_/Q _7257_/Q _5212_/B vddd vssd sg13cmos5l_nor3_1
X_5078_ _5088_/B _7271_/Q _7270_/Q _5248_/B vddd vssd sg13cmos5l_nor3_1
X_4029_ _4029_/Y _5887_/A _6533_/A _6525_/A vddd vssd sg13cmos5l_a21oi_1
XFILLER_0_2273 vddd vssd sg13cmos5l_decap_4
XFILLER_25_565 vddd vssd sg13cmos5l_decap_8
XFILLER_16_1525 vddd vssd sg13cmos5l_decap_8
XFILLER_20_292 vddd vssd sg13cmos5l_decap_4
XFILLER_14_1282 vddd vssd sg13cmos5l_decap_8
XFILLER_5_959 vddd vssd sg13cmos5l_decap_8
XFILLER_27_2355 vddd vssd sg13cmos5l_decap_8
XFILLER_27_1610 vddd vssd sg13cmos5l_decap_8
XFILLER_7_1737 vddd vssd sg13cmos5l_decap_8
Xtiedowns\[10\] io_in[2] vddd vssd sg13cmos5l_antennanp
XFILLER_5_1472 vddd vssd sg13cmos5l_decap_8
XFILLER_8_742 vddd vssd sg13cmos5l_decap_8
XFILLER_12_1923 vddd vssd sg13cmos5l_decap_8
XFILLER_7_285 vddd vssd sg13cmos5l_decap_8
X_4380_ _4384_/A _4771_/A _7116_/Q _4368_/Y vddd vssd sg13cmos5l_o21ai_1
XFILLER_12_1978 vddd vssd sg13cmos5l_decap_8
XFILLER_10_1680 vddd vssd sg13cmos5l_decap_8
XFILLER_26_1131 vddd vssd sg13cmos5l_decap_4
X_6050_ _6050_/Y _6241_/A _6049_/A _6049_/Y vddd vssd sg13cmos5l_a21oi_1
XFILLER_26_1164 vddd vssd sg13cmos5l_decap_4
X_5001_ _5008_/A _5219_/A _5272_/A vddd vssd sg13cmos5l_nor2_1
X_6952_ _6952_/Y _6952_/A _6952_/B_N vddd vssd sg13cmos5l_nor2b_1
X_6883_ _6883_/Y _6885_/A _6885_/B_N vddd vssd sg13cmos5l_nor2b_1
X_5903_ _5903_/Y _5903_/A _5908_/A _5912_/C vddd vssd sg13cmos5l_nor3_1
XFILLER_17_2546 vddd vssd sg13cmos5l_decap_8
X_5834_ _5835_/B _5637_/A _5857_/C _5857_/B vddd vssd sg13cmos5l_o21ai_1
XFILLER_22_557 vddd vssd sg13cmos5l_decap_8
XFILLER_17_1812 vddd vssd sg13cmos5l_decap_4
XFILLER_14_28 vddd vssd sg13cmos5l_decap_8
XFILLER_13_1709 vddd vssd sg13cmos5l_decap_4
X_5765_ _5765_/Y _5769_/A _5769_/B _5765_/C vddd vssd sg13cmos5l_nor3_1
X_5696_ _5696_/Y _5816_/A _5708_/B _5694_/Y vddd vssd sg13cmos5l_o21ai_1
X_4716_ _4716_/Y _4716_/A _4716_/B _4716_/C vddd vssd sg13cmos5l_nand3_1
XFILLER_11_2123 vddd vssd sg13cmos5l_decap_8
XFILLER_15_1591 vddd vssd sg13cmos5l_decap_8
X_4647_ _4648_/C _4806_/A1 _4646_/Y _4498_/Y vddd vssd sg13cmos5l_o21ai_1
XFILLER_30_49 vddd vssd sg13cmos5l_decap_8
Xhold720 _7091_/D _6777_/Y vddd vssd sg13cmos5l_dlygate4sd3_1
X_7366_ _7366_/Q _7398_/CLK _7366_/D _6879_/Y vddd vssd sg13cmos5l_dfrbpq_1
Xhold742 _7182_/D _6464_/X vddd vssd sg13cmos5l_dlygate4sd3_1
X_6317_ _7106_/D _6333_/A _6324_/B hold832/X vddd vssd sg13cmos5l_a21oi_1
Xhold764 hold764/X _7231_/Q vddd vssd sg13cmos5l_dlygate4sd3_1
Xhold731 hold731/X _3593_/Y vddd vssd sg13cmos5l_dlygate4sd3_1
X_4578_ _4579_/B _4575_/Y _4576_/Y _4577_/Y _4782_/A vddd vssd sg13cmos5l_a22oi_1
XFILLER_2_918 vddd vssd sg13cmos5l_decap_8
Xhold753 _7123_/D _6353_/Y vddd vssd sg13cmos5l_dlygate4sd3_1
XFILLER_24_2506 vddd vssd sg13cmos5l_decap_8
Xhold775 _5945_/A _6969_/Q vddd vssd sg13cmos5l_dlygate4sd3_1
X_3529_ _3529_/Y _3529_/A vddd vssd sg13cmos5l_inv_1
Xhold797 hold797/X _6374_/Y vddd vssd sg13cmos5l_dlygate4sd3_1
X_7297_ _7297_/Q _7364_/CLK _7297_/D _6810_/Y vddd vssd sg13cmos5l_dfrbpq_1
Xhold786 _7083_/D _6763_/Y vddd vssd sg13cmos5l_dlygate4sd3_1
X_6248_ _6248_/Y _6248_/A _6248_/B _6248_/C vddd vssd sg13cmos5l_nor3_1
X_6179_ _6180_/B _3791_/B _5243_/A _5239_/Y vddd vssd sg13cmos5l_a21oi_1
XFILLER_6_2460 vddd vssd sg13cmos5l_decap_8
XFILLER_29_123 vddd vssd sg13cmos5l_decap_8
Xhold1442 _7186_/D _6472_/X vddd vssd sg13cmos5l_dlygate4sd3_1
Xhold1420 hold1420/X _7222_/Q vddd vssd sg13cmos5l_dlygate4sd3_1
Xhold1431 _6366_/A _7132_/Q vddd vssd sg13cmos5l_dlygate4sd3_1
Xhold1453 _7045_/D _6702_/X vddd vssd sg13cmos5l_dlygate4sd3_1
Xhold1464 hold1464/X _7338_/Q vddd vssd sg13cmos5l_dlygate4sd3_1
Xhold1475 _6709_/A _7051_/Q vddd vssd sg13cmos5l_dlygate4sd3_1
XFILLER_2_1612 vddd vssd sg13cmos5l_decap_8
Xhold1486 _3530_/A _4641_/A vddd vssd sg13cmos5l_dlygate4sd3_1
Xhold1497 hold494/A _7009_/Q vddd vssd sg13cmos5l_dlygate4sd3_1
XFILLER_22_1584 vddd vssd sg13cmos5l_decap_8
XFILLER_26_852 vddd vssd sg13cmos5l_decap_8
XFILLER_25_373 vddd vssd sg13cmos5l_decap_4
XFILLER_16_2001 vddd vssd sg13cmos5l_decap_8
XFILLER_5_756 vddd vssd sg13cmos5l_decap_8
Xtiedowns\[58\] mask_rev_in[14] vddd vssd sg13cmos5l_antennanp
XFILLER_0_450 vddd vssd sg13cmos5l_decap_8
XFILLER_7_2279 vddd vssd sg13cmos5l_decap_8
XFILLER_27_1495 vddd vssd sg13cmos5l_decap_8
XFILLER_7_1556 vddd vssd sg13cmos5l_decap_8
XFILLER_5_1280 vddd vssd sg13cmos5l_decap_8
XFILLER_16_384 vddd vssd sg13cmos5l_decap_8
XFILLER_32_866 vddd vssd sg13cmos5l_decap_8
X_3880_ _6595_/A _3896_/A _3880_/B vddd vssd sg13cmos5l_nand2_1
X_5550_ _5574_/A _5683_/A _5550_/B _5550_/C vddd vssd sg13cmos5l_nand3_1
X_4501_ _4507_/A _4745_/B1 _4500_/Y _4499_/A vddd vssd sg13cmos5l_o21ai_1
X_5481_ _5482_/D _5676_/A _5483_/A _5481_/C vddd vssd sg13cmos5l_nor3_1
X_4432_ _4432_/Y _4432_/A _5956_/B vddd vssd sg13cmos5l_nor2b_1
X_7220_ _7220_/Q _7292_/CLK _7220_/D _6828_/B_N vddd vssd sg13cmos5l_dfrbpq_1
XFILLER_12_2498 vddd vssd sg13cmos5l_decap_8
X_4363_ _4396_/B _3489_/A _3540_/Y _4361_/Y _4362_/Y vddd vssd sg13cmos5l_a22oi_1
X_7151_ _7151_/Q _7355_/CLK _7151_/D _6827_/B_N vddd vssd sg13cmos5l_dfrbpq_1
XFILLER_28_1259 vddd vssd sg13cmos5l_decap_4
Xwire9 wire9/X wire9/A vddd vssd sg13cmos5l_buf_2
X_4294_ _4976_/C _4302_/B _4294_/B _4303_/B vddd vssd sg13cmos5l_nand3_1
X_6102_ _6102_/X _3513_/Y _7288_/Q _5090_/B vddd vssd sg13cmos5l_a21o_1
XFILLER_8_1309 vddd vssd sg13cmos5l_decap_8
X_7082_ _7082_/Q _7105_/CLK _7082_/D _6860_/B_N vddd vssd sg13cmos5l_dfrbpq_1
XFILLER_6_1011 vddd vssd sg13cmos5l_decap_8
X_6033_ _6034_/B _6203_/A _5089_/B _5089_/C vddd vssd sg13cmos5l_a21oi_1
Xoutbuffers\[41\] bandgap_trim[2] _6290_/Y vddd vssd sg13cmos5l_buf_16
XFILLER_23_2572 vddd vssd sg13cmos5l_decap_8
XFILLER_3_1932 vddd vssd sg13cmos5l_decap_8
XFILLER_26_126 vddd vssd sg13cmos5l_decap_8
X_6935_ _6935_/Y _6956_/A _6955_/B_N vddd vssd sg13cmos5l_nor2b_1
XFILLER_25_16 vddd vssd sg13cmos5l_decap_8
XFILLER_23_855 vddd vssd sg13cmos5l_decap_8
X_6866_ _6866_/Y _6911_/A _6867_/B_N vddd vssd sg13cmos5l_nor2b_1
X_6797_ _6797_/X _6797_/A vddd vssd sg13cmos5l_buf_1
X_5817_ _5818_/B _5817_/A _5817_/B _5817_/C vddd vssd sg13cmos5l_nor3_1
X_5748_ _5761_/A _5769_/A _5748_/B vddd vssd sg13cmos5l_nor2_1
XFILLER_30_2543 vddd vssd sg13cmos5l_decap_8
XFILLER_17_1697 vddd vssd sg13cmos5l_decap_8
X_5679_ _5680_/B _5679_/A _5679_/B _5682_/B vddd vssd sg13cmos5l_nand3_1
Xhold561 _6989_/D _6796_/X vddd vssd sg13cmos5l_dlygate4sd3_1
Xhold550 _4729_/A _6981_/Q vddd vssd sg13cmos5l_dlygate4sd3_1
Xhold572 _6549_/A _7228_/Q vddd vssd sg13cmos5l_dlygate4sd3_1
X_7349_ _7349_/Q _7350_/CLK _7349_/D _6862_/Y vddd vssd sg13cmos5l_dfrbpq_1
XFILLER_8_2522 vddd vssd sg13cmos5l_decap_8
XFILLER_28_2483 vddd vssd sg13cmos5l_decap_8
XFILLER_24_2314 vddd vssd sg13cmos5l_decap_4
Xhold583 hold583/X _4336_/Y vddd vssd sg13cmos5l_dlygate4sd3_1
Xhold594 _3762_/A _7389_/Q vddd vssd sg13cmos5l_dlygate4sd3_1
XFILLER_24_1602 vddd vssd sg13cmos5l_decap_8
Xhold1250 _7068_/D _6736_/X vddd vssd sg13cmos5l_dlygate4sd3_1
XFILLER_24_1668 vddd vssd sg13cmos5l_decap_4
Xhold1261 _3555_/A _7147_/Q vddd vssd sg13cmos5l_dlygate4sd3_1
Xhold1294 hold721/A _7372_/Q vddd vssd sg13cmos5l_dlygate4sd3_1
Xhold1272 _7203_/D _6502_/Y vddd vssd sg13cmos5l_dlygate4sd3_1
Xhold1283 _6428_/A1 _5444_/B vddd vssd sg13cmos5l_dlygate4sd3_1
XFILLER_26_671 vddd vssd sg13cmos5l_decap_4
XFILLER_14_811 vddd vssd sg13cmos5l_decap_4
XFILLER_25_170 vddd vssd sg13cmos5l_decap_8
XFILLER_9_325 vddd vssd sg13cmos5l_decap_4
XFILLER_16_1163 vddd vssd sg13cmos5l_decap_8
XFILLER_9_358 vddd vssd sg13cmos5l_decap_8
XFILLER_12_1005 vddd vssd sg13cmos5l_decap_4
XFILLER_29_1513 vddd vssd sg13cmos5l_decap_4
XFILLER_7_1353 vddd vssd sg13cmos5l_decap_8
XFILLER_7_2098 vddd vssd sg13cmos5l_decap_8
X_4981_ _5273_/A _7259_/Q _4981_/B vddd vssd sg13cmos5l_nand2_1
X_6720_ _7056_/D _6735_/A1 _6724_/S _6720_/B1 vddd vssd sg13cmos5l_o21ai_1
X_3932_ _3932_/Y _5669_/B _6480_/A _3930_/Y _3928_/Y _4212_/A2 vddd vssd sg13cmos5l_a221oi_1
XFILLER_32_663 vddd vssd sg13cmos5l_decap_8
X_3863_ _3863_/Y _4002_/C _3869_/B _3863_/C _3869_/D vddd vssd sg13cmos5l_nor4_1
XFILLER_20_825 vddd vssd sg13cmos5l_decap_8
XFILLER_14_2527 vddd vssd sg13cmos5l_decap_8
X_6651_ _6651_/X _6651_/A0 _6784_/A _6651_/S vddd vssd sg13cmos5l_mux2_1
XFILLER_31_184 vddd vssd sg13cmos5l_decap_8
X_5602_ _5602_/Y _5632_/A1 _5599_/Y _5600_/Y _5598_/Y _5601_/X vddd vssd sg13cmos5l_a221oi_1
XFILLER_18_1995 vddd vssd sg13cmos5l_decap_4
XFILLER_18_1973 vddd vssd sg13cmos5l_decap_8
XFILLER_14_1826 vddd vssd sg13cmos5l_decap_8
X_6582_ _6582_/X hold979/X _6704_/A0 _6582_/S vddd vssd sg13cmos5l_mux2_1
X_3794_ _3796_/B _7031_/Q _4176_/A2 _6642_/A _7289_/Q vddd vssd sg13cmos5l_a22oi_1
X_5533_ _5533_/X _5533_/A _5540_/A vddd vssd sg13cmos5l_or2_1
Xoutbuffers\[89\] io_out[4] _6103_/Y vddd vssd sg13cmos5l_buf_16
X_5464_ _5470_/A _5728_/A _5478_/B vddd vssd sg13cmos5l_nor2_1
X_4415_ _4415_/Y _4420_/A _4415_/B vddd vssd sg13cmos5l_nor2_1
X_5395_ _5396_/B _5393_/B _5392_/Y _5394_/Y vddd vssd sg13cmos5l_o21ai_1
X_7203_ _7203_/Q _7218_/CLK _7203_/D _6822_/B_N vddd vssd sg13cmos5l_dfrbpq_1
Xfanout304 _5543_/B hold1343/X vddd vssd sg13cmos5l_buf_1
XFILLER_28_1023 vddd vssd sg13cmos5l_decap_8
X_7134_ _7134_/Q _7378_/CLK _7134_/D fanout357/X vddd vssd sg13cmos5l_dfrbpq_1
X_4346_ _4346_/Y _4342_/A _4317_/A _4343_/A vddd vssd sg13cmos5l_o21ai_1
Xfanout315 _4608_/A1 _7079_/Q vddd vssd sg13cmos5l_buf_1
Xfanout337 _6701_/A1 fanout340/X vddd vssd sg13cmos5l_buf_1
Xfanout348 _6867_/B_N _6834_/B_N vddd vssd sg13cmos5l_buf_1
Xfanout326 _5604_/A1 _5916_/A1 vddd vssd sg13cmos5l_buf_1
X_7065_ _7065_/Q _7143_/CLK _7065_/D fanout357/X vddd vssd sg13cmos5l_dfrbpq_1
Xfanout359 _6827_/B_N fanout363/X vddd vssd sg13cmos5l_buf_1
X_4277_ _4277_/Y _6693_/A1 _4275_/S hold722/X vddd vssd sg13cmos5l_o21ai_1
X_6016_ _6016_/Y _4194_/X _5062_/C _7284_/Q vddd vssd sg13cmos5l_a21oi_1
XFILLER_3_2474 vddd vssd sg13cmos5l_decap_4
XFILLER_28_969 vddd vssd sg13cmos5l_decap_4
XFILLER_27_479 vddd vssd sg13cmos5l_decap_8
X_6918_ _6918_/Y _6919_/A _6919_/B_N vddd vssd sg13cmos5l_nor2b_1
X_6849_ _6849_/Y _6956_/A _6957_/B_N vddd vssd sg13cmos5l_nor2b_1
XFILLER_23_663 vddd vssd sg13cmos5l_decap_8
XFILLER_13_2004 vddd vssd sg13cmos5l_decap_4
XFILLER_32_1915 vddd vssd sg13cmos5l_decap_8
XFILLER_22_173 vddd vssd sg13cmos5l_decap_8
XFILLER_11_836 vddd vssd sg13cmos5l_decap_8
XFILLER_30_2340 vddd vssd sg13cmos5l_decap_8
XFILLER_11_1071 vddd vssd sg13cmos5l_decap_8
Xclkbuf_3_3_0_SCK_regs clkload4/A clkbuf_0_SCK_regs/X vddd vssd sg13cmos5l_buf_8
XFILLER_8_2385 vddd vssd sg13cmos5l_decap_8
XFILLER_8_1673 vddd vssd sg13cmos5l_decap_8
XFILLER_18_413 vddd vssd sg13cmos5l_decap_8
XFILLER_4_1537 vddd vssd sg13cmos5l_decap_8
Xhold1080 _3533_/A _7241_/Q vddd vssd sg13cmos5l_dlygate4sd3_1
Xhold1091 _4408_/B _4407_/Y vddd vssd sg13cmos5l_dlygate4sd3_1
XFILLER_26_490 vddd vssd sg13cmos5l_decap_8
XFILLER_26_70 vddd vssd sg13cmos5l_decap_8
XFILLER_9_100 vddd vssd sg13cmos5l_decap_8
XFILLER_13_2560 vddd vssd sg13cmos5l_decap_8
X_4200_ _4200_/Y _4192_/Y _4198_/Y _4199_/Y vddd vssd sg13cmos5l_o21ai_1
X_5180_ _5187_/A _6194_/C _5209_/B vddd vssd sg13cmos5l_and2_1
XFILLER_3_30 vddd vssd sg13cmos5l_decap_8
X_4131_ _4131_/Y _4128_/Y _4129_/Y _4130_/Y vddd vssd sg13cmos5l_o21ai_1
Xclkbuf_regs_1_SCK clkbuf_regs_1_SCK/X SCK vddd vssd sg13cmos5l_buf_8
XFILLER_3_52 vddd vssd sg13cmos5l_decap_8
X_4062_ _4062_/Y _4059_/Y _4060_/X _4061_/Y vddd vssd sg13cmos5l_o21ai_1
XFILLER_3_96 vddd vssd sg13cmos5l_decap_8
XFILLER_20_2542 vddd vssd sg13cmos5l_decap_8
XFILLER_25_906 vddd vssd sg13cmos5l_decap_8
Xwire25 wire25/X wire26/X vddd vssd sg13cmos5l_buf_4
Xwire14 wire14/X wire15/X vddd vssd sg13cmos5l_buf_4
Xwire58 wire58/X wire58/A vddd vssd sg13cmos5l_buf_4
X_4964_ _4965_/C _4964_/A _4964_/B vddd vssd sg13cmos5l_nor2_1
X_6703_ _6703_/X _6703_/A0 _6703_/A1 _6707_/S vddd vssd sg13cmos5l_mux2_1
XFILLER_18_2460 vddd vssd sg13cmos5l_decap_8
X_3915_ _6510_/A _3963_/A _3922_/A vddd vssd sg13cmos5l_nor2_1
XFILLER_32_493 vddd vssd sg13cmos5l_decap_8
X_4895_ _4903_/C _4828_/A _5285_/D _4894_/Y vddd vssd sg13cmos5l_a21oi_1
X_6634_ _6634_/X _6634_/A0 _6544_/A _6635_/S vddd vssd sg13cmos5l_mux2_1
XFILLER_22_28 vddd vssd sg13cmos5l_decap_8
X_3846_ _3846_/Y _7102_/Q _6304_/A _3845_/Y vddd vssd sg13cmos5l_o21ai_1
XFILLER_14_1656 vddd vssd sg13cmos5l_decap_4
X_6565_ _7236_/D _6565_/A1 _6568_/S _6564_/Y vddd vssd sg13cmos5l_a21oi_1
X_3777_ _3777_/Y _3777_/A _3777_/B _3777_/C vddd vssd sg13cmos5l_nand3_1
X_5516_ _5516_/Y _5604_/A1 _5489_/X _5515_/Y vddd vssd sg13cmos5l_a21oi_1
X_6496_ _6501_/B _6496_/A _6733_/B vddd vssd sg13cmos5l_nor2_1
XFILLER_12_2092 vddd vssd sg13cmos5l_decap_8
X_5447_ _5447_/Y _5639_/A _5447_/B vddd vssd sg13cmos5l_nand2_1
XFILLER_25_2431 vddd vssd sg13cmos5l_decap_8
X_5378_ _5379_/C _5527_/A _7152_/Q vddd vssd sg13cmos5l_nand2_1
Xfanout123 _4176_/A2 _6667_/A vddd vssd sg13cmos5l_buf_1
XFILLER_25_1730 vddd vssd sg13cmos5l_decap_4
X_4329_ _4329_/X _4329_/A _4329_/B vddd vssd sg13cmos5l_xor2_1
Xfanout156 _4807_/A _4432_/Y vddd vssd sg13cmos5l_buf_1
X_7117_ _7117_/Q _7125_/CLK _7117_/D fanout395/X vddd vssd sg13cmos5l_dfrbpq_1
XFILLER_5_2525 vddd vssd sg13cmos5l_decap_8
Xfanout134 _6699_/B _6748_/B vddd vssd sg13cmos5l_buf_1
X_7048_ _7048_/Q _7278_/CLK _7048_/D fanout382/X vddd vssd sg13cmos5l_dfrbpq_1
Xfanout189 _6627_/A _6665_/A0 vddd vssd sg13cmos5l_buf_1
Xfanout178 _5029_/A hold1468/X vddd vssd sg13cmos5l_buf_1
Xfanout167 _4336_/C hold1227/A vddd vssd sg13cmos5l_buf_1
XFILLER_5_1802 vddd vssd sg13cmos5l_decap_8
XFILLER_27_210 vddd vssd sg13cmos5l_decap_8
XFILLER_25_1796 vddd vssd sg13cmos5l_decap_4
XFILLER_3_2260 vddd vssd sg13cmos5l_decap_8
XFILLER_16_928 vddd vssd sg13cmos5l_decap_8
XFILLER_3_1592 vddd vssd sg13cmos5l_decap_8
XFILLER_24_961 vddd vssd sg13cmos5l_decap_8
XFILLER_19_2279 vddd vssd sg13cmos5l_decap_8
XFILLER_19_1534 vddd vssd sg13cmos5l_decap_8
XFILLER_15_1409 vddd vssd sg13cmos5l_decap_8
XFILLER_32_2468 vddd vssd sg13cmos5l_decap_8
XFILLER_10_121 vddd vssd sg13cmos5l_decap_8
XFILLER_11_666 vddd vssd sg13cmos5l_decap_8
XFILLER_32_1789 vddd vssd sg13cmos5l_decap_8
XFILLER_5_0 vddd vssd sg13cmos5l_decap_8
Xtiedowns\[40\] dbus_in_right[8] vddd vssd sg13cmos5l_antennanp
XFILLER_8_1470 vddd vssd sg13cmos5l_decap_8
XFILLER_19_733 vddd vssd sg13cmos5l_decap_4
XFILLER_4_2079 vddd vssd sg13cmos5l_decap_8
XFILLER_8_1492 vddd vssd sg13cmos5l_decap_8
XFILLER_20_1137 vddd vssd sg13cmos5l_decap_8
XFILLER_19_788 vddd vssd sg13cmos5l_decap_4
Xclkbuf_leaf_1_SCK_regs _7399_/CLK clkbuf_3_0_0_SCK_regs/X vddd vssd sg13cmos5l_buf_8
XFILLER_22_909 vddd vssd sg13cmos5l_decap_8
XFILLER_18_298 vddd vssd sg13cmos5l_decap_8
XFILLER_30_942 vddd vssd sg13cmos5l_decap_4
XFILLER_18_1044 vddd vssd sg13cmos5l_decap_8
X_3700_ _6332_/A _6315_/A _3911_/A vddd vssd sg13cmos5l_nor2_1
XFILLER_18_1077 vddd vssd sg13cmos5l_decap_4
X_4680_ _4681_/C _4680_/A _4680_/B vddd vssd sg13cmos5l_nor2_1
XFILLER_11_2519 vddd vssd sg13cmos5l_decap_8
X_6350_ _6350_/Y _6350_/A _6360_/S vddd vssd sg13cmos5l_nor2_1
X_3562_ _5447_/B _3562_/A vddd vssd sg13cmos5l_inv_1
X_5301_ _5301_/Y _5306_/B _5316_/A _5527_/A vddd vssd sg13cmos5l_nor3_1
X_3493_ _3493_/Y _3493_/A vddd vssd sg13cmos5l_inv_1
X_6281_ _6281_/X _5241_/A _6280_/Y _6261_/Y vddd vssd sg13cmos5l_a21o_1
X_5232_ _6171_/C _5268_/A _6000_/B vddd vssd sg13cmos5l_nand2_1
XFILLER_29_1184 vddd vssd sg13cmos5l_decap_8
X_5163_ _5170_/D _7236_/Q _5163_/B _5214_/B vddd vssd sg13cmos5l_nor3_1
X_4114_ _4114_/Y _7233_/Q _6556_/A _6548_/A vddd vssd sg13cmos5l_a21oi_1
X_5094_ _5274_/B _5240_/A _5240_/B vddd vssd sg13cmos5l_nand2b_1
XFILLER_22_1969 vddd vssd sg13cmos5l_decap_8
XFILLER_17_28 vddd vssd sg13cmos5l_decap_8
X_4045_ _4045_/Y _5511_/A _3946_/Y _3949_/Y vddd vssd sg13cmos5l_o21ai_1
XFILLER_0_2455 vddd vssd sg13cmos5l_decap_8
X_5996_ _5996_/Y _5996_/A _5996_/B _5996_/C vddd vssd sg13cmos5l_nor3_1
X_4947_ _4947_/X _4932_/A _4958_/B _4946_/Y vddd vssd sg13cmos5l_a21o_1
XFILLER_21_942 vddd vssd sg13cmos5l_decap_8
XFILLER_16_1729 vddd vssd sg13cmos5l_decap_8
X_4878_ _4901_/A _4878_/A _4878_/B _4878_/C vddd vssd sg13cmos5l_nand3_1
X_6617_ _7268_/D _6710_/A1 _6621_/S _6617_/B1 vddd vssd sg13cmos5l_a21oi_1
X_3829_ _6683_/A _3978_/A _6622_/B vddd vssd sg13cmos5l_or2_1
XFILLER_20_485 vddd vssd sg13cmos5l_decap_4
X_6548_ _6555_/S _6548_/A _6667_/B vddd vssd sg13cmos5l_nand2_1
XFILLER_3_117 vddd vssd sg13cmos5l_decap_8
X_6479_ _6479_/X _6501_/A _6479_/A1 _6479_/S vddd vssd sg13cmos5l_mux2_1
XFILLER_27_2537 vddd vssd sg13cmos5l_decap_8
XFILLER_5_2322 vddd vssd sg13cmos5l_decap_4
XFILLER_28_541 vddd vssd sg13cmos5l_decap_8
XFILLER_21_1468 vddd vssd sg13cmos5l_decap_8
XFILLER_16_703 vddd vssd sg13cmos5l_decap_4
XFILLER_16_758 vddd vssd sg13cmos5l_decap_8
XFILLER_30_227 vddd vssd sg13cmos5l_decap_4
XFILLER_19_1331 vddd vssd sg13cmos5l_decap_8
XFILLER_32_2243 vddd vssd sg13cmos5l_decap_4
XFILLER_12_953 vddd vssd sg13cmos5l_decap_8
XFILLER_7_489 vddd vssd sg13cmos5l_decap_8
XFILLER_10_2552 vddd vssd sg13cmos5l_decap_8
XFILLER_31_7 vddd vssd sg13cmos5l_decap_4
XFILLER_0_42 vddd vssd sg13cmos5l_decap_8
X_5850_ _5852_/B _7216_/Q _7217_/Q _5850_/C vddd vssd sg13cmos5l_nor3_1
X_4801_ _4801_/Y _3504_/Y _4800_/A _4800_/Y vddd vssd sg13cmos5l_o21ai_1
X_5781_ _5781_/Y _5779_/Y _5780_/Y _5786_/C vddd vssd sg13cmos5l_o21ai_1
XFILLER_15_2430 vddd vssd sg13cmos5l_decap_8
X_4732_ _4732_/Y _4714_/C _4733_/B _4745_/B1 vddd vssd sg13cmos5l_a21oi_1
XFILLER_9_84 vddd vssd sg13cmos5l_decap_4
X_4663_ _4663_/Y _4819_/A _4663_/B vddd vssd sg13cmos5l_nor2_1
XFILLER_15_1762 vddd vssd sg13cmos5l_decap_4
X_3614_ _3614_/Y mask_rev_in[9] vddd vssd sg13cmos5l_inv_1
X_6402_ _6402_/X _6686_/A _6402_/A1 _6404_/B vddd vssd sg13cmos5l_mux2_1
X_4594_ _4594_/Y _4594_/A1 _4593_/Y _4591_/Y vddd vssd sg13cmos5l_o21ai_1
X_7382_ _7382_/Q _7382_/CLK _7382_/D _6808_/Y vddd vssd sg13cmos5l_dfrbpq_1
Xhold902 _4342_/B _4317_/A vddd vssd sg13cmos5l_dlygate4sd3_1
Xhold913 hold913/X _7290_/Q vddd vssd sg13cmos5l_dlygate4sd3_1
Xhold924 _7281_/D _6639_/X vddd vssd sg13cmos5l_dlygate4sd3_1
X_3545_ _3545_/Y _5607_/A vddd vssd sg13cmos5l_inv_1
Xhold946 hold946/X _6504_/Y vddd vssd sg13cmos5l_dlygate4sd3_1
X_6333_ _6333_/Y _6333_/A _6343_/B vddd vssd sg13cmos5l_nor2_1
Xhold935 hold935/X hold935/A vddd vssd sg13cmos5l_dlygate4sd3_1
X_3476_ _3476_/Y _4674_/B vddd vssd sg13cmos5l_inv_1
Xoutbuffers\[71\] idac1_value[3] _7037_/Q vddd vssd sg13cmos5l_buf_16
X_6264_ _6264_/Y _4107_/Y _5008_/B _5021_/B vddd vssd sg13cmos5l_a21oi_1
Xhold957 hold957/X hold957/A vddd vssd sg13cmos5l_dlygate4sd3_1
Xhold968 hold968/X _4949_/A vddd vssd sg13cmos5l_dlygate4sd3_1
Xhold979 hold979/X _7247_/Q vddd vssd sg13cmos5l_dlygate4sd3_1
X_5215_ _6151_/B _5215_/A _5215_/B vddd vssd sg13cmos5l_nor2_1
X_6195_ _6195_/Y _6195_/A _6194_/Y vddd vssd sg13cmos5l_nor2b_1
XFILLER_26_2581 vddd vssd sg13cmos5l_decap_8
XFILLER_9_1053 vddd vssd sg13cmos5l_decap_4
XFILLER_28_16 vddd vssd sg13cmos5l_decap_8
XFILLER_22_2434 vddd vssd sg13cmos5l_decap_8
X_5146_ _5212_/B _7259_/Q _7258_/Q vddd vssd sg13cmos5l_nand2b_1
X_5077_ _5248_/B _7268_/Q _5077_/B vddd vssd sg13cmos5l_nand2_1
XFILLER_22_1766 vddd vssd sg13cmos5l_decap_8
XFILLER_2_1849 vddd vssd sg13cmos5l_decap_8
X_4028_ _4028_/Y _6540_/A _4026_/Y _4027_/Y vddd vssd sg13cmos5l_o21ai_1
XFILLER_25_544 vddd vssd sg13cmos5l_decap_8
X_5979_ _5979_/Y _7234_/Q _7235_/Q _5979_/C vddd vssd sg13cmos5l_nor3_1
XFILLER_16_1504 vddd vssd sg13cmos5l_decap_8
XFILLER_4_404 vddd vssd sg13cmos5l_decap_8
XFILLER_5_938 vddd vssd sg13cmos5l_decap_8
XFILLER_27_2334 vddd vssd sg13cmos5l_decap_8
XFILLER_4_459 vddd vssd sg13cmos5l_decap_4
XFILLER_10_1169 vddd vssd sg13cmos5l_decap_4
XFILLER_27_1600 vddd vssd sg13cmos5l_decap_4
XFILLER_7_1716 vddd vssd sg13cmos5l_decap_8
XFILLER_27_1699 vddd vssd sg13cmos5l_decap_8
XFILLER_5_2141 vddd vssd sg13cmos5l_decap_8
XFILLER_29_850 vddd vssd sg13cmos5l_decap_8
XFILLER_5_1451 vddd vssd sg13cmos5l_decap_8
XFILLER_1_2049 vddd vssd sg13cmos5l_decap_8
XFILLER_1_1348 vddd vssd sg13cmos5l_decap_4
XFILLER_16_588 vddd vssd sg13cmos5l_decap_8
XFILLER_12_2603 vddd vssd sg13cmos5l_decap_4
XFILLER_11_293 vddd vssd sg13cmos5l_decap_8
Xwire162 _4889_/B _3640_/Y vddd vssd sg13cmos5l_buf_4
XFILLER_32_1394 vddd vssd sg13cmos5l_decap_8
XFILLER_28_1419 vddd vssd sg13cmos5l_decap_8
X_5000_ _5272_/A _7266_/Q _7267_/Q vddd vssd sg13cmos5l_nand2b_1
XFILLER_6_1259 vddd vssd sg13cmos5l_decap_4
X_6951_ _6951_/Y _6952_/A _6952_/B_N vddd vssd sg13cmos5l_nor2b_1
X_6882_ _6882_/Y _6911_/A _6909_/B_N vddd vssd sg13cmos5l_nor2b_1
X_5902_ _5902_/X _5902_/A _5908_/A vddd vssd sg13cmos5l_or2_1
XFILLER_17_2525 vddd vssd sg13cmos5l_decap_8
X_5833_ _5835_/A _5897_/A _7216_/Q _7217_/Q vddd vssd sg13cmos5l_nor3_1
XFILLER_22_536 vddd vssd sg13cmos5l_decap_8
X_5764_ _5764_/X _5882_/A _5764_/B vddd vssd sg13cmos5l_and2_1
XFILLER_11_2102 vddd vssd sg13cmos5l_decap_8
X_5695_ _5695_/Y _5899_/A _5695_/B _5701_/B vddd vssd sg13cmos5l_nor3_1
X_4715_ _4716_/C _4745_/B1 _4714_/Y _4499_/A vddd vssd sg13cmos5l_o21ai_1
XFILLER_30_28 vddd vssd sg13cmos5l_decap_8
X_4646_ _4646_/Y _4670_/A _4670_/B _4621_/B vddd vssd sg13cmos5l_a21oi_1
XFILLER_11_2157 vddd vssd sg13cmos5l_decap_8
Xhold710 _5936_/A _6965_/Q vddd vssd sg13cmos5l_dlygate4sd3_1
X_4577_ _4577_/Y _4577_/A _4577_/B vddd vssd sg13cmos5l_xnor2_1
Xhold721 _4276_/A hold721/A vddd vssd sg13cmos5l_dlygate4sd3_1
X_7365_ _7365_/Q _7399_/CLK _7365_/D _6878_/Y vddd vssd sg13cmos5l_dfrbpq_1
X_6316_ _6316_/Y _6316_/A _6324_/B vddd vssd sg13cmos5l_nor2_1
Xhold754 _6370_/A _7134_/Q vddd vssd sg13cmos5l_dlygate4sd3_1
Xhold732 _7097_/D _6785_/Y vddd vssd sg13cmos5l_dlygate4sd3_1
Xhold743 _3592_/A _7227_/Q vddd vssd sg13cmos5l_dlygate4sd3_1
Xhold765 _7231_/D _6555_/X vddd vssd sg13cmos5l_dlygate4sd3_1
Xhold776 _5946_/C _5945_/Y vddd vssd sg13cmos5l_dlygate4sd3_1
Xhold787 _4333_/B _7356_/Q vddd vssd sg13cmos5l_dlygate4sd3_1
X_7296_ _7296_/Q _7372_/CLK _7296_/D _6659_/Y vddd vssd sg13cmos5l_dfrbpq_1
X_3528_ _3528_/Y _3528_/A vddd vssd sg13cmos5l_inv_1
XFILLER_28_1942 vddd vssd sg13cmos5l_decap_8
X_6247_ _6248_/C _4196_/X _5278_/B _6246_/Y vddd vssd sg13cmos5l_a21oi_1
Xhold798 _7136_/D _6375_/Y vddd vssd sg13cmos5l_dlygate4sd3_1
X_3459_ _3459_/Y _7083_/Q vddd vssd sg13cmos5l_inv_1
XFILLER_29_102 vddd vssd sg13cmos5l_decap_8
XFILLER_28_1997 vddd vssd sg13cmos5l_decap_8
Xhold1410 hold1410/X _7143_/Q vddd vssd sg13cmos5l_dlygate4sd3_1
XFILLER_24_1839 vddd vssd sg13cmos5l_decap_8
X_6178_ _6180_/A _3768_/X _5241_/C _6177_/Y vddd vssd sg13cmos5l_o21ai_1
XFILLER_22_2242 vddd vssd sg13cmos5l_decap_8
X_5129_ _5141_/B _5129_/A _5129_/B vddd vssd sg13cmos5l_nor2_1
XFILLER_2_2325 vddd vssd sg13cmos5l_decap_4
Xhold1421 _6538_/A1 _5887_/A vddd vssd sg13cmos5l_dlygate4sd3_1
Xhold1443 _4786_/A _7328_/Q vddd vssd sg13cmos5l_dlygate4sd3_1
Xhold1432 _6367_/B1 _6366_/Y vddd vssd sg13cmos5l_dlygate4sd3_1
XFILLER_29_179 vddd vssd sg13cmos5l_decap_8
Xhold1465 _7338_/D _4567_/X vddd vssd sg13cmos5l_dlygate4sd3_1
Xhold1476 _6710_/B1 _6709_/Y vddd vssd sg13cmos5l_dlygate4sd3_1
Xhold1454 hold1454/X _7377_/Q vddd vssd sg13cmos5l_dlygate4sd3_1
Xhold1498 _7010_/D _4559_/B vddd vssd sg13cmos5l_dlygate4sd3_1
Xhold1487 _7078_/D _6752_/Y vddd vssd sg13cmos5l_dlygate4sd3_1
XFILLER_5_735 vddd vssd sg13cmos5l_decap_8
XFILLER_29_2429 vddd vssd sg13cmos5l_decap_8
XFILLER_27_1430 vddd vssd sg13cmos5l_decap_8
XFILLER_7_1535 vddd vssd sg13cmos5l_decap_8
XFILLER_7_2258 vddd vssd sg13cmos5l_decap_8
XFILLER_23_1338 vddd vssd sg13cmos5l_decap_8
XFILLER_21_1051 vddd vssd sg13cmos5l_decap_8
XFILLER_28_190 vddd vssd sg13cmos5l_decap_8
XFILLER_17_897 vddd vssd sg13cmos5l_decap_8
XFILLER_32_845 vddd vssd sg13cmos5l_decap_8
XFILLER_12_591 vddd vssd sg13cmos5l_decap_8
X_4500_ _4500_/Y _4530_/A _4530_/B _4474_/A vddd vssd sg13cmos5l_a21oi_1
X_5480_ _5482_/C _5626_/A _7164_/Q _7165_/Q _5480_/D vddd vssd sg13cmos5l_nor4_1
XFILLER_12_2477 vddd vssd sg13cmos5l_decap_8
XANTENNA_1 _6287_/A vddd vssd sg13cmos5l_antennanp
X_4431_ _4498_/A _4641_/A _4734_/A vddd vssd sg13cmos5l_nand2_1
XFILLER_8_595 vddd vssd sg13cmos5l_decap_8
XFILLER_12_1754 vddd vssd sg13cmos5l_decap_8
XFILLER_6_63 vddd vssd sg13cmos5l_decap_8
X_4362_ _4362_/Y _3489_/Y _7089_/Q _7088_/Q _3490_/Y vddd vssd sg13cmos5l_a22oi_1
X_7150_ _7150_/Q _7179_/CLK _7150_/D _6827_/B_N vddd vssd sg13cmos5l_dfrbpq_1
X_4293_ _4293_/Y _4293_/A _4293_/B vddd vssd sg13cmos5l_nor2_1
X_6101_ _6101_/Y _4194_/X _5170_/D _6099_/Y _6100_/Y _7288_/Q vddd vssd sg13cmos5l_a221oi_1
X_7081_ _7081_/Q _7255_/CLK _7081_/D fanout396/X vddd vssd sg13cmos5l_dfrbpq_1
X_6032_ _6032_/Y _3820_/X _5076_/X _6030_/Y _6031_/Y _5089_/B vddd vssd sg13cmos5l_a221oi_1
XFILLER_3_2601 vddd vssd sg13cmos5l_decap_4
XFILLER_23_2551 vddd vssd sg13cmos5l_decap_8
XFILLER_20_0 vddd vssd sg13cmos5l_decap_8
Xoutbuffers\[34\] bandgap_sink1[2] _7058_/Q vddd vssd sg13cmos5l_buf_16
XFILLER_26_105 vddd vssd sg13cmos5l_decap_8
X_6934_ _6934_/Y _6958_/A _6957_/B_N vddd vssd sg13cmos5l_nor2b_1
XFILLER_23_823 vddd vssd sg13cmos5l_decap_4
XFILLER_22_322 vddd vssd sg13cmos5l_decap_8
XFILLER_17_1610 vddd vssd sg13cmos5l_decap_8
X_6865_ _6865_/Y _6911_/A _6867_/B_N vddd vssd sg13cmos5l_nor2b_1
X_6796_ _6796_/X _6796_/A vddd vssd sg13cmos5l_buf_1
X_5816_ _5817_/C _5816_/A _7215_/Q vddd vssd sg13cmos5l_nor2_1
XFILLER_30_2522 vddd vssd sg13cmos5l_decap_8
XFILLER_17_1654 vddd vssd sg13cmos5l_decap_8
X_5747_ _5748_/B _5747_/A _5747_/B vddd vssd sg13cmos5l_nor2_1
XFILLER_30_2599 vddd vssd sg13cmos5l_decap_8
XFILLER_30_1854 vddd vssd sg13cmos5l_decap_8
X_5678_ _5680_/A _5673_/Y _5674_/Y _5677_/Y vddd vssd sg13cmos5l_o21ai_1
X_4629_ _4629_/Y _4616_/Y _4626_/Y _4511_/Y vddd vssd sg13cmos5l_o21ai_1
Xhold562 _6792_/A _6999_/Q vddd vssd sg13cmos5l_dlygate4sd3_1
Xhold540 _6798_/A _6982_/Q vddd vssd sg13cmos5l_dlygate4sd3_1
Xhold551 _6982_/D _3477_/Y vddd vssd sg13cmos5l_dlygate4sd3_1
X_7348_ _7348_/Q _7348_/CLK _7348_/D _6861_/Y vddd vssd sg13cmos5l_dfrbpq_1
XFILLER_8_2501 vddd vssd sg13cmos5l_decap_8
XFILLER_9_7 vddd vssd sg13cmos5l_decap_8
XFILLER_28_2462 vddd vssd sg13cmos5l_decap_8
X_7279_ _7279_/Q _7279_/CLK _7279_/D fanout385/X vddd vssd sg13cmos5l_dfrbpq_1
Xhold573 hold573/X _6549_/Y vddd vssd sg13cmos5l_dlygate4sd3_1
Xhold584 _7356_/D _4338_/Y vddd vssd sg13cmos5l_dlygate4sd3_1
Xhold595 hold595/X _3762_/Y vddd vssd sg13cmos5l_dlygate4sd3_1
XFILLER_8_2578 vddd vssd sg13cmos5l_decap_4
XFILLER_24_2359 vddd vssd sg13cmos5l_decap_8
XFILLER_8_1877 vddd vssd sg13cmos5l_decap_4
Xhold1240 _3620_/A _7041_/Q vddd vssd sg13cmos5l_dlygate4sd3_1
XFILLER_22_2061 vddd vssd sg13cmos5l_decap_4
Xhold1251 _6587_/A0 _7250_/Q vddd vssd sg13cmos5l_dlygate4sd3_1
XFILLER_22_1360 vddd vssd sg13cmos5l_decap_8
Xhold1262 _6398_/A1 _5339_/C vddd vssd sg13cmos5l_dlygate4sd3_1
Xhold1273 _6499_/A0 _7201_/Q vddd vssd sg13cmos5l_dlygate4sd3_1
Xhold1284 _7163_/D _6428_/Y vddd vssd sg13cmos5l_dlygate4sd3_1
Xhold1295 _7296_/D _4977_/Y vddd vssd sg13cmos5l_dlygate4sd3_1
XFILLER_32_119 vddd vssd sg13cmos5l_decap_8
XFILLER_18_2108 vddd vssd sg13cmos5l_decap_8
XFILLER_13_388 vddd vssd sg13cmos5l_decap_8
XFILLER_16_1197 vddd vssd sg13cmos5l_decap_8
Xtiedowns\[70\] mask_rev_in[26] vddd vssd sg13cmos5l_antennanp
XFILLER_31_93 vddd vssd sg13cmos5l_decap_8
XFILLER_3_1229 vddd vssd sg13cmos5l_decap_8
XFILLER_23_119 vddd vssd sg13cmos5l_decap_8
X_4980_ _5212_/A _7256_/Q _7257_/Q vddd vssd sg13cmos5l_nand2_1
XFILLER_32_642 vddd vssd sg13cmos5l_decap_8
X_3931_ _6474_/A _3931_/A _3967_/B vddd vssd sg13cmos5l_and2_1
X_3862_ _3862_/Y _6622_/A _6615_/B vddd vssd sg13cmos5l_nor2_1
XFILLER_18_1952 vddd vssd sg13cmos5l_decap_8
XFILLER_14_2506 vddd vssd sg13cmos5l_decap_8
X_6650_ _6650_/X hold913/X _6328_/A _6650_/S vddd vssd sg13cmos5l_mux2_1
XFILLER_31_163 vddd vssd sg13cmos5l_decap_8
X_5601_ _5601_/X _5601_/A _5601_/B vddd vssd sg13cmos5l_and2_1
XFILLER_14_1805 vddd vssd sg13cmos5l_decap_8
X_6581_ _6581_/X _6581_/A0 _6703_/A0 _6582_/S vddd vssd sg13cmos5l_mux2_1
XFILLER_30_1117 vddd vssd sg13cmos5l_decap_8
X_3793_ _4145_/B _3978_/A _6759_/B vddd vssd sg13cmos5l_or2_1
X_5532_ _5532_/X _5532_/A _5540_/B vddd vssd sg13cmos5l_or2_1
X_5463_ _5478_/B _5463_/A _7165_/Q vddd vssd sg13cmos5l_nand2_1
X_4414_ _4414_/Y _4414_/A _4414_/B vddd vssd sg13cmos5l_xnor2_1
X_5394_ _5394_/Y _7155_/Q _5398_/D _5394_/C vddd vssd sg13cmos5l_nand3_1
X_7202_ _7202_/Q _7295_/CLK _7202_/D _6822_/B_N vddd vssd sg13cmos5l_dfrbpq_1
Xfanout305 _5540_/A _5543_/A vddd vssd sg13cmos5l_buf_1
X_7133_ _7133_/Q _7355_/CLK _7133_/D _6907_/B_N vddd vssd sg13cmos5l_dfrbpq_1
X_4345_ _4345_/X _4345_/A _4345_/B vddd vssd sg13cmos5l_xor2_1
XFILLER_28_1068 vddd vssd sg13cmos5l_decap_4
Xfanout338 _6333_/A _6710_/A1 vddd vssd sg13cmos5l_buf_1
Xfanout316 _4435_/A _4814_/A1 vddd vssd sg13cmos5l_buf_1
XFILLER_8_1118 vddd vssd sg13cmos5l_decap_8
Xfanout327 _5916_/A1 _3552_/Y vddd vssd sg13cmos5l_buf_1
X_7064_ _7064_/Q _7069_/CLK _7064_/D fanout357/X vddd vssd sg13cmos5l_dfrbpq_1
Xfanout349 _6834_/B_N _6838_/B_N vddd vssd sg13cmos5l_buf_1
X_4276_ _4276_/Y _4276_/A _4276_/B vddd vssd sg13cmos5l_nand2_1
XFILLER_23_2381 vddd vssd sg13cmos5l_decap_8
X_6015_ _6015_/Y _6011_/Y _6013_/X _6014_/Y vddd vssd sg13cmos5l_o21ai_1
XFILLER_28_948 vddd vssd sg13cmos5l_decap_8
XFILLER_27_425 vddd vssd sg13cmos5l_decap_8
Xclkbuf_leaf_25_SCK_regs _7100_/CLK clkload8/A vddd vssd sg13cmos5l_buf_8
X_6917_ _6917_/Y _6919_/A _6919_/B_N vddd vssd sg13cmos5l_nor2b_1
XFILLER_19_1716 vddd vssd sg13cmos5l_decap_8
X_6848_ _6848_/Y _6959_/A _6958_/B_N vddd vssd sg13cmos5l_nor2b_1
XFILLER_23_653 vddd vssd sg13cmos5l_decap_4
XFILLER_22_152 vddd vssd sg13cmos5l_decap_8
X_6779_ _6779_/Y _6790_/A _6781_/S hold676/X vddd vssd sg13cmos5l_a21oi_1
XFILLER_30_2396 vddd vssd sg13cmos5l_decap_8
XFILLER_30_1662 vddd vssd sg13cmos5l_decap_4
XFILLER_8_2342 vddd vssd sg13cmos5l_decap_8
XFILLER_24_1422 vddd vssd sg13cmos5l_decap_8
XFILLER_24_1400 vddd vssd sg13cmos5l_decap_8
XFILLER_24_1444 vddd vssd sg13cmos5l_decap_4
XFILLER_4_2239 vddd vssd sg13cmos5l_decap_8
XFILLER_20_1308 vddd vssd sg13cmos5l_decap_8
Xhold1081 _6573_/A1 _5199_/B vddd vssd sg13cmos5l_dlygate4sd3_1
Xhold1092 _7349_/D _4408_/Y vddd vssd sg13cmos5l_dlygate4sd3_1
Xhold1070 _7179_/D _6458_/Y vddd vssd sg13cmos5l_dlygate4sd3_1
XFILLER_31_1415 vddd vssd sg13cmos5l_decap_4
XFILLER_29_2034 vddd vssd sg13cmos5l_decap_8
XFILLER_29_2078 vddd vssd sg13cmos5l_decap_8
XFILLER_29_1333 vddd vssd sg13cmos5l_decap_8
XFILLER_9_1405 vddd vssd sg13cmos5l_decap_8
XFILLER_9_2117 vddd vssd sg13cmos5l_decap_8
X_4130_ _4130_/Y _7181_/Q _6459_/A _3939_/Y vddd vssd sg13cmos5l_a21oi_1
X_4061_ _4061_/Y _3620_/Y _3831_/X _3828_/Y vddd vssd sg13cmos5l_a21oi_1
XFILLER_7_1151 vddd vssd sg13cmos5l_decap_8
XFILLER_20_2521 vddd vssd sg13cmos5l_decap_8
XFILLER_7_1173 vddd vssd sg13cmos5l_decap_8
Xwire15 wire15/X wire15/A vddd vssd sg13cmos5l_buf_4
Xwire26 wire26/X wire26/A vddd vssd sg13cmos5l_buf_4
XFILLER_20_2598 vddd vssd sg13cmos5l_decap_8
XFILLER_20_1853 vddd vssd sg13cmos5l_decap_4
Xwire59 wire59/X wire59/A vddd vssd sg13cmos5l_buf_4
XFILLER_0_1958 vddd vssd sg13cmos5l_decap_8
X_4963_ _4963_/Y _4965_/B _4962_/Y hold855/X vddd vssd sg13cmos5l_o21ai_1
X_6702_ _6702_/X _6655_/A _6702_/A1 _6707_/S vddd vssd sg13cmos5l_mux2_1
X_3914_ _3914_/Y _3861_/Y _3913_/Y _3859_/Y vddd vssd sg13cmos5l_o21ai_1
X_6633_ _7277_/D _6633_/A1 _6635_/S _6632_/Y vddd vssd sg13cmos5l_o21ai_1
X_4894_ _4894_/Y _4894_/A _4894_/B vddd vssd sg13cmos5l_nand2_1
XFILLER_14_1624 vddd vssd sg13cmos5l_decap_8
X_3845_ _3845_/Y _3990_/A _3990_/B vddd vssd sg13cmos5l_nor2_1
X_6564_ _6564_/Y _6564_/A _6568_/S vddd vssd sg13cmos5l_nor2_1
X_3776_ _3777_/C _7104_/Q _3803_/B _4073_/A _7088_/Q _3775_/X vddd vssd sg13cmos5l_a221oi_1
XFILLER_14_1679 vddd vssd sg13cmos5l_decap_8
X_5515_ _5515_/Y _5507_/A _5513_/A _5513_/X _5428_/A _5514_/Y vddd vssd sg13cmos5l_a221oi_1
XFILLER_12_2071 vddd vssd sg13cmos5l_decap_8
X_6495_ _7199_/D _6501_/A _5708_/B _6495_/S vddd vssd sg13cmos5l_mux2_1
X_5446_ _5446_/X _5532_/A _7163_/Q vddd vssd sg13cmos5l_or2_1
XFILLER_29_2590 vddd vssd sg13cmos5l_decap_8
XFILLER_25_2410 vddd vssd sg13cmos5l_decap_8
X_5377_ _5377_/Y _5604_/A1 _5352_/X _5376_/Y vddd vssd sg13cmos5l_a21oi_1
X_4328_ _4329_/B _4313_/X _4320_/C _4330_/A vddd vssd sg13cmos5l_o21ai_1
Xfanout135 _6748_/B _6302_/Y vddd vssd sg13cmos5l_buf_1
X_7116_ _7116_/Q _7125_/CLK _7116_/D fanout395/X vddd vssd sg13cmos5l_dfrbpq_1
XFILLER_5_2504 vddd vssd sg13cmos5l_decap_8
XFILLER_5_2537 vddd vssd sg13cmos5l_decap_8
Xfanout146 _5090_/B _5247_/B vddd vssd sg13cmos5l_buf_1
X_7047_ _7047_/Q _7279_/CLK _7047_/D fanout385/X vddd vssd sg13cmos5l_dfrbpq_1
XFILLER_25_2487 vddd vssd sg13cmos5l_decap_8
XFILLER_25_1753 vddd vssd sg13cmos5l_decap_8
Xfanout179 _5028_/A _6739_/A1 vddd vssd sg13cmos5l_buf_1
X_4259_ _4259_/Y wire1/X _4256_/Y _4258_/Y vddd vssd sg13cmos5l_a21oi_1
Xfanout157 _4552_/A _4430_/Y vddd vssd sg13cmos5l_buf_1
Xfanout168 _3669_/S hold1227/A vddd vssd sg13cmos5l_buf_1
XFILLER_27_277 vddd vssd sg13cmos5l_decap_8
XFILLER_15_406 vddd vssd sg13cmos5l_decap_8
XFILLER_19_2258 vddd vssd sg13cmos5l_decap_8
XFILLER_19_1579 vddd vssd sg13cmos5l_decap_8
XFILLER_10_100 vddd vssd sg13cmos5l_decap_8
XFILLER_32_2447 vddd vssd sg13cmos5l_decap_8
XFILLER_17_1270 vddd vssd sg13cmos5l_decap_4
XFILLER_32_1757 vddd vssd sg13cmos5l_decap_8
XFILLER_6_126 vddd vssd sg13cmos5l_decap_4
XFILLER_12_84 vddd vssd sg13cmos5l_decap_8
XFILLER_26_1539 vddd vssd sg13cmos5l_decap_8
XFILLER_26_1528 vddd vssd sg13cmos5l_decap_4
Xtiedowns\[33\] dbus_in_right[1] vddd vssd sg13cmos5l_antennanp
XFILLER_8_2183 vddd vssd sg13cmos5l_decap_8
XFILLER_19_712 vddd vssd sg13cmos5l_decap_8
XFILLER_18_200 vddd vssd sg13cmos5l_decap_8
XFILLER_20_1105 vddd vssd sg13cmos5l_decap_4
XFILLER_19_767 vddd vssd sg13cmos5l_decap_8
XFILLER_2_1092 vddd vssd sg13cmos5l_decap_8
XFILLER_30_987 vddd vssd sg13cmos5l_decap_4
X_3630_ _3630_/Y mask_rev_in[15] vddd vssd sg13cmos5l_inv_1
X_3561_ _5441_/B _3561_/A vddd vssd sg13cmos5l_inv_1
XFILLER_31_1278 vddd vssd sg13cmos5l_decap_8
X_5300_ _5300_/Y _5316_/C _5299_/Y _5316_/A vddd vssd sg13cmos5l_o21ai_1
X_3492_ _3492_/Y _4398_/B vddd vssd sg13cmos5l_inv_1
X_6280_ _6280_/Y _6122_/A _6279_/A _6277_/Y _6279_/Y vddd vssd sg13cmos5l_a22oi_1
X_5231_ _5242_/B _7248_/Q _7249_/Q _5263_/A vddd vssd sg13cmos5l_nor3_1
XFILLER_29_1163 vddd vssd sg13cmos5l_decap_8
X_5162_ _5214_/B _7239_/Q _7238_/Q vddd vssd sg13cmos5l_nand2b_1
X_5093_ _6049_/A _7267_/Q _7266_/Q _5272_/B vddd vssd sg13cmos5l_nor3_1
X_4113_ _4113_/Y _3791_/A _4109_/Y _4112_/Y vddd vssd sg13cmos5l_o21ai_1
X_4044_ _4044_/Y _5543_/A _6443_/A _4042_/Y _4043_/Y _6435_/A vddd vssd sg13cmos5l_a221oi_1
XFILLER_0_2434 vddd vssd sg13cmos5l_decap_8
XFILLER_24_203 vddd vssd sg13cmos5l_decap_8
X_5995_ _5996_/C _7359_/Q _4336_/C vddd vssd sg13cmos5l_nor2b_1
XFILLER_21_921 vddd vssd sg13cmos5l_decap_8
XFILLER_16_1708 vddd vssd sg13cmos5l_decap_8
X_4946_ _4946_/Y _4946_/A _4946_/B _4965_/B vddd vssd sg13cmos5l_nor3_1
XFILLER_32_280 vddd vssd sg13cmos5l_decap_8
X_4877_ _4878_/C _4962_/A _7132_/Q vddd vssd sg13cmos5l_or2_1
X_6616_ _6616_/Y _6616_/A _6621_/S vddd vssd sg13cmos5l_nor2_1
X_3828_ _3828_/Y _3978_/A _6622_/B vddd vssd sg13cmos5l_nor2_1
XFILLER_14_1443 vddd vssd sg13cmos5l_decap_4
X_6547_ _6547_/Y hold744/X _6546_/B _6546_/Y vddd vssd sg13cmos5l_a21oi_1
X_3759_ _3759_/Y _7363_/Q sram_odata[7] _4292_/B vddd vssd sg13cmos5l_a21oi_1
XFILLER_27_2516 vddd vssd sg13cmos5l_decap_8
X_6478_ _6478_/X _6553_/A hold937/X _6479_/S vddd vssd sg13cmos5l_mux2_1
X_5429_ _5429_/Y _5429_/A _5429_/B _5429_/C vddd vssd sg13cmos5l_nor3_1
XFILLER_0_836 vddd vssd sg13cmos5l_decap_8
XFILLER_25_1572 vddd vssd sg13cmos5l_decap_8
Xclkbuf_leaf_40_SCK_regs clkload9/A clkbuf_3_0_0_SCK_regs/X vddd vssd sg13cmos5l_buf_8
XFILLER_5_1611 vddd vssd sg13cmos5l_decap_8
XFILLER_5_1655 vddd vssd sg13cmos5l_decap_8
XFILLER_21_1447 vddd vssd sg13cmos5l_decap_8
XFILLER_3_2080 vddd vssd sg13cmos5l_decap_8
XFILLER_5_1688 vddd vssd sg13cmos5l_decap_8
XFILLER_30_206 vddd vssd sg13cmos5l_decap_8
XFILLER_24_770 vddd vssd sg13cmos5l_decap_4
XFILLER_12_932 vddd vssd sg13cmos5l_decap_8
XFILLER_23_291 vddd vssd sg13cmos5l_decap_8
XFILLER_11_475 vddd vssd sg13cmos5l_decap_8
XFILLER_12_987 vddd vssd sg13cmos5l_decap_8
XFILLER_10_2531 vddd vssd sg13cmos5l_decap_8
XFILLER_32_1598 vddd vssd sg13cmos5l_decap_4
XFILLER_3_630 vddd vssd sg13cmos5l_decap_8
XFILLER_24_7 vddd vssd sg13cmos5l_decap_8
XFILLER_4_1110 vddd vssd sg13cmos5l_decap_8
XFILLER_0_21 vddd vssd sg13cmos5l_decap_8
XFILLER_4_1187 vddd vssd sg13cmos5l_decap_8
XFILLER_0_98 vddd vssd sg13cmos5l_decap_8
X_4800_ _4800_/Y _4800_/A _7099_/Q vddd vssd sg13cmos5l_nand2_1
XFILLER_15_770 vddd vssd sg13cmos5l_decap_8
X_5780_ _5780_/Y _5637_/A _5799_/C _7211_/Q vddd vssd sg13cmos5l_o21ai_1
X_4731_ _4733_/B _4464_/B _4740_/A vddd vssd sg13cmos5l_nand2b_1
XFILLER_9_63 vddd vssd sg13cmos5l_decap_8
X_4662_ _4663_/B _4740_/B _3604_/Y _4661_/Y vddd vssd sg13cmos5l_a21oi_1
X_3613_ _5963_/A _3613_/A vddd vssd sg13cmos5l_inv_1
X_6401_ _7148_/D hold846/X _6404_/B _6400_/Y vddd vssd sg13cmos5l_a21oi_1
X_4593_ _4593_/Y _4592_/B _3607_/Y _4592_/Y vddd vssd sg13cmos5l_a21oi_1
X_7381_ _7381_/Q _7398_/CLK _7381_/D _6894_/Y vddd vssd sg13cmos5l_dfrbpq_1
Xhold903 _7352_/D _4349_/Y vddd vssd sg13cmos5l_dlygate4sd3_1
Xhold925 _3611_/A _7112_/Q vddd vssd sg13cmos5l_dlygate4sd3_1
X_3544_ _3544_/Y _3544_/A vddd vssd sg13cmos5l_inv_1
Xhold914 _7290_/D _6650_/X vddd vssd sg13cmos5l_dlygate4sd3_1
X_6332_ _6332_/Y _6332_/A _6748_/B vddd vssd sg13cmos5l_nand2_1
Xhold936 hold936/X _4964_/A vddd vssd sg13cmos5l_dlygate4sd3_1
X_3475_ _3475_/Y _4650_/B vddd vssd sg13cmos5l_inv_1
X_6263_ _6263_/X _4020_/X _6262_/C _5008_/B vddd vssd sg13cmos5l_a21o_1
Xhold958 hold958/X _4930_/A vddd vssd sg13cmos5l_dlygate4sd3_1
Xhold969 _7304_/D _4950_/Y vddd vssd sg13cmos5l_dlygate4sd3_1
Xhold947 _6526_/A _7216_/Q vddd vssd sg13cmos5l_dlygate4sd3_1
Xoutbuffers\[64\] idac2_value[1] _7040_/Q vddd vssd sg13cmos5l_buf_16
X_5214_ _5222_/C _5214_/A _5214_/B vddd vssd sg13cmos5l_nor2_1
X_6194_ _6194_/Y _6194_/A _6194_/B _6194_/C vddd vssd sg13cmos5l_nand3_1
XFILLER_26_2560 vddd vssd sg13cmos5l_decap_8
XFILLER_9_1032 vddd vssd sg13cmos5l_decap_8
XFILLER_29_306 vddd vssd sg13cmos5l_decap_4
X_5145_ _5172_/B _7264_/Q _7265_/Q _5219_/B vddd vssd sg13cmos5l_nor3_1
XFILLER_2_2507 vddd vssd sg13cmos5l_decap_4
XFILLER_22_1734 vddd vssd sg13cmos5l_decap_8
X_5076_ _5076_/X _5076_/A _5255_/B vddd vssd sg13cmos5l_and2_1
XFILLER_2_2529 vddd vssd sg13cmos5l_decap_4
XFILLER_22_1778 vddd vssd sg13cmos5l_decap_8
X_4027_ _4027_/Y _3591_/Y _6540_/A _6533_/A vddd vssd sg13cmos5l_a21oi_1
XFILLER_0_1541 vddd vssd sg13cmos5l_decap_8
X_5978_ _5978_/X _6232_/A _5978_/B vddd vssd sg13cmos5l_and2_1
XFILLER_12_217 vddd vssd sg13cmos5l_decap_8
X_4929_ _4930_/B _4959_/A _4959_/B vddd vssd sg13cmos5l_and2_1
XFILLER_20_261 vddd vssd sg13cmos5l_decap_8
XFILLER_10_1148 vddd vssd sg13cmos5l_decap_8
XFILLER_0_622 vddd vssd sg13cmos5l_decap_8
XFILLER_27_1656 vddd vssd sg13cmos5l_decap_8
XFILLER_5_2120 vddd vssd sg13cmos5l_decap_8
XFILLER_21_1277 vddd vssd sg13cmos5l_decap_4
XFILLER_8_700 vddd vssd sg13cmos5l_decap_8
XFILLER_32_1373 vddd vssd sg13cmos5l_decap_8
XFILLER_12_1958 vddd vssd sg13cmos5l_decap_8
XFILLER_10_1660 vddd vssd sg13cmos5l_decap_8
XFILLER_6_1238 vddd vssd sg13cmos5l_decap_8
XFILLER_22_1008 vddd vssd sg13cmos5l_decap_8
X_6950_ _6950_/Y _6960_/A _6960_/B_N vddd vssd sg13cmos5l_nor2b_1
X_5901_ _5901_/Y _3546_/A _5908_/A _5900_/Y vddd vssd sg13cmos5l_o21ai_1
XFILLER_17_2504 vddd vssd sg13cmos5l_decap_8
X_6881_ _6881_/Y _6881_/A _6909_/B_N vddd vssd sg13cmos5l_nor2b_1
X_5832_ _5857_/C _7216_/Q _5841_/B vddd vssd sg13cmos5l_nand2_1
X_5763_ _5763_/Y _5732_/A _5761_/B _5761_/Y _5755_/Y _5764_/B vddd vssd sg13cmos5l_a221oi_1
Xoutbuffers\[8\] proj_ibias_ena[1] _7028_/Q vddd vssd sg13cmos5l_buf_16
X_4714_ _4714_/Y _6041_/A _4714_/B _4714_/C vddd vssd sg13cmos5l_nor3_1
X_5694_ _5694_/Y _5707_/C _5693_/Y _5701_/B vddd vssd sg13cmos5l_o21ai_1
XFILLER_15_2283 vddd vssd sg13cmos5l_decap_4
XFILLER_11_2114 vddd vssd sg13cmos5l_decap_4
X_4645_ _4648_/B _6104_/A1 _4636_/Y _4644_/Y vddd vssd sg13cmos5l_a21o_1
Xhold711 _5937_/A _3649_/Y vddd vssd sg13cmos5l_dlygate4sd3_1
X_4576_ _4576_/Y _4641_/A _4551_/Y _4552_/A vddd vssd sg13cmos5l_a21oi_1
X_7364_ _7364_/Q _7364_/CLK _7364_/D _6877_/Y vddd vssd sg13cmos5l_dfrbpq_1
Xhold700 hold700/X _6343_/Y vddd vssd sg13cmos5l_dlygate4sd3_1
X_3527_ _5266_/B _3527_/A vddd vssd sg13cmos5l_inv_1
Xhold755 hold755/X _6370_/Y vddd vssd sg13cmos5l_dlygate4sd3_1
X_6315_ _6320_/B _6315_/A _6315_/B _6759_/C vddd vssd sg13cmos5l_nor3_1
Xhold733 hold733/X _7094_/Q vddd vssd sg13cmos5l_dlygate4sd3_1
Xhold722 hold722/X _4276_/Y vddd vssd sg13cmos5l_dlygate4sd3_1
Xhold744 hold744/X _3592_/Y vddd vssd sg13cmos5l_dlygate4sd3_1
Xhold777 _6969_/D _5946_/Y vddd vssd sg13cmos5l_dlygate4sd3_1
Xhold788 hold788/X _4333_/Y vddd vssd sg13cmos5l_dlygate4sd3_1
Xhold766 _3598_/A _7099_/Q vddd vssd sg13cmos5l_dlygate4sd3_1
X_7295_ _7295_/Q _7295_/CLK _7295_/D _6828_/B_N vddd vssd sg13cmos5l_dfrbpq_1
X_6246_ _6246_/Y _5278_/B _6245_/Y _6241_/B vddd vssd sg13cmos5l_o21ai_1
X_3458_ _3458_/Y _5024_/A vddd vssd sg13cmos5l_inv_1
Xhold799 hold799/X _7124_/Q vddd vssd sg13cmos5l_dlygate4sd3_1
X_6177_ _6177_/Y _5241_/C _6176_/Y _5243_/A vddd vssd sg13cmos5l_a21oi_1
Xhold1400 _7162_/D _6426_/Y vddd vssd sg13cmos5l_dlygate4sd3_1
Xhold1411 _6389_/A0 _5304_/A vddd vssd sg13cmos5l_dlygate4sd3_1
X_5128_ _5129_/B _7271_/Q _7270_/Q _5210_/A vddd vssd sg13cmos5l_nor3_1
Xhold1433 hold1433/X _7235_/Q vddd vssd sg13cmos5l_dlygate4sd3_1
Xhold1422 _6368_/A _7133_/Q vddd vssd sg13cmos5l_dlygate4sd3_1
XFILLER_29_158 vddd vssd sg13cmos5l_decap_8
XFILLER_22_2298 vddd vssd sg13cmos5l_decap_8
Xhold1477 hold1477/X _7295_/Q vddd vssd sg13cmos5l_dlygate4sd3_1
Xhold1444 _4810_/A2 _4808_/Y vddd vssd sg13cmos5l_dlygate4sd3_1
Xhold1466 hold1466/X _7079_/Q vddd vssd sg13cmos5l_dlygate4sd3_1
Xhold1455 _4726_/A _7331_/Q vddd vssd sg13cmos5l_dlygate4sd3_1
Xhold1488 _3623_/A _7074_/Q vddd vssd sg13cmos5l_dlygate4sd3_1
Xhold1499 hold497/A _7002_/Q vddd vssd sg13cmos5l_dlygate4sd3_1
X_5059_ _5063_/B _6000_/B _6043_/B _5237_/B _5133_/B _5046_/Y vddd vssd sg13cmos5l_a221oi_1
XFILLER_0_2083 vddd vssd sg13cmos5l_decap_8
XFILLER_16_2036 vddd vssd sg13cmos5l_decap_8
XFILLER_16_2058 vddd vssd sg13cmos5l_decap_8
XFILLER_21_570 vddd vssd sg13cmos5l_decap_8
XFILLER_5_703 vddd vssd sg13cmos5l_decap_8
XFILLER_29_2408 vddd vssd sg13cmos5l_decap_8
XFILLER_4_224 vddd vssd sg13cmos5l_decap_8
XFILLER_4_235 vddd vssd sg13cmos5l_decap_8
XFILLER_20_84 vddd vssd sg13cmos5l_decap_8
XFILLER_23_2029 vddd vssd sg13cmos5l_decap_8
XFILLER_23_1317 vddd vssd sg13cmos5l_decap_8
XFILLER_0_485 vddd vssd sg13cmos5l_decap_8
XFILLER_7_1547 vddd vssd sg13cmos5l_decap_4
XFILLER_21_1030 vddd vssd sg13cmos5l_decap_8
XFILLER_21_1085 vddd vssd sg13cmos5l_decap_8
XFILLER_32_824 vddd vssd sg13cmos5l_decap_8
XFILLER_16_2581 vddd vssd sg13cmos5l_decap_8
XFILLER_8_552 vddd vssd sg13cmos5l_decap_4
XFILLER_8_541 vddd vssd sg13cmos5l_decap_4
XFILLER_12_2456 vddd vssd sg13cmos5l_decap_8
XFILLER_6_42 vddd vssd sg13cmos5l_decap_8
X_4430_ _4430_/Y _4460_/A _4430_/B vddd vssd sg13cmos5l_nand2b_1
XFILLER_12_1744 vddd vssd sg13cmos5l_decap_4
XANTENNA_2 _3728_/Y vddd vssd sg13cmos5l_antennanp
X_6100_ _6100_/Y _6144_/A _5169_/D _5170_/D vddd vssd sg13cmos5l_a21oi_1
X_4361_ _4361_/Y _4359_/Y _4360_/Y _4350_/Y vddd vssd sg13cmos5l_o21ai_1
X_4292_ _4293_/B _4308_/A _4292_/B vddd vssd sg13cmos5l_nor2_1
X_7080_ _7080_/Q _7255_/CLK _7080_/D fanout396/X vddd vssd sg13cmos5l_dfrbpq_1
XFILLER_23_2530 vddd vssd sg13cmos5l_decap_8
X_6031_ _6031_/Y _6138_/A _5074_/Y _5076_/X vddd vssd sg13cmos5l_a21oi_1
XFILLER_3_1901 vddd vssd sg13cmos5l_decap_4
XFILLER_13_0 vddd vssd sg13cmos5l_decap_8
XFILLER_23_1895 vddd vssd sg13cmos5l_decap_8
X_6933_ _6933_/Y _6959_/A _6958_/B_N vddd vssd sg13cmos5l_nor2b_1
Xoutbuffers\[27\] voltgen_sink1[0] _7061_/Q vddd vssd sg13cmos5l_buf_16
X_6864_ _6864_/Y _6961_/A _6961_/B_N vddd vssd sg13cmos5l_nor2b_1
X_5815_ _5817_/B _5899_/A _5815_/B _7214_/Q vddd vssd sg13cmos5l_nor3_1
X_6795_ _6795_/X _6795_/A vddd vssd sg13cmos5l_buf_1
XFILLER_30_2501 vddd vssd sg13cmos5l_decap_8
X_5746_ _5747_/B _5637_/A _5769_/C _7207_/Q vddd vssd sg13cmos5l_o21ai_1
X_5677_ _5677_/Y _7193_/Q _5682_/B _5677_/C vddd vssd sg13cmos5l_nand3_1
XFILLER_30_2578 vddd vssd sg13cmos5l_decap_8
X_4628_ _4628_/Y _4628_/A _4628_/B vddd vssd sg13cmos5l_nor2_1
Xhold530 _6799_/A _6976_/Q vddd vssd sg13cmos5l_dlygate4sd3_1
Xhold552 _4674_/A _7004_/Q vddd vssd sg13cmos5l_dlygate4sd3_1
X_4559_ _4560_/B _4559_/A _4559_/B vddd vssd sg13cmos5l_xor2_1
XFILLER_28_2441 vddd vssd sg13cmos5l_decap_8
Xhold563 _7000_/D _6792_/X vddd vssd sg13cmos5l_dlygate4sd3_1
Xhold541 _6983_/D _6798_/X vddd vssd sg13cmos5l_dlygate4sd3_1
X_7347_ _7347_/Q _7350_/CLK _7347_/D _6860_/Y vddd vssd sg13cmos5l_dfrbpq_1
XFILLER_11_1287 vddd vssd sg13cmos5l_decap_8
X_7278_ _7278_/Q _7278_/CLK _7278_/D fanout383/X vddd vssd sg13cmos5l_dfrbpq_1
Xhold574 _7228_/D _6550_/Y vddd vssd sg13cmos5l_dlygate4sd3_1
Xhold596 _7389_/D _3785_/Y vddd vssd sg13cmos5l_dlygate4sd3_1
Xhold585 _4083_/A _7385_/Q vddd vssd sg13cmos5l_dlygate4sd3_1
XFILLER_24_2338 vddd vssd sg13cmos5l_decap_8
X_6229_ _6229_/Y _6229_/A _6228_/Y vddd vssd sg13cmos5l_nor2b_1
XFILLER_8_2557 vddd vssd sg13cmos5l_decap_8
XFILLER_28_1795 vddd vssd sg13cmos5l_decap_8
XFILLER_8_1856 vddd vssd sg13cmos5l_decap_4
Xhold1230 _7063_/D _6729_/X vddd vssd sg13cmos5l_dlygate4sd3_1
Xhold1241 _6696_/A1 _3620_/Y vddd vssd sg13cmos5l_dlygate4sd3_1
Xhold1252 _7250_/D _6587_/X vddd vssd sg13cmos5l_dlygate4sd3_1
XFILLER_22_2084 vddd vssd sg13cmos5l_decap_4
Xhold1263 _7147_/D _6398_/Y vddd vssd sg13cmos5l_dlygate4sd3_1
Xhold1285 _6647_/A0 _7287_/Q vddd vssd sg13cmos5l_dlygate4sd3_1
Xhold1274 _7201_/D _6499_/X vddd vssd sg13cmos5l_dlygate4sd3_1
Xhold1296 _6613_/A0 _7266_/Q vddd vssd sg13cmos5l_dlygate4sd3_1
XFILLER_15_84 vddd vssd sg13cmos5l_decap_8
XFILLER_9_316 vddd vssd sg13cmos5l_decap_4
XFILLER_31_72 vddd vssd sg13cmos5l_decap_8
Xtiedowns\[63\] mask_rev_in[19] vddd vssd sg13cmos5l_antennanp
XFILLER_5_599 vddd vssd sg13cmos5l_decap_8
XFILLER_0_293 vddd vssd sg13cmos5l_decap_8
XFILLER_17_651 vddd vssd sg13cmos5l_decap_8
X_3930_ _3930_/Y _5711_/B _6489_/A _6480_/A vddd vssd sg13cmos5l_a21oi_1
XFILLER_32_621 vddd vssd sg13cmos5l_decap_8
Xoutbuffers\[117\] dbus_out[20] _5890_/Y vddd vssd sg13cmos5l_buf_16
XFILLER_17_695 vddd vssd sg13cmos5l_decap_8
XFILLER_31_142 vddd vssd sg13cmos5l_decap_8
X_3861_ _3861_/Y _5854_/B _6315_/B _3922_/A vddd vssd sg13cmos5l_nor3_1
XFILLER_32_698 vddd vssd sg13cmos5l_decap_8
X_5600_ _5600_/Y _5737_/A _5597_/Y _5599_/Y vddd vssd sg13cmos5l_a21oi_1
X_3792_ _6725_/A _3978_/A _6759_/B vddd vssd sg13cmos5l_nor2_1
X_6580_ _6580_/Y _6580_/A1 _6582_/S _6579_/Y vddd vssd sg13cmos5l_o21ai_1
X_5531_ _5535_/B _5543_/C _5536_/C vddd vssd sg13cmos5l_nor2_1
XFILLER_9_894 vddd vssd sg13cmos5l_decap_8
X_7201_ _7201_/Q _7218_/CLK _7201_/D _6822_/B_N vddd vssd sg13cmos5l_dfrbpq_1
X_5462_ _5486_/S _7164_/Q _7165_/Q _5483_/A vddd vssd sg13cmos5l_nor3_1
X_5393_ _5394_/C _5393_/A _5393_/B vddd vssd sg13cmos5l_nand2_1
X_4413_ _4413_/Y _4420_/A _4413_/B vddd vssd sg13cmos5l_nor2_1
XFILLER_12_1585 vddd vssd sg13cmos5l_decap_8
X_4344_ _4345_/B _4344_/A _4344_/B vddd vssd sg13cmos5l_nand2_1
X_7132_ _7132_/Q _7355_/CLK _7132_/D _6827_/B_N vddd vssd sg13cmos5l_dfrbpq_1
X_7063_ _7063_/Q _7069_/CLK _7063_/D fanout356/X vddd vssd sg13cmos5l_dfrbpq_1
Xfanout306 _5543_/A hold1338/X vddd vssd sg13cmos5l_buf_1
Xfanout328 _5632_/A1 _5679_/A vddd vssd sg13cmos5l_buf_1
Xfanout339 _6710_/A1 fanout340/X vddd vssd sg13cmos5l_buf_1
Xfanout317 _4814_/A1 _7079_/Q vddd vssd sg13cmos5l_buf_1
X_4275_ _4275_/X _4276_/A _4970_/A _4275_/S vddd vssd sg13cmos5l_mux2_1
X_6014_ _6014_/Y _6144_/A _6013_/A _5062_/C vddd vssd sg13cmos5l_a21oi_1
XFILLER_23_1681 vddd vssd sg13cmos5l_decap_8
XFILLER_3_1753 vddd vssd sg13cmos5l_decap_8
XFILLER_3_2487 vddd vssd sg13cmos5l_decap_8
XFILLER_19_2429 vddd vssd sg13cmos5l_decap_8
XFILLER_23_632 vddd vssd sg13cmos5l_decap_8
X_6916_ _6916_/Y _6919_/A _6919_/B_N vddd vssd sg13cmos5l_nor2b_1
X_6847_ _6847_/Y _6958_/A _6958_/B_N vddd vssd sg13cmos5l_nor2b_1
XFILLER_17_2131 vddd vssd sg13cmos5l_decap_8
X_6778_ _6778_/Y _6778_/A _6781_/S vddd vssd sg13cmos5l_nor2_1
XFILLER_17_1474 vddd vssd sg13cmos5l_decap_8
XFILLER_13_1316 vddd vssd sg13cmos5l_decap_8
X_5729_ _5729_/Y _5727_/X _5728_/X _5736_/C vddd vssd sg13cmos5l_a21oi_1
XFILLER_30_2375 vddd vssd sg13cmos5l_decap_8
XFILLER_24_1489 vddd vssd sg13cmos5l_decap_8
Xhold1060 _3612_/A _7113_/Q vddd vssd sg13cmos5l_dlygate4sd3_1
Xhold1093 _6581_/A0 _7246_/Q vddd vssd sg13cmos5l_dlygate4sd3_1
Xhold1082 _7241_/D _6573_/Y vddd vssd sg13cmos5l_dlygate4sd3_1
Xhold1071 _6574_/A0 _7242_/Q vddd vssd sg13cmos5l_dlygate4sd3_1
XFILLER_2_1274 vddd vssd sg13cmos5l_decap_8
XFILLER_2_1296 vddd vssd sg13cmos5l_decap_4
XFILLER_9_168 vddd vssd sg13cmos5l_decap_8
XFILLER_13_2595 vddd vssd sg13cmos5l_decap_8
XFILLER_5_352 vddd vssd sg13cmos5l_decap_8
XFILLER_6_886 vddd vssd sg13cmos5l_decap_8
XFILLER_29_2057 vddd vssd sg13cmos5l_decap_8
XFILLER_9_2129 vddd vssd sg13cmos5l_decap_8
X_4060_ _4060_/X _7046_/Q _4231_/C1 _3831_/X vddd vssd sg13cmos5l_a21o_1
XFILLER_20_2500 vddd vssd sg13cmos5l_decap_8
XFILLER_3_1016 vddd vssd sg13cmos5l_decap_8
XFILLER_20_2577 vddd vssd sg13cmos5l_decap_8
Xwire16 wire16/X wire16/A vddd vssd sg13cmos5l_buf_4
X_4962_ _4962_/Y _4962_/A _4965_/A vddd vssd sg13cmos5l_xnor2_1
X_6701_ _7044_/D _6701_/A1 _6707_/S _6701_/B1 vddd vssd sg13cmos5l_o21ai_1
X_4893_ _4894_/B _4828_/B _4892_/Y _5285_/D vddd vssd sg13cmos5l_o21ai_1
X_3913_ _3913_/Y _5887_/B _6533_/A _3912_/Y _3910_/Y _6525_/A vddd vssd sg13cmos5l_a221oi_1
X_6632_ _6632_/Y _6632_/A _6635_/S vddd vssd sg13cmos5l_nand2_1
XFILLER_18_2495 vddd vssd sg13cmos5l_decap_8
X_3844_ _3990_/B _3963_/A _4071_/C _6315_/A vddd vssd sg13cmos5l_a21oi_1
X_6563_ _6568_/S _6563_/A _6699_/B vddd vssd sg13cmos5l_nand2_1
X_3775_ _3775_/X mask_rev_in[6] _4250_/A vddd vssd sg13cmos5l_and2_1
XFILLER_9_680 vddd vssd sg13cmos5l_decap_4
Xoutbuffers\[94\] io_out[9] _6211_/Y vddd vssd sg13cmos5l_buf_16
X_5514_ _5514_/Y _5632_/A1 _5511_/Y _5512_/Y _5510_/Y _5513_/X vddd vssd sg13cmos5l_a221oi_1
X_6494_ _6494_/X _6553_/A _6494_/A1 _6495_/S vddd vssd sg13cmos5l_mux2_1
X_5445_ _5449_/B _5457_/C _5450_/C vddd vssd sg13cmos5l_nor2_1
X_5376_ _5376_/Y _5368_/A _5374_/A _5374_/X _5428_/A _5375_/Y vddd vssd sg13cmos5l_a221oi_1
X_7115_ _7115_/Q _7125_/CLK _7115_/D fanout400/X vddd vssd sg13cmos5l_dfrbpq_1
Xfanout103 _6773_/A _3728_/Y vddd vssd sg13cmos5l_buf_1
XFILLER_25_2466 vddd vssd sg13cmos5l_decap_8
X_4327_ _4327_/Y _4327_/A _4344_/B vddd vssd sg13cmos5l_nand2_1
Xfanout125 _6615_/C _6759_/C vddd vssd sg13cmos5l_buf_1
Xfanout147 _5247_/B _5278_/A vddd vssd sg13cmos5l_buf_1
X_7046_ _7046_/Q _7279_/CLK _7046_/D fanout387/X vddd vssd sg13cmos5l_dfrbpq_1
Xfanout169 _3678_/S hold1227/A vddd vssd sg13cmos5l_buf_1
X_4258_ _4258_/Y _4258_/A _4258_/B _4258_/C vddd vssd sg13cmos5l_nand3_1
XFILLER_5_1826 vddd vssd sg13cmos5l_decap_4
Xfanout158 _4628_/A _4789_/A vddd vssd sg13cmos5l_buf_1
XFILLER_21_1607 vddd vssd sg13cmos5l_decap_8
X_4189_ _4189_/Y _7244_/Q _6576_/A _6569_/A vddd vssd sg13cmos5l_o21ai_1
XFILLER_19_2226 vddd vssd sg13cmos5l_decap_8
XFILLER_15_429 vddd vssd sg13cmos5l_decap_8
XFILLER_32_2426 vddd vssd sg13cmos5l_decap_8
XFILLER_11_646 vddd vssd sg13cmos5l_decap_8
XFILLER_10_167 vddd vssd sg13cmos5l_decap_8
XFILLER_13_1124 vddd vssd sg13cmos5l_decap_8
XFILLER_13_1157 vddd vssd sg13cmos5l_decap_8
XFILLER_12_63 vddd vssd sg13cmos5l_decap_8
XFILLER_3_889 vddd vssd sg13cmos5l_decap_8
Xtiedowns\[26\] dbus_in_left[6] vddd vssd sg13cmos5l_antennanp
XFILLER_18_1013 vddd vssd sg13cmos5l_decap_8
X_3560_ _5408_/B _3560_/A vddd vssd sg13cmos5l_inv_1
XFILLER_11_1809 vddd vssd sg13cmos5l_decap_8
X_5230_ _5245_/A _6194_/B _5230_/B vddd vssd sg13cmos5l_nand2_1
X_3491_ _4358_/A _4398_/A vddd vssd sg13cmos5l_inv_1
XFILLER_9_1203 vddd vssd sg13cmos5l_decap_8
X_5161_ _5170_/C _6000_/B _6130_/C vddd vssd sg13cmos5l_and2_1
XFILLER_25_1028 vddd vssd sg13cmos5l_decap_4
X_5092_ _5272_/B _7264_/Q _7265_/Q vddd vssd sg13cmos5l_nand2b_1
X_4112_ _4112_/Y _3791_/A _6144_/A _6556_/A vddd vssd sg13cmos5l_a21oi_1
X_4043_ _4043_/Y _3569_/Y _6450_/A _6443_/A vddd vssd sg13cmos5l_a21oi_1
XFILLER_4_2582 vddd vssd sg13cmos5l_decap_8
X_5994_ _5994_/X _5994_/A0 _3689_/B _5994_/S vddd vssd sg13cmos5l_mux2_1
XFILLER_0_1723 vddd vssd sg13cmos5l_decap_8
X_4945_ _4965_/B _4945_/A _4945_/B vddd vssd sg13cmos5l_nand2_1
X_4876_ _4878_/B _4959_/A _7133_/Q vddd vssd sg13cmos5l_or2_1
X_6615_ _6621_/S _6615_/A _6615_/B _6615_/C vddd vssd sg13cmos5l_nor3_1
X_3827_ _6622_/B _3929_/A _3869_/D vddd vssd sg13cmos5l_or2_1
XFILLER_14_2156 vddd vssd sg13cmos5l_decap_8
X_3758_ wire15/A mask_rev_in[31] _4079_/B _3757_/Y vddd vssd sg13cmos5l_o21ai_1
X_6546_ _6546_/Y _6546_/A _6546_/B vddd vssd sg13cmos5l_nor2_1
XFILLER_4_609 vddd vssd sg13cmos5l_decap_8
X_6477_ _7189_/D _6520_/A _6477_/A1 _6479_/S vddd vssd sg13cmos5l_mux2_1
X_3689_ _3728_/B _3689_/A _3689_/B vddd vssd sg13cmos5l_nor2_1
X_5428_ _5429_/C _5428_/A _5428_/B _5428_/C vddd vssd sg13cmos5l_nor3_1
X_5359_ _5359_/Y _3546_/Y _3557_/Y _5357_/Y _5363_/B vddd vssd sg13cmos5l_a22oi_1
XFILLER_25_2252 vddd vssd sg13cmos5l_decap_8
XFILLER_5_2335 vddd vssd sg13cmos5l_decap_8
XFILLER_9_2493 vddd vssd sg13cmos5l_decap_8
X_7029_ _7029_/Q _7233_/CLK _7029_/D fanout375/X vddd vssd sg13cmos5l_dfrbpq_1
XFILLER_21_2138 vddd vssd sg13cmos5l_decap_8
XFILLER_5_2379 vddd vssd sg13cmos5l_decap_8
XFILLER_28_521 vddd vssd sg13cmos5l_decap_8
XFILLER_19_2034 vddd vssd sg13cmos5l_decap_8
XFILLER_15_237 vddd vssd sg13cmos5l_decap_8
XFILLER_19_2078 vddd vssd sg13cmos5l_decap_4
XFILLER_11_421 vddd vssd sg13cmos5l_decap_8
XFILLER_12_966 vddd vssd sg13cmos5l_decap_8
XFILLER_32_1544 vddd vssd sg13cmos5l_decap_8
XFILLER_23_84 vddd vssd sg13cmos5l_decap_8
XFILLER_10_2510 vddd vssd sg13cmos5l_decap_8
XFILLER_32_1577 vddd vssd sg13cmos5l_decap_8
XFILLER_10_2587 vddd vssd sg13cmos5l_decap_8
XFILLER_6_1409 vddd vssd sg13cmos5l_decap_8
XFILLER_26_1359 vddd vssd sg13cmos5l_decap_8
XFILLER_19_510 vddd vssd sg13cmos5l_decap_8
XFILLER_17_7 vddd vssd sg13cmos5l_decap_8
XFILLER_4_1166 vddd vssd sg13cmos5l_decap_8
XFILLER_21_1993 vddd vssd sg13cmos5l_decap_8
XFILLER_0_77 vddd vssd sg13cmos5l_decap_8
XFILLER_19_2590 vddd vssd sg13cmos5l_decap_8
X_4730_ _4730_/Y _4814_/A1 _3601_/Y _4773_/B1 _4729_/Y vddd vssd sg13cmos5l_a22oi_1
XFILLER_9_42 vddd vssd sg13cmos5l_decap_8
XFILLER_15_2465 vddd vssd sg13cmos5l_decap_8
XFILLER_15_1742 vddd vssd sg13cmos5l_decap_8
X_4661_ _4661_/Y _4661_/A _4740_/B vddd vssd sg13cmos5l_nor2_1
X_3612_ _4477_/B _3612_/A vddd vssd sg13cmos5l_inv_1
X_7380_ _7380_/Q _7398_/CLK _7380_/D _6893_/Y vddd vssd sg13cmos5l_dfrbpq_1
X_6400_ _6400_/Y _6400_/A _6404_/B vddd vssd sg13cmos5l_nor2_1
X_4592_ _4592_/Y _4592_/A _4592_/B vddd vssd sg13cmos5l_nor2_1
X_6331_ _6331_/Y _6331_/A1 _6330_/B _6330_/Y vddd vssd sg13cmos5l_o21ai_1
Xhold904 _3577_/A _7194_/Q vddd vssd sg13cmos5l_dlygate4sd3_1
XFILLER_11_1628 vddd vssd sg13cmos5l_decap_8
Xhold937 hold937/X _7190_/Q vddd vssd sg13cmos5l_dlygate4sd3_1
Xhold926 hold926/X _3611_/Y vddd vssd sg13cmos5l_dlygate4sd3_1
X_3543_ _5639_/A _5533_/A vddd vssd sg13cmos5l_inv_1
Xhold915 _3602_/A _7103_/Q vddd vssd sg13cmos5l_dlygate4sd3_1
X_3474_ _3474_/Y _4627_/A vddd vssd sg13cmos5l_inv_1
X_6262_ _6262_/Y _6262_/A _6262_/B _6262_/C vddd vssd sg13cmos5l_nor3_1
Xhold948 hold948/X _6526_/Y vddd vssd sg13cmos5l_dlygate4sd3_1
Xhold959 _3489_/A _7350_/Q vddd vssd sg13cmos5l_dlygate4sd3_1
X_6193_ _6193_/Y _5247_/C _6191_/Y _6192_/Y vddd vssd sg13cmos5l_o21ai_1
X_5213_ _5222_/B _5213_/A _5213_/B vddd vssd sg13cmos5l_nor2_1
XFILLER_9_1011 vddd vssd sg13cmos5l_decap_8
X_5144_ _5219_/B _7267_/Q _7266_/Q vddd vssd sg13cmos5l_nand2b_1
Xoutbuffers\[57\] voltgen_value[1] _7049_/Q vddd vssd sg13cmos5l_buf_16
XFILLER_9_1088 vddd vssd sg13cmos5l_decap_8
XFILLER_26_1882 vddd vssd sg13cmos5l_decap_4
XFILLER_22_2469 vddd vssd sg13cmos5l_decap_8
XFILLER_22_1713 vddd vssd sg13cmos5l_decap_8
X_5075_ _5255_/B _5240_/B _5240_/A vddd vssd sg13cmos5l_nor2b_1
X_4026_ _4026_/Y _3622_/Y _6548_/A _4025_/Y vddd vssd sg13cmos5l_a21oi_1
XFILLER_0_2232 vddd vssd sg13cmos5l_decap_8
XFILLER_4_2390 vddd vssd sg13cmos5l_decap_4
XFILLER_25_513 vddd vssd sg13cmos5l_decap_4
XFILLER_25_535 vddd vssd sg13cmos5l_decap_4
XFILLER_25_579 vddd vssd sg13cmos5l_decap_8
X_5977_ _5977_/Y _6231_/A1 _5975_/B _5975_/Y _5969_/Y _5978_/B vddd vssd sg13cmos5l_a221oi_1
X_4928_ _4959_/B _4962_/A _4965_/A vddd vssd sg13cmos5l_and2_1
XFILLER_21_763 vddd vssd sg13cmos5l_decap_4
XFILLER_16_1539 vddd vssd sg13cmos5l_decap_8
X_4859_ _4859_/Y hold802/X _4859_/A2 _4858_/Y vddd vssd sg13cmos5l_a21oi_1
X_6529_ _7217_/D _6529_/A1 _6532_/S _6528_/Y vddd vssd sg13cmos5l_a21oi_1
XFILLER_0_601 vddd vssd sg13cmos5l_decap_8
XFILLER_27_2369 vddd vssd sg13cmos5l_decap_8
XFILLER_27_1624 vddd vssd sg13cmos5l_decap_8
XFILLER_0_645 vddd vssd sg13cmos5l_decap_8
XFILLER_25_1370 vddd vssd sg13cmos5l_decap_8
XFILLER_5_1420 vddd vssd sg13cmos5l_decap_8
XFILLER_5_2187 vddd vssd sg13cmos5l_decap_8
XFILLER_32_2064 vddd vssd sg13cmos5l_decap_8
XFILLER_8_756 vddd vssd sg13cmos5l_decap_8
XFILLER_12_785 vddd vssd sg13cmos5l_decap_8
XFILLER_32_1352 vddd vssd sg13cmos5l_decap_8
XFILLER_12_1937 vddd vssd sg13cmos5l_decap_8
XFILLER_4_951 vddd vssd sg13cmos5l_decap_4
XFILLER_21_2491 vddd vssd sg13cmos5l_decap_8
X_5900_ _5900_/Y _3512_/Y _5908_/A _5899_/B vddd vssd sg13cmos5l_a21oi_1
X_6880_ _6880_/Y _6885_/A _6885_/B_N vddd vssd sg13cmos5l_nor2b_1
X_5831_ _5831_/Y _7216_/Q _7217_/Q _5854_/A _5854_/B vddd vssd sg13cmos5l_nor4_1
X_5762_ _5764_/B _7204_/Q _7205_/Q _5762_/C vddd vssd sg13cmos5l_nor3_1
X_4713_ _4716_/B _4713_/A _4713_/B vddd vssd sg13cmos5l_nand2_1
X_5693_ _5693_/Y _7340_/Q _5708_/B vddd vssd sg13cmos5l_nor2b_1
X_4644_ _4644_/Y _6104_/A1 _4636_/Y _4713_/A vddd vssd sg13cmos5l_o21ai_1
Xhold712 _6966_/D _5937_/Y vddd vssd sg13cmos5l_dlygate4sd3_1
X_7363_ _7363_/Q _7372_/CLK _7363_/D _6876_/Y vddd vssd sg13cmos5l_dfrbpq_1
Xhold701 _6364_/A _7131_/Q vddd vssd sg13cmos5l_dlygate4sd3_1
XFILLER_11_1436 vddd vssd sg13cmos5l_decap_8
X_4575_ _4575_/Y _4599_/A _4599_/B vddd vssd sg13cmos5l_xnor2_1
X_3526_ _5202_/B _5228_/A vddd vssd sg13cmos5l_inv_1
X_7294_ _7294_/Q _7294_/CLK _7294_/D fanout384/X vddd vssd sg13cmos5l_dfrbpq_1
Xhold734 _7094_/D _6781_/X vddd vssd sg13cmos5l_dlygate4sd3_1
Xhold723 _7372_/D _4277_/Y vddd vssd sg13cmos5l_dlygate4sd3_1
Xhold745 _7227_/D _6547_/Y vddd vssd sg13cmos5l_dlygate4sd3_1
X_6314_ _6314_/Y hold985/X _6790_/B _6313_/Y vddd vssd sg13cmos5l_o21ai_1
X_6245_ _6245_/Y _6194_/A _5270_/Y _6244_/Y vddd vssd sg13cmos5l_o21ai_1
Xhold778 _4327_/A _7359_/Q vddd vssd sg13cmos5l_dlygate4sd3_1
Xhold756 _3513_/A _7313_/Q vddd vssd sg13cmos5l_dlygate4sd3_1
Xhold767 hold767/X _3598_/Y vddd vssd sg13cmos5l_dlygate4sd3_1
Xhold789 _7357_/D _4335_/Y vddd vssd sg13cmos5l_dlygate4sd3_1
Xclkbuf_leaf_19_SCK_regs _7279_/CLK clkload7/A vddd vssd sg13cmos5l_buf_8
Xhold1401 _4506_/A1 _7341_/Q vddd vssd sg13cmos5l_dlygate4sd3_1
X_6176_ _6176_/Y _6241_/A _5241_/B _6175_/Y vddd vssd sg13cmos5l_o21ai_1
Xhold1412 _7143_/D _6389_/X vddd vssd sg13cmos5l_dlygate4sd3_1
X_5127_ _5129_/A _5127_/A _5099_/A vddd vssd sg13cmos5l_nor2b_1
Xhold1434 _6562_/A1 _5972_/B vddd vssd sg13cmos5l_dlygate4sd3_1
Xhold1423 _6369_/B1 _6368_/Y vddd vssd sg13cmos5l_dlygate4sd3_1
XFILLER_29_137 vddd vssd sg13cmos5l_decap_8
X_5058_ _5061_/A _5058_/A _5058_/B _5058_/C _5058_/D vddd vssd sg13cmos5l_nor4_1
Xhold1445 hold1445/X _7340_/Q vddd vssd sg13cmos5l_dlygate4sd3_1
XFILLER_22_1532 vddd vssd sg13cmos5l_decap_8
Xhold1456 _7331_/D _4727_/Y vddd vssd sg13cmos5l_dlygate4sd3_1
Xhold1467 _6753_/A _4430_/B vddd vssd sg13cmos5l_dlygate4sd3_1
Xhold1489 _6744_/A1 _3623_/Y vddd vssd sg13cmos5l_dlygate4sd3_1
X_4009_ _4011_/B _7270_/Q _3862_/Y _3868_/Y _7274_/Q vddd vssd sg13cmos5l_a22oi_1
XFILLER_26_811 vddd vssd sg13cmos5l_decap_8
Xhold1478 _6658_/A0 _4979_/A vddd vssd sg13cmos5l_dlygate4sd3_1
XFILLER_2_1626 vddd vssd sg13cmos5l_decap_8
XFILLER_26_866 vddd vssd sg13cmos5l_decap_8
XFILLER_22_1598 vddd vssd sg13cmos5l_decap_8
XFILLER_0_2062 vddd vssd sg13cmos5l_decap_8
XFILLER_16_2015 vddd vssd sg13cmos5l_decap_8
XFILLER_16_1358 vddd vssd sg13cmos5l_decap_8
XFILLER_20_63 vddd vssd sg13cmos5l_decap_8
XFILLER_4_269 vddd vssd sg13cmos5l_decap_8
XFILLER_0_464 vddd vssd sg13cmos5l_decap_8
XFILLER_29_72 vddd vssd sg13cmos5l_decap_8
XFILLER_29_682 vddd vssd sg13cmos5l_decap_8
XFILLER_32_803 vddd vssd sg13cmos5l_decap_8
XFILLER_31_302 vddd vssd sg13cmos5l_decap_8
XFILLER_16_398 vddd vssd sg13cmos5l_decap_4
XFILLER_16_2560 vddd vssd sg13cmos5l_decap_8
XFILLER_12_560 vddd vssd sg13cmos5l_decap_8
XFILLER_16_1881 vddd vssd sg13cmos5l_decap_8
XFILLER_12_1723 vddd vssd sg13cmos5l_decap_8
XFILLER_12_2435 vddd vssd sg13cmos5l_decap_8
XFILLER_32_1171 vddd vssd sg13cmos5l_decap_8
XFILLER_6_21 vddd vssd sg13cmos5l_decap_8
XANTENNA_3 _3728_/Y vddd vssd sg13cmos5l_antennanp
XFILLER_32_1193 vddd vssd sg13cmos5l_decap_8
X_4360_ _4360_/Y _4409_/A _4360_/B vddd vssd sg13cmos5l_nor2_1
XFILLER_28_1207 vddd vssd sg13cmos5l_decap_8
XFILLER_10_1480 vddd vssd sg13cmos5l_decap_4
X_4291_ _4291_/Y _6693_/A1 _4286_/B _4286_/Y _4976_/B vddd vssd sg13cmos5l_a22oi_1
X_6030_ _6030_/Y _5088_/C _6028_/Y _6029_/Y vddd vssd sg13cmos5l_o21ai_1
XFILLER_6_1025 vddd vssd sg13cmos5l_decap_8
XFILLER_23_2586 vddd vssd sg13cmos5l_decap_8
XFILLER_3_1946 vddd vssd sg13cmos5l_decap_8
X_6932_ _6932_/Y _6952_/A _6949_/B_N vddd vssd sg13cmos5l_nor2b_1
X_6863_ _6863_/Y _6863_/A _6863_/B_N vddd vssd sg13cmos5l_nor2b_1
X_5814_ _5817_/A _5812_/Y _5813_/Y _3586_/Y vddd vssd sg13cmos5l_a21oi_1
X_6794_ _6794_/X _6794_/A vddd vssd sg13cmos5l_buf_1
XFILLER_23_869 vddd vssd sg13cmos5l_decap_8
XFILLER_17_2357 vddd vssd sg13cmos5l_decap_8
XFILLER_22_379 vddd vssd sg13cmos5l_decap_8
X_5745_ _5747_/A _5897_/A _7204_/Q _7205_/Q vddd vssd sg13cmos5l_nor3_1
XFILLER_30_2557 vddd vssd sg13cmos5l_decap_8
X_5676_ _5677_/C _5676_/A _5683_/B vddd vssd sg13cmos5l_nand2_1
X_4627_ _4628_/B _4627_/A _7007_/D vddd vssd sg13cmos5l_xor2_1
Xhold520 _4533_/A _7010_/Q vddd vssd sg13cmos5l_dlygate4sd3_1
Xhold531 _6977_/D _6799_/X vddd vssd sg13cmos5l_dlygate4sd3_1
Xhold553 _7005_/D _3465_/Y vddd vssd sg13cmos5l_dlygate4sd3_1
XFILLER_28_2420 vddd vssd sg13cmos5l_decap_8
Xhold542 _6793_/A _6998_/Q vddd vssd sg13cmos5l_dlygate4sd3_1
X_4558_ _4558_/Y _4594_/A1 _4546_/Y _4557_/Y vddd vssd sg13cmos5l_o21ai_1
X_7346_ _7346_/Q _7348_/CLK _7346_/D _6859_/Y vddd vssd sg13cmos5l_dfrbpq_1
Xhold564 _6794_/A _6997_/Q vddd vssd sg13cmos5l_dlygate4sd3_1
XFILLER_28_1730 vddd vssd sg13cmos5l_decap_4
X_7277_ _7277_/Q _7279_/CLK _7277_/D fanout385/X vddd vssd sg13cmos5l_dfrbpq_1
Xhold575 _5956_/B _6974_/Q vddd vssd sg13cmos5l_dlygate4sd3_1
X_4489_ _4489_/X _4489_/A _4771_/B vddd vssd sg13cmos5l_or2_1
X_3509_ _3509_/Y _4855_/B vddd vssd sg13cmos5l_inv_1
Xhold586 hold586/X _4083_/Y vddd vssd sg13cmos5l_dlygate4sd3_1
Xhold597 _4000_/A _7386_/Q vddd vssd sg13cmos5l_dlygate4sd3_1
XFILLER_8_2536 vddd vssd sg13cmos5l_decap_8
XFILLER_28_2497 vddd vssd sg13cmos5l_decap_8
X_6228_ _6228_/Y _6234_/B _6227_/Y _6225_/Y vddd vssd sg13cmos5l_a21oi_1
XFILLER_28_1774 vddd vssd sg13cmos5l_decap_8
XFILLER_24_1616 vddd vssd sg13cmos5l_decap_8
X_6159_ _6159_/Y _3791_/B _5223_/B _6157_/X _6158_/Y _5225_/C vddd vssd sg13cmos5l_a221oi_1
Xhold1242 _7041_/D _6696_/Y vddd vssd sg13cmos5l_dlygate4sd3_1
Xhold1220 _3590_/A _7221_/Q vddd vssd sg13cmos5l_dlygate4sd3_1
XFILLER_6_2282 vddd vssd sg13cmos5l_decap_8
Xhold1231 _3557_/A _7151_/Q vddd vssd sg13cmos5l_dlygate4sd3_1
Xhold1264 _6737_/A0 _7069_/Q vddd vssd sg13cmos5l_dlygate4sd3_1
Xhold1253 _3575_/A _7188_/Q vddd vssd sg13cmos5l_dlygate4sd3_1
Xhold1275 _3573_/A _7183_/Q vddd vssd sg13cmos5l_dlygate4sd3_1
XFILLER_6_1570 vddd vssd sg13cmos5l_decap_8
Xhold1297 _7266_/D _6613_/X vddd vssd sg13cmos5l_dlygate4sd3_1
Xhold1286 _7287_/D _6647_/X vddd vssd sg13cmos5l_dlygate4sd3_1
XFILLER_2_1478 vddd vssd sg13cmos5l_decap_4
XFILLER_26_685 vddd vssd sg13cmos5l_decap_8
XFILLER_25_184 vddd vssd sg13cmos5l_decap_8
XFILLER_15_63 vddd vssd sg13cmos5l_decap_8
XFILLER_31_51 vddd vssd sg13cmos5l_decap_8
XFILLER_5_589 vddd vssd sg13cmos5l_decap_8
Xtiedowns\[56\] mask_rev_in[12] vddd vssd sg13cmos5l_antennanp
XFILLER_27_1273 vddd vssd sg13cmos5l_decap_8
XFILLER_0_283 vddd vssd sg13cmos5l_decap_4
XFILLER_7_1367 vddd vssd sg13cmos5l_decap_8
XFILLER_17_630 vddd vssd sg13cmos5l_decap_8
XFILLER_32_600 vddd vssd sg13cmos5l_decap_8
XFILLER_18_2600 vddd vssd sg13cmos5l_decap_8
XFILLER_31_121 vddd vssd sg13cmos5l_decap_8
X_3860_ _6525_/A _6315_/B _3922_/A vddd vssd sg13cmos5l_nor2_1
XFILLER_32_677 vddd vssd sg13cmos5l_decap_8
X_3791_ _3796_/A _3791_/A _3791_/B vddd vssd sg13cmos5l_nand2_1
XFILLER_20_839 vddd vssd sg13cmos5l_decap_8
XFILLER_31_198 vddd vssd sg13cmos5l_decap_8
X_5530_ _5536_/C _5540_/B _5540_/A vddd vssd sg13cmos5l_nand2b_1
XFILLER_8_361 vddd vssd sg13cmos5l_decap_8
X_5461_ _5483_/A _7166_/Q _7167_/Q vddd vssd sg13cmos5l_or2_1
X_4412_ _4412_/Y _4412_/A _4412_/B vddd vssd sg13cmos5l_nand2_1
X_7200_ _7200_/Q _7218_/CLK _7200_/D _6822_/B_N vddd vssd sg13cmos5l_dfrbpq_1
XFILLER_12_1564 vddd vssd sg13cmos5l_decap_8
X_5392_ _5392_/Y _5903_/A _7152_/Q _5391_/Y vddd vssd sg13cmos5l_a21oi_1
X_7131_ _7131_/Q _7355_/CLK _7131_/D _6907_/B_N vddd vssd sg13cmos5l_dfrbpq_1
X_4343_ _4343_/Y _4343_/A _4343_/B vddd vssd sg13cmos5l_nand2_1
X_7062_ _7062_/Q _7069_/CLK _7062_/D fanout357/X vddd vssd sg13cmos5l_dfrbpq_1
Xfanout329 _5679_/A _3551_/Y vddd vssd sg13cmos5l_buf_1
Xfanout318 _4641_/A hold1485/X vddd vssd sg13cmos5l_buf_1
Xfanout307 _5511_/A hold1428/X vddd vssd sg13cmos5l_buf_1
X_4274_ _4274_/X _4970_/A _4287_/A _4276_/B vddd vssd sg13cmos5l_mux2_1
X_6013_ _6013_/X _6013_/A _6013_/B vddd vssd sg13cmos5l_or2_1
XFILLER_3_2433 vddd vssd sg13cmos5l_decap_8
XFILLER_3_1732 vddd vssd sg13cmos5l_decap_8
X_6915_ _6915_/Y _6919_/A _6919_/B_N vddd vssd sg13cmos5l_nor2b_1
XFILLER_17_2110 vddd vssd sg13cmos5l_decap_8
X_6846_ _6846_/Y _6857_/A _6846_/B_N vddd vssd sg13cmos5l_nor2b_1
XFILLER_23_677 vddd vssd sg13cmos5l_decap_8
XFILLER_17_2187 vddd vssd sg13cmos5l_decap_8
XFILLER_17_1431 vddd vssd sg13cmos5l_decap_8
XFILLER_13_2018 vddd vssd sg13cmos5l_decap_4
X_6777_ _6777_/Y _6777_/A1 _6781_/S hold719/X vddd vssd sg13cmos5l_a21oi_1
XFILLER_32_1929 vddd vssd sg13cmos5l_decap_8
X_3989_ _3990_/D _7101_/Q _6304_/A vddd vssd sg13cmos5l_nor2_1
X_5728_ _5728_/X _5728_/A _5736_/A vddd vssd sg13cmos5l_or2_1
XFILLER_30_2354 vddd vssd sg13cmos5l_decap_8
X_5659_ _5659_/Y _7192_/Q _7193_/Q vddd vssd sg13cmos5l_nand2_1
Xclkbuf_leaf_34_SCK_regs _7295_/CLK clkload5/A vddd vssd sg13cmos5l_buf_8
X_7329_ _7329_/Q _7350_/CLK _7329_/D _6842_/Y vddd vssd sg13cmos5l_dfrbpq_1
XFILLER_11_1085 vddd vssd sg13cmos5l_decap_8
XFILLER_28_1571 vddd vssd sg13cmos5l_decap_8
XFILLER_19_906 vddd vssd sg13cmos5l_decap_8
Xhold1050 _7166_/D _6433_/X vddd vssd sg13cmos5l_dlygate4sd3_1
Xhold1061 _6331_/A1 _4477_/B vddd vssd sg13cmos5l_dlygate4sd3_1
Xhold1083 _3523_/A _7261_/Q vddd vssd sg13cmos5l_dlygate4sd3_1
XFILLER_18_449 vddd vssd sg13cmos5l_decap_4
XFILLER_18_427 vddd vssd sg13cmos5l_decap_4
Xhold1072 _7242_/D _6574_/X vddd vssd sg13cmos5l_dlygate4sd3_1
Xhold1094 _7246_/D _6581_/X vddd vssd sg13cmos5l_dlygate4sd3_1
XFILLER_26_84 vddd vssd sg13cmos5l_decap_8
XFILLER_14_688 vddd vssd sg13cmos5l_decap_8
XFILLER_13_2574 vddd vssd sg13cmos5l_decap_8
XFILLER_10_883 vddd vssd sg13cmos5l_decap_8
XFILLER_7_1120 vddd vssd sg13cmos5l_decap_8
XFILLER_3_66 vddd vssd sg13cmos5l_decap_8
XFILLER_20_2556 vddd vssd sg13cmos5l_decap_8
Xwire17 wire17/X wire18/X vddd vssd sg13cmos5l_buf_4
XFILLER_3_1039 vddd vssd sg13cmos5l_decap_8
XFILLER_0_1905 vddd vssd sg13cmos5l_decap_8
X_4961_ _4961_/Y _4962_/A _4967_/B vddd vssd sg13cmos5l_nand2_1
XFILLER_32_441 vddd vssd sg13cmos5l_decap_8
X_6700_ _6700_/Y _6700_/A _6707_/S vddd vssd sg13cmos5l_nand2_1
X_4892_ _4892_/Y _4829_/A _4892_/B vddd vssd sg13cmos5l_nand2b_1
X_3912_ _3912_/Y _3592_/Y _6540_/A _6533_/A vddd vssd sg13cmos5l_a21oi_1
X_6631_ _7276_/D _6675_/A1 _6635_/S _6630_/Y vddd vssd sg13cmos5l_a21oi_1
XFILLER_18_2474 vddd vssd sg13cmos5l_decap_8
X_3843_ _6748_/A _6315_/A _4071_/C vddd vssd sg13cmos5l_nor2_1
X_6562_ _7235_/D _6546_/A _6562_/A1 _6562_/S vddd vssd sg13cmos5l_mux2_1
X_3774_ _3777_/B _7096_/Q _3990_/A _4252_/A vddd vssd sg13cmos5l_a21oi_1
X_5513_ _5513_/X _5513_/A _5513_/B vddd vssd sg13cmos5l_and2_1
X_6493_ _7197_/D _6493_/A1 _6495_/S _6492_/Y vddd vssd sg13cmos5l_a21oi_1
Xoutbuffers\[87\] io_out[2] _6062_/Y vddd vssd sg13cmos5l_buf_16
X_5444_ _5450_/C _5454_/A _5444_/B vddd vssd sg13cmos5l_nand2_1
X_5375_ _5375_/Y _5632_/A1 _5373_/A _5373_/Y _5370_/Y _5374_/X vddd vssd sg13cmos5l_a221oi_1
X_7114_ _7114_/Q _7255_/CLK _7114_/D fanout395/X vddd vssd sg13cmos5l_dfrbpq_1
Xfanout104 _4251_/B _3728_/Y vddd vssd sg13cmos5l_buf_1
XFILLER_25_2445 vddd vssd sg13cmos5l_decap_8
Xfanout126 _6759_/C _6773_/C vddd vssd sg13cmos5l_buf_1
Xfanout115 _3978_/A _3691_/Y vddd vssd sg13cmos5l_buf_1
X_4326_ _4326_/Y hold706/X _4320_/Y _4321_/Y vddd vssd sg13cmos5l_a21oi_1
Xfanout137 _5285_/D _4889_/X vddd vssd sg13cmos5l_buf_1
X_7045_ _7045_/Q _7279_/CLK _7045_/D fanout382/X vddd vssd sg13cmos5l_dfrbpq_1
XFILLER_25_1722 vddd vssd sg13cmos5l_decap_4
X_4257_ _4258_/C sram_odata[0] _4257_/B vddd vssd sg13cmos5l_nand2b_1
Xfanout159 _4789_/A _4651_/A vddd vssd sg13cmos5l_buf_1
Xfanout148 _5278_/A _4979_/X vddd vssd sg13cmos5l_buf_1
X_4188_ _4188_/Y _7248_/Q _3889_/B _3895_/X vddd vssd sg13cmos5l_a21oi_1
XFILLER_27_224 vddd vssd sg13cmos5l_decap_8
XFILLER_3_2274 vddd vssd sg13cmos5l_decap_8
XFILLER_32_2405 vddd vssd sg13cmos5l_decap_8
XFILLER_24_975 vddd vssd sg13cmos5l_decap_8
XFILLER_23_474 vddd vssd sg13cmos5l_decap_8
XFILLER_19_1548 vddd vssd sg13cmos5l_decap_4
X_6829_ _6829_/Y _6829_/A _6829_/B_N vddd vssd sg13cmos5l_nor2b_1
XFILLER_32_1704 vddd vssd sg13cmos5l_decap_4
XFILLER_12_42 vddd vssd sg13cmos5l_decap_8
XFILLER_8_1440 vddd vssd sg13cmos5l_decap_8
XFILLER_24_1232 vddd vssd sg13cmos5l_decap_8
Xtiedowns\[19\] _6221_/A vddd vssd sg13cmos5l_antennanp
XFILLER_14_441 vddd vssd sg13cmos5l_decap_8
XFILLER_31_1203 vddd vssd sg13cmos5l_decap_4
XFILLER_13_2382 vddd vssd sg13cmos5l_decap_8
X_3490_ _3490_/Y _4403_/B vddd vssd sg13cmos5l_inv_1
XFILLER_6_695 vddd vssd sg13cmos5l_decap_8
XFILLER_29_1121 vddd vssd sg13cmos5l_decap_4
X_5160_ _6150_/C _7283_/Q _7282_/Q vddd vssd sg13cmos5l_nand2b_1
X_4111_ _6120_/A dbus_in_left[1] dbus_in_right[1] vddd vssd sg13cmos5l_or2_1
X_5091_ _5091_/Y _6023_/D _5091_/B _5091_/C _5091_/D vddd vssd sg13cmos5l_nand4_1
X_4042_ _4042_/Y _4039_/Y _4040_/Y _4041_/Y vddd vssd sg13cmos5l_o21ai_1
XFILLER_20_2353 vddd vssd sg13cmos5l_decap_4
X_5993_ _5993_/X hold968/X _3689_/A _5994_/S vddd vssd sg13cmos5l_mux2_1
XFILLER_0_2469 vddd vssd sg13cmos5l_decap_8
Xclkbuf_3_2_0_SCK_regs clkload3/A clkbuf_0_SCK_regs/X vddd vssd sg13cmos5l_buf_8
X_4944_ _4946_/B _4949_/A _4952_/A _4932_/A vddd vssd sg13cmos5l_a21oi_1
XFILLER_21_956 vddd vssd sg13cmos5l_decap_8
XFILLER_14_2113 vddd vssd sg13cmos5l_decap_8
X_4875_ _4875_/Y _4878_/A vddd vssd sg13cmos5l_inv_1
X_3826_ wire58/A _7075_/Q _6708_/A vddd vssd sg13cmos5l_nor2_1
X_6614_ _6614_/X _6614_/A0 _6743_/A _6614_/S vddd vssd sg13cmos5l_mux2_1
XFILLER_20_444 vddd vssd sg13cmos5l_decap_8
XFILLER_31_2482 vddd vssd sg13cmos5l_decap_8
X_3757_ _3757_/Y _3757_/A wire61/X vddd vssd sg13cmos5l_nor2_1
X_6545_ _7226_/D _6545_/A1 _6546_/B _6544_/Y vddd vssd sg13cmos5l_a21oi_1
XFILLER_14_1489 vddd vssd sg13cmos5l_decap_8
X_3631__464 _7382_/CLK _7398_/CLK vddd vssd sg13cmos5l_inv_1
XFILLER_10_1309 vddd vssd sg13cmos5l_decap_8
X_6476_ _7188_/D _6476_/A1 _6479_/S _6475_/Y vddd vssd sg13cmos5l_a21oi_1
X_3688_ _3688_/Y _7033_/Q _4176_/A2 _6642_/A _7291_/Q vddd vssd sg13cmos5l_a22oi_1
X_5427_ _5429_/B _5427_/A _5427_/B vddd vssd sg13cmos5l_nor2_1
X_5358_ _5358_/Y _5527_/A _7149_/Q vddd vssd sg13cmos5l_nand2b_1
X_4309_ _4309_/Y _4301_/B _4308_/Y hold567/X vddd vssd sg13cmos5l_a21oi_1
X_7028_ _7028_/Q _7233_/CLK _7028_/D fanout373/X vddd vssd sg13cmos5l_dfrbpq_1
X_5289_ _5289_/Y _4892_/B _3641_/Y _4889_/X _4829_/A vddd vssd sg13cmos5l_a22oi_1
XFILLER_28_555 vddd vssd sg13cmos5l_decap_8
XFILLER_28_599 vddd vssd sg13cmos5l_decap_8
XFILLER_19_2057 vddd vssd sg13cmos5l_decap_8
XFILLER_19_1356 vddd vssd sg13cmos5l_decap_4
XFILLER_32_1523 vddd vssd sg13cmos5l_decap_8
XFILLER_23_63 vddd vssd sg13cmos5l_decap_8
XFILLER_10_2566 vddd vssd sg13cmos5l_decap_8
XFILLER_3_0 vddd vssd sg13cmos5l_decap_8
XFILLER_21_1961 vddd vssd sg13cmos5l_decap_8
XFILLER_0_56 vddd vssd sg13cmos5l_decap_8
XFILLER_9_21 vddd vssd sg13cmos5l_decap_8
XFILLER_15_2444 vddd vssd sg13cmos5l_decap_8
XFILLER_19_1890 vddd vssd sg13cmos5l_decap_8
X_4660_ _4660_/Y _4450_/C _4659_/Y _4819_/A vddd vssd sg13cmos5l_o21ai_1
X_3611_ _3611_/Y _3611_/A vddd vssd sg13cmos5l_inv_1
XFILLER_11_1607 vddd vssd sg13cmos5l_decap_8
X_6330_ _6330_/Y _6330_/A _6330_/B vddd vssd sg13cmos5l_nand2_1
X_4591_ _4591_/Y _4568_/B _4590_/X _4594_/A1 vddd vssd sg13cmos5l_o21ai_1
X_3542_ _5306_/B _3542_/A vddd vssd sg13cmos5l_inv_1
Xhold927 _3537_/A _6972_/Q vddd vssd sg13cmos5l_dlygate4sd3_1
Xhold905 hold905/X _3577_/Y vddd vssd sg13cmos5l_dlygate4sd3_1
Xhold916 hold916/X _3602_/Y vddd vssd sg13cmos5l_dlygate4sd3_1
X_3473_ _3473_/Y _4603_/A vddd vssd sg13cmos5l_inv_1
Xhold938 _7190_/D _6478_/X vddd vssd sg13cmos5l_dlygate4sd3_1
Xhold949 _6610_/A _7264_/Q vddd vssd sg13cmos5l_dlygate4sd3_1
X_6261_ _6261_/Y _4452_/A _6041_/B _6260_/Y vddd vssd sg13cmos5l_a21oi_1
X_6192_ _6192_/Y _6194_/B _6194_/C _5247_/C _4019_/Y vddd vssd sg13cmos5l_a22oi_1
X_5212_ _5223_/B _5212_/A _5212_/B vddd vssd sg13cmos5l_nor2_1
XFILLER_6_2601 vddd vssd sg13cmos5l_decap_4
X_5143_ _6087_/B _5228_/A _7277_/Q _5215_/B vddd vssd sg13cmos5l_nor3_1
XFILLER_26_2595 vddd vssd sg13cmos5l_decap_8
XFILLER_22_2448 vddd vssd sg13cmos5l_decap_8
X_5074_ _5074_/Y _7259_/Q _7258_/Q _5259_/B vddd vssd sg13cmos5l_nor3_1
X_4025_ _4025_/Y _3876_/B _3859_/A _6556_/A _5983_/A _4024_/Y vddd vssd sg13cmos5l_a221oi_1
XFILLER_0_2200 vddd vssd sg13cmos5l_decap_8
XFILLER_0_2211 vddd vssd sg13cmos5l_decap_8
XFILLER_0_2266 vddd vssd sg13cmos5l_decap_8
XFILLER_25_558 vddd vssd sg13cmos5l_decap_8
XFILLER_20_1471 vddd vssd sg13cmos5l_decap_4
X_5976_ _5978_/B _7232_/Q _7233_/Q _5976_/C vddd vssd sg13cmos5l_nor3_1
XFILLER_16_1518 vddd vssd sg13cmos5l_decap_8
X_4927_ _4965_/A _4964_/A _4964_/B vddd vssd sg13cmos5l_and2_1
XFILLER_21_742 vddd vssd sg13cmos5l_decap_8
X_4858_ _4858_/Y hold802/X _4826_/Y _4827_/Y sram_odata[0] _4859_/A2 vddd vssd sg13cmos5l_a221oi_1
X_3809_ wire18/A _3807_/Y _3808_/Y _3748_/Y vddd vssd sg13cmos5l_o21ai_1
XFILLER_20_285 vddd vssd sg13cmos5l_decap_8
X_4789_ _4789_/Y _4789_/A _4789_/B vddd vssd sg13cmos5l_nor2_1
XFILLER_14_1275 vddd vssd sg13cmos5l_decap_8
X_6528_ _6528_/Y _6632_/A _6532_/S vddd vssd sg13cmos5l_nor2_1
X_6459_ _6465_/B _6459_/A _6459_/B vddd vssd sg13cmos5l_nand2_1
XFILLER_27_2348 vddd vssd sg13cmos5l_decap_8
XFILLER_5_2155 vddd vssd sg13cmos5l_decap_8
XFILLER_29_864 vddd vssd sg13cmos5l_decap_4
XFILLER_5_1465 vddd vssd sg13cmos5l_decap_8
XFILLER_7_212 vddd vssd sg13cmos5l_decap_8
XFILLER_11_274 vddd vssd sg13cmos5l_decap_8
XFILLER_7_234 vddd vssd sg13cmos5l_decap_8
XFILLER_4_996 vddd vssd sg13cmos5l_decap_8
XFILLER_1_2531 vddd vssd sg13cmos5l_decap_4
XFILLER_21_2470 vddd vssd sg13cmos5l_decap_8
XFILLER_1_2597 vddd vssd sg13cmos5l_decap_8
X_5830_ _5830_/X io_in[0] _5829_/A _5829_/Y vddd vssd sg13cmos5l_a21o_1
XFILLER_17_2539 vddd vssd sg13cmos5l_decap_8
XFILLER_17_1805 vddd vssd sg13cmos5l_decap_8
XFILLER_15_580 vddd vssd sg13cmos5l_decap_8
X_5761_ _5761_/Y _5761_/A _5761_/B _5761_/C vddd vssd sg13cmos5l_nor3_1
X_4712_ _4713_/B _4712_/A _4712_/B vddd vssd sg13cmos5l_xnor2_1
X_5692_ _5707_/C _7196_/Q _7197_/Q vddd vssd sg13cmos5l_nand2_1
XFILLER_15_1584 vddd vssd sg13cmos5l_decap_8
X_4643_ _4648_/A _4734_/A _4643_/B _4643_/C vddd vssd sg13cmos5l_nand3_1
X_4574_ _4579_/A _4806_/A1 _4573_/Y _4499_/A vddd vssd sg13cmos5l_o21ai_1
X_7362_ _7362_/Q _7398_/CLK _7362_/D _6875_/Y vddd vssd sg13cmos5l_dfrbpq_1
Xhold702 hold702/X _6364_/Y vddd vssd sg13cmos5l_dlygate4sd3_1
X_3525_ _5004_/A _3525_/A vddd vssd sg13cmos5l_inv_1
XFILLER_28_2602 vddd vssd sg13cmos5l_decap_4
Xhold746 _5939_/A _6967_/Q vddd vssd sg13cmos5l_dlygate4sd3_1
X_7293_ _7293_/Q _7293_/CLK _7293_/D fanout383/X vddd vssd sg13cmos5l_dfrbpq_1
Xhold724 _4855_/A _7319_/Q vddd vssd sg13cmos5l_dlygate4sd3_1
Xhold713 _6337_/A _7116_/Q vddd vssd sg13cmos5l_dlygate4sd3_1
Xhold735 _3540_/A _7089_/Q vddd vssd sg13cmos5l_dlygate4sd3_1
X_6313_ _6313_/Y _6330_/A _6790_/B vddd vssd sg13cmos5l_nand2_1
X_6244_ _6244_/Y _6243_/Y _6244_/B vddd vssd sg13cmos5l_nand2b_1
Xhold779 _4329_/A _4327_/Y vddd vssd sg13cmos5l_dlygate4sd3_1
Xhold757 hold757/X _3513_/Y vddd vssd sg13cmos5l_dlygate4sd3_1
Xhold768 _7099_/D _6789_/Y vddd vssd sg13cmos5l_dlygate4sd3_1
X_6175_ _6175_/Y _6172_/Y _6173_/Y _6174_/Y vddd vssd sg13cmos5l_o21ai_1
XFILLER_6_2453 vddd vssd sg13cmos5l_decap_8
XFILLER_29_116 vddd vssd sg13cmos5l_decap_8
XFILLER_26_2392 vddd vssd sg13cmos5l_decap_8
Xhold1402 _7341_/D _4491_/X vddd vssd sg13cmos5l_dlygate4sd3_1
Xhold1413 hold1413/X _7223_/Q vddd vssd sg13cmos5l_dlygate4sd3_1
X_5126_ _6080_/A _5214_/A _5126_/B vddd vssd sg13cmos5l_nand2b_1
Xhold1424 _7133_/D _6369_/Y vddd vssd sg13cmos5l_dlygate4sd3_1
Xhold1446 _7340_/D _4519_/X vddd vssd sg13cmos5l_dlygate4sd3_1
Xhold1457 hold1457/X _7335_/Q vddd vssd sg13cmos5l_dlygate4sd3_1
XFILLER_22_2256 vddd vssd sg13cmos5l_decap_4
Xhold1468 hold1468/X _7379_/Q vddd vssd sg13cmos5l_dlygate4sd3_1
X_5057_ _5060_/C _7260_/Q _7261_/Q _7263_/Q _7262_/Q vddd vssd sg13cmos5l_nor4_1
XFILLER_2_1605 vddd vssd sg13cmos5l_decap_8
Xhold1435 hold1435/X _7198_/Q vddd vssd sg13cmos5l_dlygate4sd3_1
Xhold1479 hold1479/X _7337_/Q vddd vssd sg13cmos5l_dlygate4sd3_1
X_4008_ _4011_/A _7278_/Q _6629_/A _4007_/Y vddd vssd sg13cmos5l_o21ai_1
XFILLER_22_1577 vddd vssd sg13cmos5l_decap_8
XFILLER_0_2041 vddd vssd sg13cmos5l_decap_8
XFILLER_25_366 vddd vssd sg13cmos5l_decap_8
X_5959_ _5961_/A _6215_/A _7232_/Q _7233_/Q vddd vssd sg13cmos5l_nor3_1
XFILLER_20_42 vddd vssd sg13cmos5l_decap_8
XFILLER_5_749 vddd vssd sg13cmos5l_decap_8
XFILLER_11_1982 vddd vssd sg13cmos5l_decap_8
XFILLER_0_443 vddd vssd sg13cmos5l_decap_8
XFILLER_29_51 vddd vssd sg13cmos5l_decap_8
XFILLER_29_95 vddd vssd sg13cmos5l_decap_8
XFILLER_5_1273 vddd vssd sg13cmos5l_decap_8
XFILLER_32_859 vddd vssd sg13cmos5l_decap_8
XFILLER_12_1702 vddd vssd sg13cmos5l_decap_8
XFILLER_32_1150 vddd vssd sg13cmos5l_decap_8
XFILLER_10_2182 vddd vssd sg13cmos5l_decap_8
XANTENNA_4 _3728_/Y vddd vssd sg13cmos5l_antennanp
XFILLER_12_1768 vddd vssd sg13cmos5l_decap_4
XFILLER_6_77 vddd vssd sg13cmos5l_decap_8
X_4290_ _4976_/B _4302_/A _4294_/B _4303_/B vddd vssd sg13cmos5l_nand3_1
XFILLER_6_1004 vddd vssd sg13cmos5l_decap_8
XFILLER_23_2565 vddd vssd sg13cmos5l_decap_8
XFILLER_26_119 vddd vssd sg13cmos5l_decap_8
X_6931_ _6931_/Y _6952_/A _6949_/B_N vddd vssd sg13cmos5l_nor2b_1
XFILLER_1_2372 vddd vssd sg13cmos5l_decap_4
X_6862_ _6862_/Y _6863_/A _6863_/B_N vddd vssd sg13cmos5l_nor2b_1
XFILLER_23_848 vddd vssd sg13cmos5l_decap_8
X_5813_ _5813_/Y _5813_/A _7215_/Q vddd vssd sg13cmos5l_nand2_1
X_6793_ _6793_/X _6793_/A vddd vssd sg13cmos5l_buf_1
X_5744_ _5769_/C _7204_/Q _5753_/B vddd vssd sg13cmos5l_nand2_1
XFILLER_30_2536 vddd vssd sg13cmos5l_decap_8
XFILLER_30_1813 vddd vssd sg13cmos5l_decap_4
X_5675_ _5682_/B _7194_/Q _7195_/Q vddd vssd sg13cmos5l_nor2_1
XFILLER_15_2093 vddd vssd sg13cmos5l_decap_8
X_4626_ _4626_/Y _4782_/A _4624_/Y _4625_/Y _4499_/A _4623_/Y vddd vssd sg13cmos5l_a221oi_1
Xhold510 _3468_/A _6994_/Q vddd vssd sg13cmos5l_dlygate4sd3_1
X_7345_ _7345_/Q _7348_/CLK _7345_/D _6858_/Y vddd vssd sg13cmos5l_dfrbpq_1
Xhold554 _4509_/A _7011_/Q vddd vssd sg13cmos5l_dlygate4sd3_1
Xhold521 _7011_/D _3463_/Y vddd vssd sg13cmos5l_dlygate4sd3_1
Xhold532 _4772_/B hold532/A vddd vssd sg13cmos5l_dlygate4sd3_1
Xhold543 _6999_/D _6793_/X vddd vssd sg13cmos5l_dlygate4sd3_1
X_4557_ _4557_/Y _4553_/Y _4554_/Y _4556_/Y vddd vssd sg13cmos5l_o21ai_1
Xhold565 _6998_/D _6794_/X vddd vssd sg13cmos5l_dlygate4sd3_1
X_7276_ _7276_/Q _7278_/CLK _7276_/D fanout385/X vddd vssd sg13cmos5l_dfrbpq_1
Xhold576 _6975_/D _5956_/X vddd vssd sg13cmos5l_dlygate4sd3_1
X_4488_ _4488_/Y _4774_/B _4438_/B _4438_/A vddd vssd sg13cmos5l_o21ai_1
X_3508_ _3508_/Y _4855_/A vddd vssd sg13cmos5l_inv_1
Xhold587 _7385_/D _4084_/Y vddd vssd sg13cmos5l_dlygate4sd3_1
XFILLER_8_2515 vddd vssd sg13cmos5l_decap_8
XFILLER_28_2476 vddd vssd sg13cmos5l_decap_8
X_6227_ _6227_/Y _6227_/A1 _7230_/Q _6226_/X vddd vssd sg13cmos5l_o21ai_1
Xhold598 hold598/X _4000_/Y vddd vssd sg13cmos5l_dlygate4sd3_1
X_6158_ _6158_/Y _6112_/A _5217_/Y _5223_/B vddd vssd sg13cmos5l_a21oi_1
XFILLER_22_2031 vddd vssd sg13cmos5l_decap_4
X_5109_ _5120_/C _7263_/Q _7262_/Q _5275_/B vddd vssd sg13cmos5l_nor3_1
Xhold1210 _7332_/D _4704_/Y vddd vssd sg13cmos5l_dlygate4sd3_1
XFILLER_2_2114 vddd vssd sg13cmos5l_decap_4
Xhold1221 _6537_/A1 _5871_/B vddd vssd sg13cmos5l_dlygate4sd3_1
Xhold1243 _6586_/A0 _7249_/Q vddd vssd sg13cmos5l_dlygate4sd3_1
Xhold1232 _6405_/A1 _3557_/Y vddd vssd sg13cmos5l_dlygate4sd3_1
Xhold1265 _7069_/D _6737_/X vddd vssd sg13cmos5l_dlygate4sd3_1
Xhold1254 _6476_/A1 _5654_/B vddd vssd sg13cmos5l_dlygate4sd3_1
Xhold1276 _6466_/A1 _5583_/B vddd vssd sg13cmos5l_dlygate4sd3_1
X_6089_ _6089_/X _4107_/Y _5168_/C _5168_/B vddd vssd sg13cmos5l_a21o_1
XFILLER_2_1402 vddd vssd sg13cmos5l_decap_4
Xhold1298 _6730_/A1 _7064_/Q vddd vssd sg13cmos5l_dlygate4sd3_1
Xhold1287 _6721_/A1 _7057_/Q vddd vssd sg13cmos5l_dlygate4sd3_1
XFILLER_14_804 vddd vssd sg13cmos5l_decap_8
XFILLER_25_163 vddd vssd sg13cmos5l_decap_8
XFILLER_13_314 vddd vssd sg13cmos5l_decap_4
XFILLER_15_42 vddd vssd sg13cmos5l_decap_8
XFILLER_21_391 vddd vssd sg13cmos5l_decap_4
XFILLER_16_1156 vddd vssd sg13cmos5l_decap_8
XFILLER_31_30 vddd vssd sg13cmos5l_decap_8
XFILLER_29_1506 vddd vssd sg13cmos5l_decap_8
XFILLER_11_2491 vddd vssd sg13cmos5l_decap_8
XFILLER_29_1528 vddd vssd sg13cmos5l_decap_4
Xtiedowns\[49\] mask_rev_in[5] vddd vssd sg13cmos5l_antennanp
XFILLER_0_262 vddd vssd sg13cmos5l_decap_8
XFILLER_7_1313 vddd vssd sg13cmos5l_decap_4
XFILLER_31_100 vddd vssd sg13cmos5l_decap_8
Xclkbuf_leaf_4_SCK_regs _7179_/CLK clkload2/A vddd vssd sg13cmos5l_buf_8
XFILLER_32_656 vddd vssd sg13cmos5l_decap_8
XFILLER_31_177 vddd vssd sg13cmos5l_decap_8
X_3790_ _3791_/B dbus_in_left[5] dbus_in_right[5] vddd vssd sg13cmos5l_or2_1
XFILLER_20_818 vddd vssd sg13cmos5l_decap_8
XFILLER_18_1966 vddd vssd sg13cmos5l_decap_8
XFILLER_18_1988 vddd vssd sg13cmos5l_decap_8
XFILLER_14_1819 vddd vssd sg13cmos5l_decap_8
XFILLER_9_841 vddd vssd sg13cmos5l_decap_8
X_5460_ _5460_/Y _5604_/A1 _5431_/Y _5459_/Y vddd vssd sg13cmos5l_a21oi_1
X_4411_ _4411_/Y _4414_/A _4414_/B _4411_/B1 vddd vssd sg13cmos5l_o21ai_1
XFILLER_12_1532 vddd vssd sg13cmos5l_decap_8
X_5391_ _5391_/Y _5674_/A _7152_/Q vddd vssd sg13cmos5l_nor2_1
XFILLER_28_1016 vddd vssd sg13cmos5l_decap_8
X_7130_ _7130_/Q _7355_/CLK _7130_/D _6907_/B_N vddd vssd sg13cmos5l_dfrbpq_1
X_4342_ _4343_/B _4342_/A _4342_/B vddd vssd sg13cmos5l_nor2_1
X_7061_ _7061_/Q _7066_/CLK _7061_/D fanout356/X vddd vssd sg13cmos5l_dfrbpq_1
Xfanout308 _5454_/A hold1398/X vddd vssd sg13cmos5l_buf_1
Xfanout319 _4755_/A _7078_/Q vddd vssd sg13cmos5l_buf_1
X_4273_ _4276_/B _4308_/A _4298_/A _4273_/C vddd vssd sg13cmos5l_nand3b_1
X_6012_ _6013_/B _6012_/A _6012_/B vddd vssd sg13cmos5l_nor2_1
.ends

.subckt chipalooza_frame vddd vdd3v3 vdd1v2 s1_an[0] s1_an[1] s2_an[0] s2_an[1] s3_an[0]
+ s3_an[1] s4_an[0] s5_an[0] s5_an[1] s5_an[2] s6_an[0] s6_an[1] s8_an[0] s9_an[0]
+ s9_an[1] s9_an[2] analog[0] analog[1] analog[2] analog[3] s10_an[0] s10_an[1] s10_an[2]
+ s11_an[0] s12_an[0] s12_an[1] s13_an[0] s13_an[1] s14_an[0] s14_an[1] s14_an[2]
+ s15_an[0] s16_an[0] s16_an[1] s17_an[0] s17_an[1] s18_an[0] s18_an[1] SDO_out SDO_ena
+ SDI_in CSB_in SCK_in clk_in gpio_in[0] gpio_out[0] gpio_oe[0] gpio_in[1] gpio_out[1]
+ gpio_oe[1] gpio_in[2] gpio_out[2] gpio_oe[2] gpio_in[3] gpio_out[3] gpio_oe[3] gpio_in[4]
+ gpio_out[4] gpio_oe[4] gpio_in[5] gpio_out[5] gpio_oe[5] gpio_in[6] gpio_out[6]
+ gpio_oe[6] gpio_in[7] gpio_out[7] gpio_oe[7] gpio_in[8] gpio_out[8] gpio_oe[8] gpio_in[9]
+ gpio_out[9] gpio_oe[9] gpio_in[10] gpio_out[10] gpio_oe[10] gpio_in[11] gpio_out[11]
+ gpio_oe[11] analog_esd[0] analog_esd[1] analog_esd[2] analog_esd[3] s1_an_0_esd
+ s1_an_1_esd s2_an_0_esd s2_an_1_esd s3_an_0_esd s3_an_1_esd s4_an_0_esd s5_an_0_esd
+ s5_an_1_esd s5_an_2_esd s6_an_0_esd s6_an_1_esd s8_an_0_esd s9_an_0_esd s9_an_1_esd
+ s9_an_2_esd s10_an_0_esd s10_an_1_esd s10_an_2_esd s11_an_0_esd s12_an_0_esd s12_an_1_esd
+ s13_an_0_esd s13_an_1_esd s14_an_0_esd s14_an_1_esd s14_an_2_esd s15_an_0_esd s16_an_0_esd
+ s16_an_1_esd s17_an_0_esd s17_an_1_esd s18_an_0_esd s18_an_1_esd mask_rev[0] mask_rev[1]
+ mask_rev[2] mask_rev[3] mask_rev[4] mask_rev[5] mask_rev[6] mask_rev[7] mask_rev[8]
+ mask_rev[9] mask_rev[20] mask_rev[21] mask_rev[22] mask_rev[23] mask_rev[24] mask_rev[25]
+ mask_rev[26] vdd1v2_uq0 vdd1v2_uq2 slot7_wrapper_0/s7_an_0_vcm slot7_wrapper_0/s7_an_0_vref
+ mask_rev[27] slot7_wrapper_0/s7_an_0_en_3v3_b mask_rev[28] mask_rev[29] slot7_wrapper_0/s7_an_0_outp
+ slot7_wrapper_0/s7_an_0_outn mask_rev[10] slot7_wrapper_0/s7_an_1_vref mask_rev[11]
+ slot7_wrapper_0/s7_an_1_en_3v3_b chipalooza_frame_wrapper_0/m1_375748_55800# mask_rev[12]
+ slot7_wrapper_0/s7_an_1_en_3v3 mask_rev[13] slot7_wrapper_0/s7_an_1_vinp mask_rev[30]
+ mask_rev[14] mask_rev[31] slot7_wrapper_0/s7_an_0_iref mask_rev[15] slot7_wrapper_0/s7_an_1_vinn
+ mask_rev[16] mask_rev[17] mask_rev[18] slot7_wrapper_0/s7_an_0_en_3v3 mask_rev[19]
+ slot7_wrapper_0/s7_an_1_iref sub
Xslot16_wrapper_0 sub s16_an[0] s16_an[1] s16_an_0_esd s16_an_1_esd slot16_wrapper_0/vbias
+ slot16_wrapper_0/dig_in[23] slot16_wrapper_0/dig_in[22] slot16_wrapper_0/dig_in[21]
+ slot16_wrapper_0/dig_in[20] slot16_wrapper_0/dig_in[19] slot16_wrapper_0/dig_in[18]
+ slot16_wrapper_0/dig_in[17] slot16_wrapper_0/dig_in[16] slot16_wrapper_0/dig_in[15]
+ slot16_wrapper_0/dig_in[14] slot16_wrapper_0/dig_in[13] slot16_wrapper_0/dig_in[12]
+ slot16_wrapper_0/dig_in[11] slot16_wrapper_0/dig_in[10] slot16_wrapper_0/dig_in[9]
+ slot16_wrapper_0/dig_in[8] slot16_wrapper_0/dig_in[7] slot16_wrapper_0/dig_in[6]
+ slot16_wrapper_0/dig_in[5] slot16_wrapper_0/dig_in[4] slot16_wrapper_0/dig_in[3]
+ slot16_wrapper_0/dig_in[2] slot16_wrapper_0/dig_in[1] slot16_wrapper_0/dig_in[0]
+ slot16_wrapper_0/dig_out[11] slot16_wrapper_0/dig_out[10] slot16_wrapper_0/dig_out[9]
+ slot16_wrapper_0/dig_out[8] slot16_wrapper_0/dig_out[7] slot16_wrapper_0/dig_out[6]
+ slot16_wrapper_0/dig_out[5] slot16_wrapper_0/dig_out[4] slot16_wrapper_0/dig_out[3]
+ slot16_wrapper_0/dig_out[2] slot16_wrapper_0/dig_out[1] slot16_wrapper_0/dig_out[0]
+ slot16_wrapper_0/ibias0 slot16_wrapper_0/ibias1 slot16_wrapper_0/analog_bus3 slot16_wrapper_0/analog_bus2
+ slot16_wrapper_0/analog_bus1 slot16_wrapper_0/analog_bus0 slot16_wrapper_0/vdd_1v2
+ sub slot16_wrapper_0/vdd_3v3 slot16_wrapper_0/enable slot16_wrapper_0/clk slot16_wrapper_0/reset
+ slot16_wrapper
Xanalog_switch_array_7[0] analog[0] analog_switch_array_7[0]/analog_switch_med_17/enable
+ analog_switch_small_1/in sub analog_switch_array_7[0]/analog_switch_med_0/enable
+ analog_switch_array_7[0]/analog_switch_med_2/enable sub slot1_wrapper_0/analog_bus1
+ sub slot1_wrapper_0/analog_bus3 analog_switch_array_7[0]/analog_switch_med_20/enable
+ analog_switch_array_7[0]/analog_switch_med_1/enable analog_pswitch_small_1/out sub
+ vdd3v3 analog_switch_array_7[0]/analog_pswitch_small_3/enable analog_pswitch_small_0/out
+ slot1_wrapper_0/analog_bus0 sub slot18_wrapper_0/analog_bus2 sub analog_switch_array_7[0]/analog_pswitch_small_2/enable
+ vdd3v3 analog_switch_array_7[0]/analog_switch_small_1/enable vdd3v3 analog_switch_array_7[0]/analog_switch_med_3/enable
+ slot1_wrapper_0/vbias slot18_wrapper_0/analog_bus0 slot18_wrapper_0/analog_bus1
+ vdd1v2_uq2 slot18_wrapper_0/analog_bus3 vdd3v3 vdd1v2_uq2 sub slot18_wrapper_0/ibias0
+ slot1_wrapper_0/ibias1 slot1_wrapper_0/analog_bus2 analog_switch_array_7[0]/analog_pswitch_small_1/enable
+ sub vdd1v2_uq2 slot1_wrapper_0/ibias0 analog_switch_array_7[0]/analog_switch_small_0/enable
+ sub vdd1v2_uq2 sub sub sub vdd3v3 analog[2] analog[3] slot18_wrapper_0/ibias1 sub
+ analog_switch_array_7[0]/analog_switch_med_18/enable slot18_wrapper_0/vbias analog_switch_array_7[0]/analog_pswitch_small_0/enable
+ vdd3v3 sub analog_switch_array_7[0]/analog_switch_med_22/enable vdd1v2_uq2 sub sub
+ vdd1v2_uq2 sub sub analog[1] vdd3v3 vdd1v2_uq2 sub vdd1v2_uq2 sub sub sub analog_switch_array
Xanalog_switch_array_7[1] analog[0] analog_switch_array_7[1]/analog_switch_med_17/enable
+ analog_switch_small_1/in sub analog_switch_array_7[1]/analog_switch_med_0/enable
+ analog_switch_array_7[1]/analog_switch_med_2/enable sub slot2_wrapper_0/analog_bus1
+ sub slot2_wrapper_0/analog_bus3 analog_switch_array_7[1]/analog_switch_med_20/enable
+ analog_switch_array_7[1]/analog_switch_med_1/enable analog_pswitch_small_1/out sub
+ vdd3v3 analog_switch_array_7[1]/analog_pswitch_small_3/enable analog_pswitch_small_0/out
+ slot2_wrapper_0/analog_bus0 sub slot17_wrapper_0/analog_bus2 sub analog_switch_array_7[1]/analog_pswitch_small_2/enable
+ vdd3v3 analog_switch_array_7[1]/analog_switch_small_1/enable vdd3v3 analog_switch_array_7[1]/analog_switch_med_3/enable
+ slot2_wrapper_0/vbias slot17_wrapper_0/analog_bus0 slot17_wrapper_0/analog_bus1
+ vdd1v2_uq2 slot17_wrapper_0/analog_bus3 vdd3v3 vdd1v2_uq2 sub slot17_wrapper_0/ibias0
+ slot2_wrapper_0/ibias1 slot2_wrapper_0/analog_bus2 analog_switch_array_7[1]/analog_pswitch_small_1/enable
+ sub vdd1v2_uq2 slot2_wrapper_0/ibias0 analog_switch_array_7[1]/analog_switch_small_0/enable
+ sub vdd1v2_uq2 sub sub sub vdd3v3 analog[2] analog[3] slot17_wrapper_0/ibias1 sub
+ analog_switch_array_7[1]/analog_switch_med_18/enable slot17_wrapper_0/vbias analog_switch_array_7[1]/analog_pswitch_small_0/enable
+ vdd3v3 sub analog_switch_array_7[1]/analog_switch_med_22/enable vdd1v2_uq2 sub sub
+ vdd1v2_uq2 sub sub analog[1] vdd3v3 vdd1v2_uq2 sub vdd1v2_uq2 sub sub sub analog_switch_array
Xanalog_switch_array_7[2] analog[0] analog_switch_array_7[2]/analog_switch_med_17/enable
+ analog_switch_small_1/in sub analog_switch_array_7[2]/analog_switch_med_0/enable
+ analog_switch_array_7[2]/analog_switch_med_2/enable sub slot3_wrapper_0/analog_bus1
+ sub slot3_wrapper_0/analog_bus3 analog_switch_array_7[2]/analog_switch_med_20/enable
+ analog_switch_array_7[2]/analog_switch_med_1/enable analog_pswitch_small_1/out sub
+ vdd3v3 analog_switch_array_7[2]/analog_pswitch_small_3/enable analog_pswitch_small_0/out
+ slot3_wrapper_0/analog_bus0 sub slot16_wrapper_0/analog_bus2 sub analog_switch_array_7[2]/analog_pswitch_small_2/enable
+ vdd3v3 analog_switch_array_7[2]/analog_switch_small_1/enable vdd3v3 analog_switch_array_7[2]/analog_switch_med_3/enable
+ slot3_wrapper_0/vbias slot16_wrapper_0/analog_bus0 slot16_wrapper_0/analog_bus1
+ vdd1v2_uq2 slot16_wrapper_0/analog_bus3 vdd3v3 vdd1v2_uq2 sub slot16_wrapper_0/ibias0
+ slot3_wrapper_0/ibias1 slot3_wrapper_0/analog_bus2 analog_switch_array_7[2]/analog_pswitch_small_1/enable
+ sub vdd1v2_uq2 slot3_wrapper_0/ibias0 analog_switch_array_7[2]/analog_switch_small_0/enable
+ sub vdd1v2_uq2 sub sub sub vdd3v3 analog[2] analog[3] slot16_wrapper_0/ibias1 sub
+ analog_switch_array_7[2]/analog_switch_med_18/enable slot16_wrapper_0/vbias analog_switch_array_7[2]/analog_pswitch_small_0/enable
+ vdd3v3 sub analog_switch_array_7[2]/analog_switch_med_22/enable vdd1v2_uq2 sub sub
+ vdd1v2_uq2 sub sub analog[1] vdd3v3 vdd1v2_uq2 sub vdd1v2_uq2 sub sub sub analog_switch_array
Xanalog_switch_array_7[3] analog[0] analog_switch_array_7[3]/analog_switch_med_17/enable
+ analog_switch_small_1/in sub analog_switch_array_7[3]/analog_switch_med_0/enable
+ analog_switch_array_7[3]/analog_switch_med_2/enable sub slot4_wrapper_0/analog_bus1
+ sub slot4_wrapper_0/analog_bus3 analog_switch_array_7[3]/analog_switch_med_20/enable
+ analog_switch_array_7[3]/analog_switch_med_1/enable analog_pswitch_small_1/out sub
+ vdd3v3 analog_switch_array_7[3]/analog_pswitch_small_3/enable analog_pswitch_small_0/out
+ slot4_wrapper_0/analog_bus0 sub slot15_wrapper_0/analog_bus2 sub analog_switch_array_7[3]/analog_pswitch_small_2/enable
+ vdd3v3 analog_switch_array_7[3]/analog_switch_small_1/enable vdd3v3 analog_switch_array_7[3]/analog_switch_med_3/enable
+ slot4_wrapper_0/vbias slot15_wrapper_0/analog_bus0 slot15_wrapper_0/analog_bus1
+ vdd1v2_uq2 slot15_wrapper_0/analog_bus3 vdd3v3 vdd1v2_uq2 sub slot15_wrapper_0/ibias0
+ slot4_wrapper_0/ibias1 slot4_wrapper_0/analog_bus2 analog_switch_array_7[3]/analog_pswitch_small_1/enable
+ sub vdd1v2_uq2 slot4_wrapper_0/ibias0 analog_switch_array_7[3]/analog_switch_small_0/enable
+ sub vdd1v2_uq2 sub sub sub vdd3v3 analog[2] analog[3] slot15_wrapper_0/ibias1 sub
+ analog_switch_array_7[3]/analog_switch_med_18/enable slot15_wrapper_0/vbias analog_switch_array_7[3]/analog_pswitch_small_0/enable
+ vdd3v3 sub analog_switch_array_7[3]/analog_switch_med_22/enable vdd1v2_uq2 sub sub
+ vdd1v2_uq2 sub sub analog[1] vdd3v3 vdd1v2_uq2 sub vdd1v2_uq2 sub sub sub analog_switch_array
Xanalog_switch_array_7[4] analog[0] analog_switch_array_7[4]/analog_switch_med_17/enable
+ analog_switch_small_1/in sub analog_switch_array_7[4]/analog_switch_med_0/enable
+ analog_switch_array_7[4]/analog_switch_med_2/enable sub slot5_wrapper_0/analog_bus1
+ sub slot5_wrapper_0/analog_bus3 analog_switch_array_7[4]/analog_switch_med_20/enable
+ analog_switch_array_7[4]/analog_switch_med_1/enable analog_pswitch_small_1/out sub
+ vdd3v3 analog_switch_array_7[4]/analog_pswitch_small_3/enable analog_pswitch_small_0/out
+ slot5_wrapper_0/analog_bus0 sub slot14_wrapper_0/analog_bus2 sub analog_switch_array_7[4]/analog_pswitch_small_2/enable
+ vdd3v3 analog_switch_array_7[4]/analog_switch_small_1/enable vdd3v3 analog_switch_array_7[4]/analog_switch_med_3/enable
+ slot5_wrapper_0/vbias slot14_wrapper_0/analog_bus0 slot14_wrapper_0/analog_bus1
+ vdd1v2_uq2 slot14_wrapper_0/analog_bus3 vdd3v3 vdd1v2_uq2 sub slot14_wrapper_0/ibias0
+ slot5_wrapper_0/ibias1 slot5_wrapper_0/analog_bus2 analog_switch_array_7[4]/analog_pswitch_small_1/enable
+ sub vdd1v2_uq2 slot5_wrapper_0/ibias0 analog_switch_array_7[4]/analog_switch_small_0/enable
+ sub vdd1v2_uq2 sub sub sub vdd3v3 analog[2] analog[3] slot14_wrapper_0/ibias1 sub
+ analog_switch_array_7[4]/analog_switch_med_18/enable slot14_wrapper_0/vbias analog_switch_array_7[4]/analog_pswitch_small_0/enable
+ vdd3v3 sub analog_switch_array_7[4]/analog_switch_med_22/enable vdd1v2_uq2 sub sub
+ vdd1v2_uq2 sub sub analog[1] vdd3v3 vdd1v2_uq2 sub vdd1v2_uq2 sub sub sub analog_switch_array
Xanalog_switch_array_7[5] analog[0] analog_switch_array_7[5]/analog_switch_med_17/enable
+ analog_switch_small_1/in sub analog_switch_array_7[5]/analog_switch_med_0/enable
+ analog_switch_array_7[5]/analog_switch_med_2/enable sub slot6_wrapper_0/analog_bus1
+ sub slot6_wrapper_0/analog_bus3 analog_switch_array_7[5]/analog_switch_med_20/enable
+ analog_switch_array_7[5]/analog_switch_med_1/enable analog_pswitch_small_1/out sub
+ vdd3v3 analog_switch_array_7[5]/analog_pswitch_small_3/enable analog_pswitch_small_0/out
+ slot6_wrapper_0/analog_bus0 sub slot13_wrapper_0/analog_bus2 sub analog_switch_array_7[5]/analog_pswitch_small_2/enable
+ vdd3v3 analog_switch_array_7[5]/analog_switch_small_1/enable vdd3v3 analog_switch_array_7[5]/analog_switch_med_3/enable
+ slot6_wrapper_0/vbias slot13_wrapper_0/analog_bus0 slot13_wrapper_0/analog_bus1
+ vdd1v2_uq2 slot13_wrapper_0/analog_bus3 vdd3v3 vdd1v2_uq2 sub slot13_wrapper_0/ibias0
+ slot6_wrapper_0/ibias1 slot6_wrapper_0/analog_bus2 analog_switch_array_7[5]/analog_pswitch_small_1/enable
+ sub vdd1v2_uq2 slot6_wrapper_0/ibias0 analog_switch_array_7[5]/analog_switch_small_0/enable
+ sub vdd1v2_uq2 sub sub sub vdd3v3 analog[2] analog[3] slot13_wrapper_0/ibias1 sub
+ analog_switch_array_7[5]/analog_switch_med_18/enable slot13_wrapper_0/vbias analog_switch_array_7[5]/analog_pswitch_small_0/enable
+ vdd3v3 sub analog_switch_array_7[5]/analog_switch_med_22/enable vdd1v2_uq2 sub sub
+ vdd1v2_uq2 sub sub analog[1] vdd3v3 vdd1v2_uq2 sub vdd1v2_uq2 sub sub sub analog_switch_array
Xanalog_switch_array_7[6] analog[0] analog_switch_array_7[6]/analog_switch_med_17/enable
+ analog_switch_small_1/in sub analog_switch_array_7[6]/analog_switch_med_0/enable
+ analog_switch_array_7[6]/analog_switch_med_2/enable sub slot7_wrapper_0/analog_bus1
+ sub slot7_wrapper_0/analog_bus3 analog_switch_array_7[6]/analog_switch_med_20/enable
+ analog_switch_array_7[6]/analog_switch_med_1/enable analog_pswitch_small_1/out sub
+ vdd3v3 analog_switch_array_7[6]/analog_pswitch_small_3/enable analog_pswitch_small_0/out
+ slot7_wrapper_0/analog_bus0 sub slot12_wrapper_0/analog_bus2 sub analog_switch_array_7[6]/analog_pswitch_small_2/enable
+ vdd3v3 analog_switch_array_7[6]/analog_switch_small_1/enable vdd3v3 analog_switch_array_7[6]/analog_switch_med_3/enable
+ slot7_wrapper_0/vbias slot12_wrapper_0/analog_bus0 slot12_wrapper_0/analog_bus1
+ vdd1v2_uq2 slot12_wrapper_0/analog_bus3 vdd3v3 vdd1v2_uq2 sub slot12_wrapper_0/ibias0
+ slot7_wrapper_0/ibias1 slot7_wrapper_0/analog_bus2 analog_switch_array_7[6]/analog_pswitch_small_1/enable
+ sub vdd1v2_uq2 slot7_wrapper_0/ibias0 analog_switch_array_7[6]/analog_switch_small_0/enable
+ sub vdd1v2_uq2 sub sub sub vdd3v3 analog[2] analog[3] slot12_wrapper_0/ibias1 sub
+ analog_switch_array_7[6]/analog_switch_med_18/enable slot12_wrapper_0/vbias analog_switch_array_7[6]/analog_pswitch_small_0/enable
+ vdd3v3 sub analog_switch_array_7[6]/analog_switch_med_22/enable vdd1v2_uq2 sub sub
+ vdd1v2_uq2 sub sub analog[1] vdd3v3 vdd1v2_uq2 sub vdd1v2_uq2 sub sub sub analog_switch_array
Xanalog_switch_array_7[7] analog[0] analog_switch_array_7[7]/analog_switch_med_17/enable
+ analog_switch_small_1/in sub analog_switch_array_7[7]/analog_switch_med_0/enable
+ analog_switch_array_7[7]/analog_switch_med_2/enable sub slot8_wrapper_0/analog_bus1
+ sub slot8_wrapper_0/analog_bus3 analog_switch_array_7[7]/analog_switch_med_20/enable
+ analog_switch_array_7[7]/analog_switch_med_1/enable analog_pswitch_small_1/out sub
+ vdd3v3 analog_switch_array_7[7]/analog_pswitch_small_3/enable analog_pswitch_small_0/out
+ slot8_wrapper_0/analog_bus0 sub slot11_wrapper_0/analog_bus2 sub analog_switch_array_7[7]/analog_pswitch_small_2/enable
+ vdd3v3 analog_switch_array_7[7]/analog_switch_small_1/enable vdd3v3 analog_switch_array_7[7]/analog_switch_med_3/enable
+ slot8_wrapper_0/vbias slot11_wrapper_0/analog_bus0 slot11_wrapper_0/analog_bus1
+ vdd1v2_uq2 slot11_wrapper_0/analog_bus3 vdd3v3 vdd1v2_uq2 sub slot11_wrapper_0/ibias0
+ slot8_wrapper_0/ibias1 slot8_wrapper_0/analog_bus2 analog_switch_array_7[7]/analog_pswitch_small_1/enable
+ sub vdd1v2_uq2 slot8_wrapper_0/ibias0 analog_switch_array_7[7]/analog_switch_small_0/enable
+ sub vdd1v2_uq2 sub sub sub vdd3v3 analog[2] analog[3] slot11_wrapper_0/ibias1 sub
+ analog_switch_array_7[7]/analog_switch_med_18/enable slot11_wrapper_0/vbias analog_switch_array_7[7]/analog_pswitch_small_0/enable
+ vdd3v3 sub analog_switch_array_7[7]/analog_switch_med_22/enable vdd1v2_uq2 sub sub
+ vdd1v2_uq2 sub sub analog[1] vdd3v3 vdd1v2_uq2 sub vdd1v2_uq2 sub sub sub analog_switch_array
Xanalog_switch_array_7[8] analog[0] analog_switch_array_7[8]/analog_switch_med_17/enable
+ analog_switch_small_1/in sub analog_switch_array_7[8]/analog_switch_med_0/enable
+ analog_switch_array_7[8]/analog_switch_med_2/enable sub slot9_wrapper_0/analog_bus1
+ sub slot9_wrapper_0/analog_bus3 analog_switch_array_7[8]/analog_switch_med_20/enable
+ analog_switch_array_7[8]/analog_switch_med_1/enable analog_pswitch_small_1/out sub
+ vdd3v3 analog_switch_array_7[8]/analog_pswitch_small_3/enable analog_pswitch_small_0/out
+ slot9_wrapper_0/analog_bus0 sub slot10_wrapper_0/analog_bus2 sub analog_switch_array_7[8]/analog_pswitch_small_2/enable
+ vdd3v3 analog_switch_array_7[8]/analog_switch_small_1/enable vdd3v3 analog_switch_array_7[8]/analog_switch_med_3/enable
+ slot9_wrapper_0/vbias slot10_wrapper_0/analog_bus0 slot10_wrapper_0/analog_bus1
+ vdd1v2_uq2 slot10_wrapper_0/analog_bus3 vdd3v3 vdd1v2_uq2 sub slot10_wrapper_0/ibias0
+ slot9_wrapper_0/ibias1 slot9_wrapper_0/analog_bus2 analog_switch_array_7[8]/analog_pswitch_small_1/enable
+ sub vdd1v2_uq2 slot9_wrapper_0/ibias0 analog_switch_array_7[8]/analog_switch_small_0/enable
+ sub vdd1v2_uq2 sub sub sub vdd3v3 analog[2] analog[3] slot10_wrapper_0/ibias1 sub
+ analog_switch_array_7[8]/analog_switch_med_18/enable slot10_wrapper_0/vbias analog_switch_array_7[8]/analog_pswitch_small_0/enable
+ vdd3v3 sub analog_switch_array_7[8]/analog_switch_med_22/enable vdd1v2_uq2 sub sub
+ vdd1v2_uq2 sub sub analog[1] vdd3v3 vdd1v2_uq2 sub vdd1v2_uq2 sub sub sub analog_switch_array
Xproject_control_area_0 slot10_wrapper_0/dig_in[20] analog_switch_array_7[8]/analog_switch_med_1/enable
+ analog_switch_array_7[8]/analog_switch_med_0/enable slot10_wrapper_0/dig_out[7]
+ housekeeping_top_0/proj_sel[2] sub slot10_wrapper_0/dig_in[2] slot10_wrapper_0/dig_in[21]
+ housekeeping_top_0/dbus_out[22] slot10_wrapper_0/dig_out[8] housekeeping_top_0/proj_sel[1]
+ slot10_wrapper_0/dig_in[3] slot10_wrapper_0/dig_in[22] slot10_wrapper_0/dig_out[9]
+ housekeeping_top_0/analog_bus_ena[2] slot10_wrapper_0/analog_bus3 slot10_wrapper_0/dig_in[4]
+ analog_switch_array_7[8]/analog_switch_med_2/enable slot10_wrapper_0/dig_in[23]
+ project_control_area_0/user_project_control_0/dig_out[3] project_control_area_0/user_project_control_0/dig_out[11]
+ project_control_area_0/user_project_control_0/dig_out[4] slot10_wrapper_0/analog_bus2
+ slot10_wrapper_0/dig_in[5] housekeeping_top_0/analog_bus_ena[1] slot10_wrapper_0/analog_bus1
+ housekeeping_top_0/dbus_out[5] slot10_wrapper_0/dig_in[6] housekeeping_top_0/dbus_out[21]
+ housekeeping_top_0/dbus_out[9] project_control_area_0/user_project_control_0/dig_out[8]
+ slot10_wrapper_0/analog_bus0 project_control_area_0/user_project_control_0/dig_out[9]
+ slot10_wrapper_0/dig_in[7] sub slot10_wrapper_0/dig_in[8] analog_switch_array_7[8]/analog_pswitch_small_3/enable
+ housekeeping_top_0/proj_sel[0] housekeeping_top_0/dbus_out[1] slot10_wrapper_0/dig_in[9]
+ housekeeping_top_0/dbus_out[17] housekeeping_top_0/dbus_out[2] sub slot10_wrapper_0/dig_out[10]
+ housekeeping_top_0/proj_dig_ena slot10_wrapper_0/dig_out[11] housekeeping_top_0/dbus_out[10]
+ vdd1v2_uq2 vdd1v2_uq2 project_control_area_0/user_project_control_0/dig_out[5] housekeeping_top_0/proj_ibias_ena[1]
+ housekeeping_top_0/dbus_out[23] slot10_wrapper_0/ibias1 project_control_area_0/user_project_control_0/dig_out[10]
+ slot10_wrapper_0/vdd_3v3 housekeeping_top_0/dbus_out[6] slot10_wrapper_0/ibias0
+ slot10_wrapper_0/dig_in[10] sub housekeeping_top_0/proj_vbias_ena slot10_wrapper_0/dig_in[11]
+ vdd3v3 slot10_wrapper_0/enable sub sub slot10_wrapper_0/dig_in[12] slot10_wrapper_0/dig_in[13]
+ housekeeping_top_0/proj_3v3_ena sub slot10_wrapper_0/vbias slot10_wrapper_0/dig_in[14]
+ housekeeping_top_0/analog_bus_ena[3] housekeeping_top_0/proj_ibias_ena[0] sub slot10_wrapper_0/dig_in[15]
+ housekeeping_top_0/dbus_out[20] vdd1v2_uq2 housekeeping_top_0/dbus_out[19] slot10_wrapper_0/dig_in[16]
+ sub housekeeping_top_0/proj_sel[4] project_control_area_0/user_project_control_0/dig_out[6]
+ sub housekeeping_top_0/reset housekeeping_top_0/dbus_out[12] slot10_wrapper_0/dig_in[17]
+ housekeeping_top_0/analog_bus_ena[0] housekeeping_top_0/proj_1v2_ena slot10_wrapper_0/dig_in[18]
+ housekeeping_top_0/proj_ena slot10_wrapper_0/dig_in[19] vdd1v2_uq2 sub vdd3v3 housekeeping_top_0/dbus_out[14]
+ analog_switch_array_7[8]/analog_pswitch_small_2/enable sub housekeeping_top_0/dbus_out[16]
+ housekeeping_top_0/dbus_out[18] slot10_wrapper_0/dig_out[0] housekeeping_top_0/clk_out
+ slot10_wrapper_0/reset slot10_wrapper_0/dig_out[1] project_control_area_0/user_project_control_0/dig_out[2]
+ housekeeping_top_0/dbus_out[0] slot10_wrapper_0/dig_out[2] project_control_area_0/user_project_control_0/dig_out[7]
+ project_control_area_0/user_project_control_0/dig_out[0] slot10_wrapper_0/clk project_control_area_0/user_project_control_0/dig_out[1]
+ housekeeping_top_0/dbus_out[7] slot10_wrapper_0/dig_out[3] housekeeping_top_0/dbus_out[8]
+ housekeeping_top_0/dbus_out[11] sub slot10_wrapper_0/dig_out[4] housekeeping_top_0/dbus_out[3]
+ analog_switch_array_7[8]/analog_switch_small_1/enable housekeeping_top_0/proj_sel[3]
+ slot10_wrapper_0/dig_out[5] sub housekeeping_top_0/dbus_out[4] slot10_wrapper_0/dig_in[0]
+ housekeeping_top_0/dbus_out[15] sub analog_switch_array_7[8]/analog_switch_med_3/enable
+ housekeeping_top_0/dbus_out[13] slot10_wrapper_0/dig_out[6] sub slot10_wrapper_0/vdd_1v2
+ sub sub slot10_wrapper_0/dig_in[1] project_control_area
Xproject_control_area_1 slot9_wrapper_0/dig_in[20] analog_switch_array_7[8]/analog_switch_med_18/enable
+ analog_switch_array_7[8]/analog_switch_med_17/enable slot9_wrapper_0/dig_out[7]
+ housekeeping_top_0/proj_sel[2] sub slot9_wrapper_0/dig_in[2] slot9_wrapper_0/dig_in[21]
+ housekeeping_top_0/dbus_out[22] slot9_wrapper_0/dig_out[8] housekeeping_top_0/proj_sel[1]
+ slot9_wrapper_0/dig_in[3] slot9_wrapper_0/dig_in[22] slot9_wrapper_0/dig_out[9]
+ housekeeping_top_0/analog_bus_ena[2] slot9_wrapper_0/analog_bus3 slot9_wrapper_0/dig_in[4]
+ analog_switch_array_7[8]/analog_switch_med_20/enable slot9_wrapper_0/dig_in[23]
+ project_control_area_1/user_project_control_0/dig_out[3] project_control_area_1/user_project_control_0/dig_out[11]
+ project_control_area_1/user_project_control_0/dig_out[4] slot9_wrapper_0/analog_bus2
+ slot9_wrapper_0/dig_in[5] housekeeping_top_0/analog_bus_ena[1] slot9_wrapper_0/analog_bus1
+ housekeeping_top_0/dbus_out[5] slot9_wrapper_0/dig_in[6] housekeeping_top_0/dbus_out[21]
+ housekeeping_top_0/dbus_out[9] project_control_area_1/user_project_control_0/dig_out[8]
+ slot9_wrapper_0/analog_bus0 project_control_area_1/user_project_control_0/dig_out[9]
+ slot9_wrapper_0/dig_in[7] sub slot9_wrapper_0/dig_in[8] analog_switch_array_7[8]/analog_pswitch_small_0/enable
+ housekeeping_top_0/proj_sel[0] housekeeping_top_0/dbus_out[1] slot9_wrapper_0/dig_in[9]
+ housekeeping_top_0/dbus_out[17] housekeeping_top_0/dbus_out[2] vdd1v2_uq2 slot9_wrapper_0/dig_out[10]
+ housekeeping_top_0/proj_dig_ena slot9_wrapper_0/dig_out[11] housekeeping_top_0/dbus_out[10]
+ sub vdd1v2_uq2 project_control_area_1/user_project_control_0/dig_out[5] housekeeping_top_0/proj_ibias_ena[1]
+ housekeeping_top_0/dbus_out[23] slot9_wrapper_0/ibias1 project_control_area_1/user_project_control_0/dig_out[10]
+ slot9_wrapper_0/vdd_3v3 housekeeping_top_0/dbus_out[6] slot9_wrapper_0/ibias0 slot9_wrapper_0/dig_in[10]
+ sub housekeeping_top_0/proj_vbias_ena slot9_wrapper_0/dig_in[11] vdd3v3 slot9_wrapper_0/enable
+ sub sub slot9_wrapper_0/dig_in[12] slot9_wrapper_0/dig_in[13] housekeeping_top_0/proj_3v3_ena
+ sub slot9_wrapper_0/vbias slot9_wrapper_0/dig_in[14] housekeeping_top_0/analog_bus_ena[3]
+ housekeeping_top_0/proj_ibias_ena[0] sub slot9_wrapper_0/dig_in[15] housekeeping_top_0/dbus_out[20]
+ vdd1v2_uq2 housekeeping_top_0/dbus_out[19] slot9_wrapper_0/dig_in[16] sub housekeeping_top_0/proj_sel[4]
+ project_control_area_1/user_project_control_0/dig_out[6] sub housekeeping_top_0/reset
+ housekeeping_top_0/dbus_out[12] slot9_wrapper_0/dig_in[17] housekeeping_top_0/analog_bus_ena[0]
+ housekeeping_top_0/proj_1v2_ena slot9_wrapper_0/dig_in[18] housekeeping_top_0/proj_ena
+ slot9_wrapper_0/dig_in[19] vdd1v2_uq2 sub vdd3v3 housekeeping_top_0/dbus_out[14]
+ analog_switch_array_7[8]/analog_pswitch_small_1/enable sub housekeeping_top_0/dbus_out[16]
+ housekeeping_top_0/dbus_out[18] slot9_wrapper_0/dig_out[0] housekeeping_top_0/clk_out
+ slot9_wrapper_0/reset slot9_wrapper_0/dig_out[1] project_control_area_1/user_project_control_0/dig_out[2]
+ housekeeping_top_0/dbus_out[0] slot9_wrapper_0/dig_out[2] project_control_area_1/user_project_control_0/dig_out[7]
+ project_control_area_1/user_project_control_0/dig_out[0] slot9_wrapper_0/clk project_control_area_1/user_project_control_0/dig_out[1]
+ housekeeping_top_0/dbus_out[7] slot9_wrapper_0/dig_out[3] housekeeping_top_0/dbus_out[8]
+ housekeeping_top_0/dbus_out[11] sub slot9_wrapper_0/dig_out[4] housekeeping_top_0/dbus_out[3]
+ analog_switch_array_7[8]/analog_switch_small_0/enable housekeeping_top_0/proj_sel[3]
+ slot9_wrapper_0/dig_out[5] sub housekeeping_top_0/dbus_out[4] slot9_wrapper_0/dig_in[0]
+ housekeeping_top_0/dbus_out[15] sub analog_switch_array_7[8]/analog_switch_med_22/enable
+ housekeeping_top_0/dbus_out[13] slot9_wrapper_0/dig_out[6] sub slot9_wrapper_0/vdd_1v2
+ sub sub slot9_wrapper_0/dig_in[1] project_control_area
Xslot3_wrapper_0 sub s3_an[0] s3_an[1] s3_an_0_esd slot3_wrapper_0/vbias slot3_wrapper_0/dig_in[23]
+ slot3_wrapper_0/dig_in[22] slot3_wrapper_0/dig_in[21] slot3_wrapper_0/dig_in[20]
+ slot3_wrapper_0/dig_in[19] slot3_wrapper_0/dig_in[18] slot3_wrapper_0/dig_in[17]
+ slot3_wrapper_0/dig_in[16] slot3_wrapper_0/dig_in[15] slot3_wrapper_0/dig_in[14]
+ slot3_wrapper_0/dig_in[13] slot3_wrapper_0/dig_in[12] slot3_wrapper_0/dig_in[11]
+ slot3_wrapper_0/dig_in[10] slot3_wrapper_0/dig_in[9] slot3_wrapper_0/dig_in[8] slot3_wrapper_0/dig_in[7]
+ slot3_wrapper_0/dig_in[6] slot3_wrapper_0/dig_in[5] slot3_wrapper_0/dig_in[4] slot3_wrapper_0/dig_in[3]
+ slot3_wrapper_0/dig_in[2] slot3_wrapper_0/dig_in[1] slot3_wrapper_0/dig_in[0] slot3_wrapper_0/dig_out[11]
+ slot3_wrapper_0/dig_out[10] slot3_wrapper_0/dig_out[9] slot3_wrapper_0/dig_out[8]
+ slot3_wrapper_0/dig_out[7] slot3_wrapper_0/dig_out[6] slot3_wrapper_0/dig_out[5]
+ slot3_wrapper_0/dig_out[4] slot3_wrapper_0/dig_out[3] slot3_wrapper_0/dig_out[2]
+ slot3_wrapper_0/dig_out[1] slot3_wrapper_0/dig_out[0] slot3_wrapper_0/ibias0 slot3_wrapper_0/ibias1
+ slot3_wrapper_0/analog_bus3 slot3_wrapper_0/analog_bus2 slot3_wrapper_0/analog_bus1
+ slot3_wrapper_0/analog_bus0 sub slot3_wrapper_0/vdd_1v2 slot3_wrapper_0/vdd_3v3
+ slot3_wrapper_0/enable slot3_wrapper_0/clk slot3_wrapper_0/reset slot3_wrapper
Xsg13cmos5l_ocd_ip__por_0 vdd1v2_uq2 vdd1v2_uq2 sg13cmos5l_ocd_ip__por_0/por_unbuf
+ housekeeping_top_0/porb sg13cmos5l_ocd_ip__por_0/por sub sg13cmos5l_ocd_ip__por
Xproject_control_area_2 slot11_wrapper_0/dig_in[20] analog_switch_array_7[7]/analog_switch_med_1/enable
+ analog_switch_array_7[7]/analog_switch_med_0/enable slot11_wrapper_0/dig_out[7]
+ housekeeping_top_0/proj_sel[2] project_control_area_0/user_project_control_0/dig_out[0]
+ slot11_wrapper_0/dig_in[2] slot11_wrapper_0/dig_in[21] housekeeping_top_0/dbus_out[22]
+ slot11_wrapper_0/dig_out[8] housekeeping_top_0/proj_sel[1] slot11_wrapper_0/dig_in[3]
+ slot11_wrapper_0/dig_in[22] slot11_wrapper_0/dig_out[9] housekeeping_top_0/analog_bus_ena[2]
+ slot11_wrapper_0/analog_bus3 slot11_wrapper_0/dig_in[4] analog_switch_array_7[7]/analog_switch_med_2/enable
+ slot11_wrapper_0/dig_in[23] project_control_area_2/user_project_control_0/dig_out[3]
+ project_control_area_2/user_project_control_0/dig_out[11] project_control_area_2/user_project_control_0/dig_out[4]
+ slot11_wrapper_0/analog_bus2 slot11_wrapper_0/dig_in[5] housekeeping_top_0/analog_bus_ena[1]
+ slot11_wrapper_0/analog_bus1 housekeeping_top_0/dbus_out[5] slot11_wrapper_0/dig_in[6]
+ housekeeping_top_0/dbus_out[21] housekeeping_top_0/dbus_out[9] project_control_area_2/user_project_control_0/dig_out[8]
+ slot11_wrapper_0/analog_bus0 project_control_area_2/user_project_control_0/dig_out[9]
+ slot11_wrapper_0/dig_in[7] project_control_area_0/user_project_control_0/dig_out[11]
+ slot11_wrapper_0/dig_in[8] analog_switch_array_7[7]/analog_pswitch_small_3/enable
+ housekeeping_top_0/proj_sel[0] housekeeping_top_0/dbus_out[1] slot11_wrapper_0/dig_in[9]
+ housekeeping_top_0/dbus_out[17] housekeeping_top_0/dbus_out[2] vdd1v2_uq2 slot11_wrapper_0/dig_out[10]
+ housekeeping_top_0/proj_dig_ena slot11_wrapper_0/dig_out[11] housekeeping_top_0/dbus_out[10]
+ vdd1v2_uq2 vdd1v2_uq2 project_control_area_2/user_project_control_0/dig_out[5] housekeeping_top_0/proj_ibias_ena[1]
+ housekeeping_top_0/dbus_out[23] slot11_wrapper_0/ibias1 project_control_area_2/user_project_control_0/dig_out[10]
+ slot11_wrapper_0/vdd_3v3 housekeeping_top_0/dbus_out[6] slot11_wrapper_0/ibias0
+ slot11_wrapper_0/dig_in[10] project_control_area_0/user_project_control_0/dig_out[2]
+ housekeeping_top_0/proj_vbias_ena slot11_wrapper_0/dig_in[11] vdd3v3 slot11_wrapper_0/enable
+ project_control_area_0/user_project_control_0/dig_out[1] project_control_area_0/user_project_control_0/dig_out[3]
+ slot11_wrapper_0/dig_in[12] slot11_wrapper_0/dig_in[13] housekeeping_top_0/proj_3v3_ena
+ project_control_area_0/user_project_control_0/dig_out[4] slot11_wrapper_0/vbias
+ slot11_wrapper_0/dig_in[14] housekeeping_top_0/analog_bus_ena[3] housekeeping_top_0/proj_ibias_ena[0]
+ project_control_area_0/user_project_control_0/dig_out[5] slot11_wrapper_0/dig_in[15]
+ housekeeping_top_0/dbus_out[20] vdd1v2_uq2 housekeeping_top_0/dbus_out[19] slot11_wrapper_0/dig_in[16]
+ project_control_area_0/user_project_control_0/dig_out[6] housekeeping_top_0/proj_sel[4]
+ project_control_area_2/user_project_control_0/dig_out[6] sub housekeeping_top_0/reset
+ housekeeping_top_0/dbus_out[12] slot11_wrapper_0/dig_in[17] housekeeping_top_0/analog_bus_ena[0]
+ housekeeping_top_0/proj_1v2_ena slot11_wrapper_0/dig_in[18] housekeeping_top_0/proj_ena
+ slot11_wrapper_0/dig_in[19] vdd1v2_uq2 project_control_area_0/user_project_control_0/dig_out[9]
+ vdd3v3 housekeeping_top_0/dbus_out[14] analog_switch_array_7[7]/analog_pswitch_small_2/enable
+ project_control_area_0/user_project_control_0/dig_out[10] housekeeping_top_0/dbus_out[16]
+ housekeeping_top_0/dbus_out[18] slot11_wrapper_0/dig_out[0] housekeeping_top_0/clk_out
+ slot11_wrapper_0/reset slot11_wrapper_0/dig_out[1] project_control_area_2/user_project_control_0/dig_out[2]
+ housekeeping_top_0/dbus_out[0] slot11_wrapper_0/dig_out[2] project_control_area_2/user_project_control_0/dig_out[7]
+ project_control_area_2/user_project_control_0/dig_out[0] slot11_wrapper_0/clk project_control_area_2/user_project_control_0/dig_out[1]
+ housekeeping_top_0/dbus_out[7] slot11_wrapper_0/dig_out[3] housekeeping_top_0/dbus_out[8]
+ housekeeping_top_0/dbus_out[11] project_control_area_0/user_project_control_0/dig_out[7]
+ slot11_wrapper_0/dig_out[4] housekeeping_top_0/dbus_out[3] analog_switch_array_7[7]/analog_switch_small_1/enable
+ housekeeping_top_0/proj_sel[3] slot11_wrapper_0/dig_out[5] project_control_area_0/user_project_control_0/dig_out[8]
+ housekeeping_top_0/dbus_out[4] slot11_wrapper_0/dig_in[0] housekeeping_top_0/dbus_out[15]
+ sub analog_switch_array_7[7]/analog_switch_med_3/enable housekeeping_top_0/dbus_out[13]
+ slot11_wrapper_0/dig_out[6] sub slot11_wrapper_0/vdd_1v2 sub sub slot11_wrapper_0/dig_in[1]
+ project_control_area
Xproject_control_area_3 slot8_wrapper_0/dig_in[20] analog_switch_array_7[7]/analog_switch_med_18/enable
+ analog_switch_array_7[7]/analog_switch_med_17/enable slot8_wrapper_0/dig_out[7]
+ housekeeping_top_0/proj_sel[2] project_control_area_1/user_project_control_0/dig_out[0]
+ slot8_wrapper_0/dig_in[2] slot8_wrapper_0/dig_in[21] housekeeping_top_0/dbus_out[22]
+ slot8_wrapper_0/dig_out[8] housekeeping_top_0/proj_sel[1] slot8_wrapper_0/dig_in[3]
+ slot8_wrapper_0/dig_in[22] slot8_wrapper_0/dig_out[9] housekeeping_top_0/analog_bus_ena[2]
+ slot8_wrapper_0/analog_bus3 slot8_wrapper_0/dig_in[4] analog_switch_array_7[7]/analog_switch_med_20/enable
+ slot8_wrapper_0/dig_in[23] project_control_area_3/user_project_control_0/dig_out[3]
+ project_control_area_3/user_project_control_0/dig_out[11] project_control_area_3/user_project_control_0/dig_out[4]
+ slot8_wrapper_0/analog_bus2 slot8_wrapper_0/dig_in[5] housekeeping_top_0/analog_bus_ena[1]
+ slot8_wrapper_0/analog_bus1 housekeeping_top_0/dbus_out[5] slot8_wrapper_0/dig_in[6]
+ housekeeping_top_0/dbus_out[21] housekeeping_top_0/dbus_out[9] project_control_area_3/user_project_control_0/dig_out[8]
+ slot8_wrapper_0/analog_bus0 project_control_area_3/user_project_control_0/dig_out[9]
+ slot8_wrapper_0/dig_in[7] project_control_area_1/user_project_control_0/dig_out[11]
+ slot8_wrapper_0/dig_in[8] analog_switch_array_7[7]/analog_pswitch_small_0/enable
+ housekeeping_top_0/proj_sel[0] housekeeping_top_0/dbus_out[1] slot8_wrapper_0/dig_in[9]
+ housekeeping_top_0/dbus_out[17] housekeeping_top_0/dbus_out[2] sub slot8_wrapper_0/dig_out[10]
+ housekeeping_top_0/proj_dig_ena slot8_wrapper_0/dig_out[11] housekeeping_top_0/dbus_out[10]
+ sub vdd1v2_uq2 project_control_area_3/user_project_control_0/dig_out[5] housekeeping_top_0/proj_ibias_ena[1]
+ housekeeping_top_0/dbus_out[23] slot8_wrapper_0/ibias1 project_control_area_3/user_project_control_0/dig_out[10]
+ slot8_wrapper_0/vdd_3v3 housekeeping_top_0/dbus_out[6] slot8_wrapper_0/ibias0 slot8_wrapper_0/dig_in[10]
+ project_control_area_1/user_project_control_0/dig_out[2] housekeeping_top_0/proj_vbias_ena
+ slot8_wrapper_0/dig_in[11] vdd3v3 slot8_wrapper_0/enable project_control_area_1/user_project_control_0/dig_out[1]
+ project_control_area_1/user_project_control_0/dig_out[3] slot8_wrapper_0/dig_in[12]
+ slot8_wrapper_0/dig_in[13] housekeeping_top_0/proj_3v3_ena project_control_area_1/user_project_control_0/dig_out[4]
+ slot8_wrapper_0/vbias slot8_wrapper_0/dig_in[14] housekeeping_top_0/analog_bus_ena[3]
+ housekeeping_top_0/proj_ibias_ena[0] project_control_area_1/user_project_control_0/dig_out[5]
+ slot8_wrapper_0/dig_in[15] housekeeping_top_0/dbus_out[20] vdd1v2_uq2 housekeeping_top_0/dbus_out[19]
+ slot8_wrapper_0/dig_in[16] project_control_area_1/user_project_control_0/dig_out[6]
+ housekeeping_top_0/proj_sel[4] project_control_area_3/user_project_control_0/dig_out[6]
+ sub housekeeping_top_0/reset housekeeping_top_0/dbus_out[12] slot8_wrapper_0/dig_in[17]
+ housekeeping_top_0/analog_bus_ena[0] housekeeping_top_0/proj_1v2_ena slot8_wrapper_0/dig_in[18]
+ housekeeping_top_0/proj_ena slot8_wrapper_0/dig_in[19] vdd1v2_uq2 project_control_area_1/user_project_control_0/dig_out[9]
+ vdd3v3 housekeeping_top_0/dbus_out[14] analog_switch_array_7[7]/analog_pswitch_small_1/enable
+ project_control_area_1/user_project_control_0/dig_out[10] housekeeping_top_0/dbus_out[16]
+ housekeeping_top_0/dbus_out[18] slot8_wrapper_0/dig_out[0] housekeeping_top_0/clk_out
+ slot8_wrapper_0/reset slot8_wrapper_0/dig_out[1] project_control_area_3/user_project_control_0/dig_out[2]
+ housekeeping_top_0/dbus_out[0] slot8_wrapper_0/dig_out[2] project_control_area_3/user_project_control_0/dig_out[7]
+ project_control_area_3/user_project_control_0/dig_out[0] slot8_wrapper_0/clk project_control_area_3/user_project_control_0/dig_out[1]
+ housekeeping_top_0/dbus_out[7] slot8_wrapper_0/dig_out[3] housekeeping_top_0/dbus_out[8]
+ housekeeping_top_0/dbus_out[11] project_control_area_1/user_project_control_0/dig_out[7]
+ slot8_wrapper_0/dig_out[4] housekeeping_top_0/dbus_out[3] analog_switch_array_7[7]/analog_switch_small_0/enable
+ housekeeping_top_0/proj_sel[3] slot8_wrapper_0/dig_out[5] project_control_area_1/user_project_control_0/dig_out[8]
+ housekeeping_top_0/dbus_out[4] slot8_wrapper_0/dig_in[0] housekeeping_top_0/dbus_out[15]
+ sub analog_switch_array_7[7]/analog_switch_med_22/enable housekeeping_top_0/dbus_out[13]
+ slot8_wrapper_0/dig_out[6] sub slot8_wrapper_0/vdd_1v2 sub sub slot8_wrapper_0/dig_in[1]
+ project_control_area
Xslot7_wrapper_0 sub slot7_wrapper_0/s7_an_0_vref slot7_wrapper_0/s7_an_0_outp slot7_wrapper_0/s7_an_0_outn
+ slot7_wrapper_0/s7_an_0_vcm slot7_wrapper_0/s7_an_0_en_3v3 slot7_wrapper_0/s7_an_0_en_3v3_b
+ slot7_wrapper_0/s7_an_0_iref slot7_wrapper_0/s7_an_1_vinp slot7_wrapper_0/s7_an_1_vinn
+ slot7_wrapper_0/s7_an_1_vref slot7_wrapper_0/s7_an_1_iref slot7_wrapper_0/s7_an_1_en_3v3_b
+ slot7_wrapper_0/s7_an_1_en_3v3 slot7_wrapper_0/vbias slot7_wrapper_0/dig_in[23]
+ slot7_wrapper_0/dig_in[22] slot7_wrapper_0/dig_in[21] slot7_wrapper_0/dig_in[20]
+ slot7_wrapper_0/dig_in[19] slot7_wrapper_0/dig_in[18] slot7_wrapper_0/dig_in[17]
+ slot7_wrapper_0/dig_in[16] slot7_wrapper_0/dig_in[15] slot7_wrapper_0/dig_in[14]
+ slot7_wrapper_0/dig_in[13] slot7_wrapper_0/dig_in[12] slot7_wrapper_0/dig_in[11]
+ slot7_wrapper_0/dig_in[10] slot7_wrapper_0/dig_in[9] slot7_wrapper_0/dig_in[8] slot7_wrapper_0/dig_in[7]
+ slot7_wrapper_0/dig_in[6] slot7_wrapper_0/dig_in[5] slot7_wrapper_0/dig_in[4] slot7_wrapper_0/dig_in[3]
+ slot7_wrapper_0/dig_in[2] slot7_wrapper_0/dig_in[1] slot7_wrapper_0/dig_in[0] slot7_wrapper_0/dig_out[11]
+ slot7_wrapper_0/dig_out[10] slot7_wrapper_0/dig_out[9] slot7_wrapper_0/dig_out[8]
+ slot7_wrapper_0/dig_out[7] slot7_wrapper_0/dig_out[6] slot7_wrapper_0/dig_out[5]
+ slot7_wrapper_0/dig_out[4] slot7_wrapper_0/dig_out[3] slot7_wrapper_0/dig_out[2]
+ slot7_wrapper_0/dig_out[1] slot7_wrapper_0/dig_out[0] slot7_wrapper_0/ibias0 slot7_wrapper_0/ibias1
+ slot7_wrapper_0/analog_bus3 slot7_wrapper_0/analog_bus2 slot7_wrapper_0/analog_bus1
+ slot7_wrapper_0/analog_bus0 slot7_wrapper_0/vdd_1v2 sub slot7_wrapper_0/vdd_3v3
+ slot7_wrapper_0/enable slot7_wrapper_0/clk slot7_wrapper_0/reset slot7_wrapper
Xproject_control_area_4 slot12_wrapper_0/dig_in[20] analog_switch_array_7[6]/analog_switch_med_1/enable
+ analog_switch_array_7[6]/analog_switch_med_0/enable slot12_wrapper_0/dig_out[7]
+ housekeeping_top_0/proj_sel[2] project_control_area_2/user_project_control_0/dig_out[0]
+ slot12_wrapper_0/dig_in[2] slot12_wrapper_0/dig_in[21] housekeeping_top_0/dbus_out[22]
+ slot12_wrapper_0/dig_out[8] housekeeping_top_0/proj_sel[1] slot12_wrapper_0/dig_in[3]
+ slot12_wrapper_0/dig_in[22] slot12_wrapper_0/dig_out[9] housekeeping_top_0/analog_bus_ena[2]
+ slot12_wrapper_0/analog_bus3 slot12_wrapper_0/dig_in[4] analog_switch_array_7[6]/analog_switch_med_2/enable
+ slot12_wrapper_0/dig_in[23] project_control_area_4/user_project_control_0/dig_out[3]
+ project_control_area_4/user_project_control_0/dig_out[11] project_control_area_4/user_project_control_0/dig_out[4]
+ slot12_wrapper_0/analog_bus2 slot12_wrapper_0/dig_in[5] housekeeping_top_0/analog_bus_ena[1]
+ slot12_wrapper_0/analog_bus1 housekeeping_top_0/dbus_out[5] slot12_wrapper_0/dig_in[6]
+ housekeeping_top_0/dbus_out[21] housekeeping_top_0/dbus_out[9] project_control_area_4/user_project_control_0/dig_out[8]
+ slot12_wrapper_0/analog_bus0 project_control_area_4/user_project_control_0/dig_out[9]
+ slot12_wrapper_0/dig_in[7] project_control_area_2/user_project_control_0/dig_out[11]
+ slot12_wrapper_0/dig_in[8] analog_switch_array_7[6]/analog_pswitch_small_3/enable
+ housekeeping_top_0/proj_sel[0] housekeeping_top_0/dbus_out[1] slot12_wrapper_0/dig_in[9]
+ housekeeping_top_0/dbus_out[17] housekeeping_top_0/dbus_out[2] sub slot12_wrapper_0/dig_out[10]
+ housekeeping_top_0/proj_dig_ena slot12_wrapper_0/dig_out[11] housekeeping_top_0/dbus_out[10]
+ sub vdd1v2_uq2 project_control_area_4/user_project_control_0/dig_out[5] housekeeping_top_0/proj_ibias_ena[1]
+ housekeeping_top_0/dbus_out[23] slot12_wrapper_0/ibias1 project_control_area_4/user_project_control_0/dig_out[10]
+ slot12_wrapper_0/vdd_3v3 housekeeping_top_0/dbus_out[6] slot12_wrapper_0/ibias0
+ slot12_wrapper_0/dig_in[10] project_control_area_2/user_project_control_0/dig_out[2]
+ housekeeping_top_0/proj_vbias_ena slot12_wrapper_0/dig_in[11] vdd3v3 slot12_wrapper_0/enable
+ project_control_area_2/user_project_control_0/dig_out[1] project_control_area_2/user_project_control_0/dig_out[3]
+ slot12_wrapper_0/dig_in[12] slot12_wrapper_0/dig_in[13] housekeeping_top_0/proj_3v3_ena
+ project_control_area_2/user_project_control_0/dig_out[4] slot12_wrapper_0/vbias
+ slot12_wrapper_0/dig_in[14] housekeeping_top_0/analog_bus_ena[3] housekeeping_top_0/proj_ibias_ena[0]
+ project_control_area_2/user_project_control_0/dig_out[5] slot12_wrapper_0/dig_in[15]
+ housekeeping_top_0/dbus_out[20] vdd1v2_uq2 housekeeping_top_0/dbus_out[19] slot12_wrapper_0/dig_in[16]
+ project_control_area_2/user_project_control_0/dig_out[6] housekeeping_top_0/proj_sel[4]
+ project_control_area_4/user_project_control_0/dig_out[6] sub housekeeping_top_0/reset
+ housekeeping_top_0/dbus_out[12] slot12_wrapper_0/dig_in[17] housekeeping_top_0/analog_bus_ena[0]
+ housekeeping_top_0/proj_1v2_ena slot12_wrapper_0/dig_in[18] housekeeping_top_0/proj_ena
+ slot12_wrapper_0/dig_in[19] vdd1v2_uq2 project_control_area_2/user_project_control_0/dig_out[9]
+ vdd3v3 housekeeping_top_0/dbus_out[14] analog_switch_array_7[6]/analog_pswitch_small_2/enable
+ project_control_area_2/user_project_control_0/dig_out[10] housekeeping_top_0/dbus_out[16]
+ housekeeping_top_0/dbus_out[18] slot12_wrapper_0/dig_out[0] housekeeping_top_0/clk_out
+ slot12_wrapper_0/reset slot12_wrapper_0/dig_out[1] project_control_area_4/user_project_control_0/dig_out[2]
+ housekeeping_top_0/dbus_out[0] slot12_wrapper_0/dig_out[2] project_control_area_4/user_project_control_0/dig_out[7]
+ project_control_area_4/user_project_control_0/dig_out[0] slot12_wrapper_0/clk project_control_area_4/user_project_control_0/dig_out[1]
+ housekeeping_top_0/dbus_out[7] slot12_wrapper_0/dig_out[3] housekeeping_top_0/dbus_out[8]
+ housekeeping_top_0/dbus_out[11] project_control_area_2/user_project_control_0/dig_out[7]
+ slot12_wrapper_0/dig_out[4] housekeeping_top_0/dbus_out[3] analog_switch_array_7[6]/analog_switch_small_1/enable
+ housekeeping_top_0/proj_sel[3] slot12_wrapper_0/dig_out[5] project_control_area_2/user_project_control_0/dig_out[8]
+ housekeeping_top_0/dbus_out[4] slot12_wrapper_0/dig_in[0] housekeeping_top_0/dbus_out[15]
+ sub analog_switch_array_7[6]/analog_switch_med_3/enable housekeeping_top_0/dbus_out[13]
+ slot12_wrapper_0/dig_out[6] sub slot12_wrapper_0/vdd_1v2 vdd1v2_uq2 sub slot12_wrapper_0/dig_in[1]
+ project_control_area
Xproject_control_area_5 slot7_wrapper_0/dig_in[20] analog_switch_array_7[6]/analog_switch_med_18/enable
+ analog_switch_array_7[6]/analog_switch_med_17/enable slot7_wrapper_0/dig_out[7]
+ housekeeping_top_0/proj_sel[2] project_control_area_3/user_project_control_0/dig_out[0]
+ slot7_wrapper_0/dig_in[2] slot7_wrapper_0/dig_in[21] housekeeping_top_0/dbus_out[22]
+ slot7_wrapper_0/dig_out[8] housekeeping_top_0/proj_sel[1] slot7_wrapper_0/dig_in[3]
+ slot7_wrapper_0/dig_in[22] slot7_wrapper_0/dig_out[9] housekeeping_top_0/analog_bus_ena[2]
+ slot7_wrapper_0/analog_bus3 slot7_wrapper_0/dig_in[4] analog_switch_array_7[6]/analog_switch_med_20/enable
+ slot7_wrapper_0/dig_in[23] project_control_area_5/user_project_control_0/dig_out[3]
+ project_control_area_5/user_project_control_0/dig_out[11] project_control_area_5/user_project_control_0/dig_out[4]
+ slot7_wrapper_0/analog_bus2 slot7_wrapper_0/dig_in[5] housekeeping_top_0/analog_bus_ena[1]
+ slot7_wrapper_0/analog_bus1 housekeeping_top_0/dbus_out[5] slot7_wrapper_0/dig_in[6]
+ housekeeping_top_0/dbus_out[21] housekeeping_top_0/dbus_out[9] project_control_area_5/user_project_control_0/dig_out[8]
+ slot7_wrapper_0/analog_bus0 project_control_area_5/user_project_control_0/dig_out[9]
+ slot7_wrapper_0/dig_in[7] project_control_area_3/user_project_control_0/dig_out[11]
+ slot7_wrapper_0/dig_in[8] analog_switch_array_7[6]/analog_pswitch_small_0/enable
+ housekeeping_top_0/proj_sel[0] housekeeping_top_0/dbus_out[1] slot7_wrapper_0/dig_in[9]
+ housekeeping_top_0/dbus_out[17] housekeeping_top_0/dbus_out[2] vdd1v2_uq2 slot7_wrapper_0/dig_out[10]
+ housekeeping_top_0/proj_dig_ena slot7_wrapper_0/dig_out[11] housekeeping_top_0/dbus_out[10]
+ vdd1v2_uq2 sub project_control_area_5/user_project_control_0/dig_out[5] housekeeping_top_0/proj_ibias_ena[1]
+ housekeeping_top_0/dbus_out[23] slot7_wrapper_0/ibias1 project_control_area_5/user_project_control_0/dig_out[10]
+ slot7_wrapper_0/vdd_3v3 housekeeping_top_0/dbus_out[6] slot7_wrapper_0/ibias0 slot7_wrapper_0/dig_in[10]
+ project_control_area_3/user_project_control_0/dig_out[2] housekeeping_top_0/proj_vbias_ena
+ slot7_wrapper_0/dig_in[11] vdd3v3 slot7_wrapper_0/enable project_control_area_3/user_project_control_0/dig_out[1]
+ project_control_area_3/user_project_control_0/dig_out[3] slot7_wrapper_0/dig_in[12]
+ slot7_wrapper_0/dig_in[13] housekeeping_top_0/proj_3v3_ena project_control_area_3/user_project_control_0/dig_out[4]
+ slot7_wrapper_0/vbias slot7_wrapper_0/dig_in[14] housekeeping_top_0/analog_bus_ena[3]
+ housekeeping_top_0/proj_ibias_ena[0] project_control_area_3/user_project_control_0/dig_out[5]
+ slot7_wrapper_0/dig_in[15] housekeeping_top_0/dbus_out[20] vdd1v2_uq2 housekeeping_top_0/dbus_out[19]
+ slot7_wrapper_0/dig_in[16] project_control_area_3/user_project_control_0/dig_out[6]
+ housekeeping_top_0/proj_sel[4] project_control_area_5/user_project_control_0/dig_out[6]
+ sub housekeeping_top_0/reset housekeeping_top_0/dbus_out[12] slot7_wrapper_0/dig_in[17]
+ housekeeping_top_0/analog_bus_ena[0] housekeeping_top_0/proj_1v2_ena slot7_wrapper_0/dig_in[18]
+ housekeeping_top_0/proj_ena slot7_wrapper_0/dig_in[19] vdd1v2_uq2 project_control_area_3/user_project_control_0/dig_out[9]
+ vdd3v3 housekeeping_top_0/dbus_out[14] analog_switch_array_7[6]/analog_pswitch_small_1/enable
+ project_control_area_3/user_project_control_0/dig_out[10] housekeeping_top_0/dbus_out[16]
+ housekeeping_top_0/dbus_out[18] slot7_wrapper_0/dig_out[0] housekeeping_top_0/clk_out
+ slot7_wrapper_0/reset slot7_wrapper_0/dig_out[1] project_control_area_5/user_project_control_0/dig_out[2]
+ housekeeping_top_0/dbus_out[0] slot7_wrapper_0/dig_out[2] project_control_area_5/user_project_control_0/dig_out[7]
+ project_control_area_5/user_project_control_0/dig_out[0] slot7_wrapper_0/clk project_control_area_5/user_project_control_0/dig_out[1]
+ housekeeping_top_0/dbus_out[7] slot7_wrapper_0/dig_out[3] housekeeping_top_0/dbus_out[8]
+ housekeeping_top_0/dbus_out[11] project_control_area_3/user_project_control_0/dig_out[7]
+ slot7_wrapper_0/dig_out[4] housekeeping_top_0/dbus_out[3] analog_switch_array_7[6]/analog_switch_small_0/enable
+ housekeeping_top_0/proj_sel[3] slot7_wrapper_0/dig_out[5] project_control_area_3/user_project_control_0/dig_out[8]
+ housekeeping_top_0/dbus_out[4] slot7_wrapper_0/dig_in[0] housekeeping_top_0/dbus_out[15]
+ sub analog_switch_array_7[6]/analog_switch_med_22/enable housekeeping_top_0/dbus_out[13]
+ slot7_wrapper_0/dig_out[6] sub slot7_wrapper_0/vdd_1v2 vdd1v2_uq2 sub slot7_wrapper_0/dig_in[1]
+ project_control_area
Xslot11_wrapper_0 sub s11_an[0] s11_an_0_esd slot11_wrapper_0/vbias slot11_wrapper_0/dig_in[23]
+ slot11_wrapper_0/dig_in[22] slot11_wrapper_0/dig_in[21] slot11_wrapper_0/dig_in[20]
+ slot11_wrapper_0/dig_in[19] slot11_wrapper_0/dig_in[18] slot11_wrapper_0/dig_in[17]
+ slot11_wrapper_0/dig_in[16] slot11_wrapper_0/dig_in[15] slot11_wrapper_0/dig_in[14]
+ slot11_wrapper_0/dig_in[13] slot11_wrapper_0/dig_in[12] slot11_wrapper_0/dig_in[11]
+ slot11_wrapper_0/dig_in[10] slot11_wrapper_0/dig_in[9] slot11_wrapper_0/dig_in[8]
+ slot11_wrapper_0/dig_in[7] slot11_wrapper_0/dig_in[6] slot11_wrapper_0/dig_in[5]
+ slot11_wrapper_0/dig_in[4] slot11_wrapper_0/dig_in[3] slot11_wrapper_0/dig_in[2]
+ slot11_wrapper_0/dig_in[1] slot11_wrapper_0/dig_in[0] slot11_wrapper_0/dig_out[11]
+ slot11_wrapper_0/dig_out[10] slot11_wrapper_0/dig_out[9] slot11_wrapper_0/dig_out[8]
+ slot11_wrapper_0/dig_out[7] slot11_wrapper_0/dig_out[6] slot11_wrapper_0/dig_out[5]
+ slot11_wrapper_0/dig_out[4] slot11_wrapper_0/dig_out[3] slot11_wrapper_0/dig_out[2]
+ slot11_wrapper_0/dig_out[1] slot11_wrapper_0/dig_out[0] slot11_wrapper_0/ibias0
+ slot11_wrapper_0/ibias1 slot11_wrapper_0/analog_bus3 slot11_wrapper_0/analog_bus2
+ slot11_wrapper_0/analog_bus1 slot11_wrapper_0/analog_bus0 slot11_wrapper_0/vdd_1v2
+ sub slot11_wrapper_0/vdd_3v3 slot11_wrapper_0/enable slot11_wrapper_0/clk slot11_wrapper_0/reset
+ slot11_wrapper
Xproject_control_area_6 slot13_wrapper_0/dig_in[20] analog_switch_array_7[5]/analog_switch_med_1/enable
+ analog_switch_array_7[5]/analog_switch_med_0/enable slot13_wrapper_0/dig_out[7]
+ housekeeping_top_0/proj_sel[2] project_control_area_4/user_project_control_0/dig_out[0]
+ slot13_wrapper_0/dig_in[2] slot13_wrapper_0/dig_in[21] housekeeping_top_0/dbus_out[22]
+ slot13_wrapper_0/dig_out[8] housekeeping_top_0/proj_sel[1] slot13_wrapper_0/dig_in[3]
+ slot13_wrapper_0/dig_in[22] slot13_wrapper_0/dig_out[9] housekeeping_top_0/analog_bus_ena[2]
+ slot13_wrapper_0/analog_bus3 slot13_wrapper_0/dig_in[4] analog_switch_array_7[5]/analog_switch_med_2/enable
+ slot13_wrapper_0/dig_in[23] project_control_area_6/user_project_control_0/dig_out[3]
+ project_control_area_6/user_project_control_0/dig_out[11] project_control_area_6/user_project_control_0/dig_out[4]
+ slot13_wrapper_0/analog_bus2 slot13_wrapper_0/dig_in[5] housekeeping_top_0/analog_bus_ena[1]
+ slot13_wrapper_0/analog_bus1 housekeeping_top_0/dbus_out[5] slot13_wrapper_0/dig_in[6]
+ housekeeping_top_0/dbus_out[21] housekeeping_top_0/dbus_out[9] project_control_area_6/user_project_control_0/dig_out[8]
+ slot13_wrapper_0/analog_bus0 project_control_area_6/user_project_control_0/dig_out[9]
+ slot13_wrapper_0/dig_in[7] project_control_area_4/user_project_control_0/dig_out[11]
+ slot13_wrapper_0/dig_in[8] analog_switch_array_7[5]/analog_pswitch_small_3/enable
+ housekeeping_top_0/proj_sel[0] housekeeping_top_0/dbus_out[1] slot13_wrapper_0/dig_in[9]
+ housekeeping_top_0/dbus_out[17] housekeeping_top_0/dbus_out[2] vdd1v2_uq2 slot13_wrapper_0/dig_out[10]
+ housekeeping_top_0/proj_dig_ena slot13_wrapper_0/dig_out[11] housekeeping_top_0/dbus_out[10]
+ sub vdd1v2_uq2 project_control_area_6/user_project_control_0/dig_out[5] housekeeping_top_0/proj_ibias_ena[1]
+ housekeeping_top_0/dbus_out[23] slot13_wrapper_0/ibias1 project_control_area_6/user_project_control_0/dig_out[10]
+ slot13_wrapper_0/vdd_3v3 housekeeping_top_0/dbus_out[6] slot13_wrapper_0/ibias0
+ slot13_wrapper_0/dig_in[10] project_control_area_4/user_project_control_0/dig_out[2]
+ housekeeping_top_0/proj_vbias_ena slot13_wrapper_0/dig_in[11] vdd3v3 slot13_wrapper_0/enable
+ project_control_area_4/user_project_control_0/dig_out[1] project_control_area_4/user_project_control_0/dig_out[3]
+ slot13_wrapper_0/dig_in[12] slot13_wrapper_0/dig_in[13] housekeeping_top_0/proj_3v3_ena
+ project_control_area_4/user_project_control_0/dig_out[4] slot13_wrapper_0/vbias
+ slot13_wrapper_0/dig_in[14] housekeeping_top_0/analog_bus_ena[3] housekeeping_top_0/proj_ibias_ena[0]
+ project_control_area_4/user_project_control_0/dig_out[5] slot13_wrapper_0/dig_in[15]
+ housekeeping_top_0/dbus_out[20] vdd1v2_uq2 housekeeping_top_0/dbus_out[19] slot13_wrapper_0/dig_in[16]
+ project_control_area_4/user_project_control_0/dig_out[6] housekeeping_top_0/proj_sel[4]
+ project_control_area_6/user_project_control_0/dig_out[6] sub housekeeping_top_0/reset
+ housekeeping_top_0/dbus_out[12] slot13_wrapper_0/dig_in[17] housekeeping_top_0/analog_bus_ena[0]
+ housekeeping_top_0/proj_1v2_ena slot13_wrapper_0/dig_in[18] housekeeping_top_0/proj_ena
+ slot13_wrapper_0/dig_in[19] vdd1v2_uq2 project_control_area_4/user_project_control_0/dig_out[9]
+ vdd3v3 housekeeping_top_0/dbus_out[14] analog_switch_array_7[5]/analog_pswitch_small_2/enable
+ project_control_area_4/user_project_control_0/dig_out[10] housekeeping_top_0/dbus_out[16]
+ housekeeping_top_0/dbus_out[18] slot13_wrapper_0/dig_out[0] housekeeping_top_0/clk_out
+ slot13_wrapper_0/reset slot13_wrapper_0/dig_out[1] project_control_area_6/user_project_control_0/dig_out[2]
+ housekeeping_top_0/dbus_out[0] slot13_wrapper_0/dig_out[2] project_control_area_6/user_project_control_0/dig_out[7]
+ project_control_area_6/user_project_control_0/dig_out[0] slot13_wrapper_0/clk project_control_area_6/user_project_control_0/dig_out[1]
+ housekeeping_top_0/dbus_out[7] slot13_wrapper_0/dig_out[3] housekeeping_top_0/dbus_out[8]
+ housekeeping_top_0/dbus_out[11] project_control_area_4/user_project_control_0/dig_out[7]
+ slot13_wrapper_0/dig_out[4] housekeeping_top_0/dbus_out[3] analog_switch_array_7[5]/analog_switch_small_1/enable
+ housekeeping_top_0/proj_sel[3] slot13_wrapper_0/dig_out[5] project_control_area_4/user_project_control_0/dig_out[8]
+ housekeeping_top_0/dbus_out[4] slot13_wrapper_0/dig_in[0] housekeeping_top_0/dbus_out[15]
+ sub analog_switch_array_7[5]/analog_switch_med_3/enable housekeeping_top_0/dbus_out[13]
+ slot13_wrapper_0/dig_out[6] sub slot13_wrapper_0/vdd_1v2 vdd1v2_uq2 sub slot13_wrapper_0/dig_in[1]
+ project_control_area
Xproject_control_area_7 slot6_wrapper_0/dig_in[20] analog_switch_array_7[5]/analog_switch_med_18/enable
+ analog_switch_array_7[5]/analog_switch_med_17/enable slot6_wrapper_0/dig_out[7]
+ housekeeping_top_0/proj_sel[2] project_control_area_5/user_project_control_0/dig_out[0]
+ slot6_wrapper_0/dig_in[2] slot6_wrapper_0/dig_in[21] housekeeping_top_0/dbus_out[22]
+ slot6_wrapper_0/dig_out[8] housekeeping_top_0/proj_sel[1] slot6_wrapper_0/dig_in[3]
+ slot6_wrapper_0/dig_in[22] slot6_wrapper_0/dig_out[9] housekeeping_top_0/analog_bus_ena[2]
+ slot6_wrapper_0/analog_bus3 slot6_wrapper_0/dig_in[4] analog_switch_array_7[5]/analog_switch_med_20/enable
+ slot6_wrapper_0/dig_in[23] project_control_area_7/user_project_control_0/dig_out[3]
+ project_control_area_7/user_project_control_0/dig_out[11] project_control_area_7/user_project_control_0/dig_out[4]
+ slot6_wrapper_0/analog_bus2 slot6_wrapper_0/dig_in[5] housekeeping_top_0/analog_bus_ena[1]
+ slot6_wrapper_0/analog_bus1 housekeeping_top_0/dbus_out[5] slot6_wrapper_0/dig_in[6]
+ housekeeping_top_0/dbus_out[21] housekeeping_top_0/dbus_out[9] project_control_area_7/user_project_control_0/dig_out[8]
+ slot6_wrapper_0/analog_bus0 project_control_area_7/user_project_control_0/dig_out[9]
+ slot6_wrapper_0/dig_in[7] project_control_area_5/user_project_control_0/dig_out[11]
+ slot6_wrapper_0/dig_in[8] analog_switch_array_7[5]/analog_pswitch_small_0/enable
+ housekeeping_top_0/proj_sel[0] housekeeping_top_0/dbus_out[1] slot6_wrapper_0/dig_in[9]
+ housekeeping_top_0/dbus_out[17] housekeeping_top_0/dbus_out[2] sub slot6_wrapper_0/dig_out[10]
+ housekeeping_top_0/proj_dig_ena slot6_wrapper_0/dig_out[11] housekeeping_top_0/dbus_out[10]
+ vdd1v2_uq2 sub project_control_area_7/user_project_control_0/dig_out[5] housekeeping_top_0/proj_ibias_ena[1]
+ housekeeping_top_0/dbus_out[23] slot6_wrapper_0/ibias1 project_control_area_7/user_project_control_0/dig_out[10]
+ slot6_wrapper_0/vdd_3v3 housekeeping_top_0/dbus_out[6] slot6_wrapper_0/ibias0 slot6_wrapper_0/dig_in[10]
+ project_control_area_5/user_project_control_0/dig_out[2] housekeeping_top_0/proj_vbias_ena
+ slot6_wrapper_0/dig_in[11] vdd3v3 slot6_wrapper_0/enable project_control_area_5/user_project_control_0/dig_out[1]
+ project_control_area_5/user_project_control_0/dig_out[3] slot6_wrapper_0/dig_in[12]
+ slot6_wrapper_0/dig_in[13] housekeeping_top_0/proj_3v3_ena project_control_area_5/user_project_control_0/dig_out[4]
+ slot6_wrapper_0/vbias slot6_wrapper_0/dig_in[14] housekeeping_top_0/analog_bus_ena[3]
+ housekeeping_top_0/proj_ibias_ena[0] project_control_area_5/user_project_control_0/dig_out[5]
+ slot6_wrapper_0/dig_in[15] housekeeping_top_0/dbus_out[20] vdd1v2_uq2 housekeeping_top_0/dbus_out[19]
+ slot6_wrapper_0/dig_in[16] project_control_area_5/user_project_control_0/dig_out[6]
+ housekeeping_top_0/proj_sel[4] project_control_area_7/user_project_control_0/dig_out[6]
+ sub housekeeping_top_0/reset housekeeping_top_0/dbus_out[12] slot6_wrapper_0/dig_in[17]
+ housekeeping_top_0/analog_bus_ena[0] housekeeping_top_0/proj_1v2_ena slot6_wrapper_0/dig_in[18]
+ housekeeping_top_0/proj_ena slot6_wrapper_0/dig_in[19] vdd1v2_uq2 project_control_area_5/user_project_control_0/dig_out[9]
+ vdd3v3 housekeeping_top_0/dbus_out[14] analog_switch_array_7[5]/analog_pswitch_small_1/enable
+ project_control_area_5/user_project_control_0/dig_out[10] housekeeping_top_0/dbus_out[16]
+ housekeeping_top_0/dbus_out[18] slot6_wrapper_0/dig_out[0] housekeeping_top_0/clk_out
+ slot6_wrapper_0/reset slot6_wrapper_0/dig_out[1] project_control_area_7/user_project_control_0/dig_out[2]
+ housekeeping_top_0/dbus_out[0] slot6_wrapper_0/dig_out[2] project_control_area_7/user_project_control_0/dig_out[7]
+ project_control_area_7/user_project_control_0/dig_out[0] slot6_wrapper_0/clk project_control_area_7/user_project_control_0/dig_out[1]
+ housekeeping_top_0/dbus_out[7] slot6_wrapper_0/dig_out[3] housekeeping_top_0/dbus_out[8]
+ housekeeping_top_0/dbus_out[11] project_control_area_5/user_project_control_0/dig_out[7]
+ slot6_wrapper_0/dig_out[4] housekeeping_top_0/dbus_out[3] analog_switch_array_7[5]/analog_switch_small_0/enable
+ housekeeping_top_0/proj_sel[3] slot6_wrapper_0/dig_out[5] project_control_area_5/user_project_control_0/dig_out[8]
+ housekeeping_top_0/dbus_out[4] slot6_wrapper_0/dig_in[0] housekeeping_top_0/dbus_out[15]
+ sub analog_switch_array_7[5]/analog_switch_med_22/enable housekeeping_top_0/dbus_out[13]
+ slot6_wrapper_0/dig_out[6] sub slot6_wrapper_0/vdd_1v2 vdd1v2_uq2 sub slot6_wrapper_0/dig_in[1]
+ project_control_area
Xslot15_wrapper_0 sub s15_an[0] s15_an_0_esd slot15_wrapper_0/vbias slot15_wrapper_0/dig_in[23]
+ slot15_wrapper_0/dig_in[22] slot15_wrapper_0/dig_in[21] slot15_wrapper_0/dig_in[20]
+ slot15_wrapper_0/dig_in[19] slot15_wrapper_0/dig_in[18] slot15_wrapper_0/dig_in[17]
+ slot15_wrapper_0/dig_in[16] slot15_wrapper_0/dig_in[15] slot15_wrapper_0/dig_in[14]
+ slot15_wrapper_0/dig_in[13] slot15_wrapper_0/dig_in[12] slot15_wrapper_0/dig_in[11]
+ slot15_wrapper_0/dig_in[10] slot15_wrapper_0/dig_in[9] slot15_wrapper_0/dig_in[8]
+ slot15_wrapper_0/dig_in[7] slot15_wrapper_0/dig_in[6] slot15_wrapper_0/dig_in[5]
+ slot15_wrapper_0/dig_in[4] slot15_wrapper_0/dig_in[3] slot15_wrapper_0/dig_in[2]
+ slot15_wrapper_0/dig_in[1] slot15_wrapper_0/dig_in[0] slot15_wrapper_0/dig_out[11]
+ slot15_wrapper_0/dig_out[10] slot15_wrapper_0/dig_out[9] slot15_wrapper_0/dig_out[8]
+ slot15_wrapper_0/dig_out[7] slot15_wrapper_0/dig_out[6] slot15_wrapper_0/dig_out[5]
+ slot15_wrapper_0/dig_out[4] slot15_wrapper_0/dig_out[3] slot15_wrapper_0/dig_out[2]
+ slot15_wrapper_0/dig_out[1] slot15_wrapper_0/dig_out[0] slot15_wrapper_0/ibias0
+ slot15_wrapper_0/ibias1 slot15_wrapper_0/analog_bus3 slot15_wrapper_0/analog_bus2
+ slot15_wrapper_0/analog_bus1 slot15_wrapper_0/analog_bus0 sub slot15_wrapper_0/vdd_1v2
+ slot15_wrapper_0/vdd_3v3 slot15_wrapper_0/enable slot15_wrapper_0/clk slot15_wrapper_0/reset
+ slot15_wrapper
XRM_IHPSG13_1P_1024x8_c2_bm_bist_0 housekeeping_top_0/sram_addr[9] housekeeping_top_0/sram_addr[8]
+ housekeeping_top_0/sram_addr[7] housekeeping_top_0/sram_addr[6] housekeeping_top_0/sram_addr[5]
+ housekeeping_top_0/sram_addr[4] housekeeping_top_0/sram_addr[3] housekeeping_top_0/sram_addr[2]
+ housekeeping_top_0/sram_addr[1] housekeeping_top_0/sram_addr[0] sub sub sub sub
+ sub sub sub sub sub sub sub sub sub sub sub sub sub sub sub sub sub sub sub sub
+ sub sub sub sub sub sub sub vddd vddd vddd vddd vddd vddd vddd vddd housekeeping_top_0/sram_clk
+ housekeeping_top_0/sram_idata[7] housekeeping_top_0/sram_idata[6] housekeeping_top_0/sram_idata[5]
+ housekeeping_top_0/sram_idata[4] housekeeping_top_0/sram_idata[3] housekeeping_top_0/sram_idata[2]
+ housekeeping_top_0/sram_idata[1] housekeeping_top_0/sram_idata[0] vddd housekeeping_top_0/sram_odata[7]
+ housekeeping_top_0/sram_odata[6] housekeeping_top_0/sram_odata[5] housekeeping_top_0/sram_odata[4]
+ housekeeping_top_0/sram_odata[3] housekeeping_top_0/sram_odata[2] housekeeping_top_0/sram_odata[1]
+ housekeeping_top_0/sram_odata[0] housekeeping_top_0/porb housekeeping_top_0/sram_read
+ housekeeping_top_0/sram_write vddd vddd sub RM_IHPSG13_1P_1024x8_c2_bm_bist
Xproject_control_area_8 slot14_wrapper_0/dig_in[20] analog_switch_array_7[4]/analog_switch_med_1/enable
+ analog_switch_array_7[4]/analog_switch_med_0/enable slot14_wrapper_0/dig_out[7]
+ housekeeping_top_0/proj_sel[2] project_control_area_6/user_project_control_0/dig_out[0]
+ slot14_wrapper_0/dig_in[2] slot14_wrapper_0/dig_in[21] housekeeping_top_0/dbus_out[22]
+ slot14_wrapper_0/dig_out[8] housekeeping_top_0/proj_sel[1] slot14_wrapper_0/dig_in[3]
+ slot14_wrapper_0/dig_in[22] slot14_wrapper_0/dig_out[9] housekeeping_top_0/analog_bus_ena[2]
+ slot14_wrapper_0/analog_bus3 slot14_wrapper_0/dig_in[4] analog_switch_array_7[4]/analog_switch_med_2/enable
+ slot14_wrapper_0/dig_in[23] project_control_area_8/user_project_control_0/dig_out[3]
+ project_control_area_8/user_project_control_0/dig_out[11] project_control_area_8/user_project_control_0/dig_out[4]
+ slot14_wrapper_0/analog_bus2 slot14_wrapper_0/dig_in[5] housekeeping_top_0/analog_bus_ena[1]
+ slot14_wrapper_0/analog_bus1 housekeeping_top_0/dbus_out[5] slot14_wrapper_0/dig_in[6]
+ housekeeping_top_0/dbus_out[21] housekeeping_top_0/dbus_out[9] project_control_area_8/user_project_control_0/dig_out[8]
+ slot14_wrapper_0/analog_bus0 project_control_area_8/user_project_control_0/dig_out[9]
+ slot14_wrapper_0/dig_in[7] project_control_area_6/user_project_control_0/dig_out[11]
+ slot14_wrapper_0/dig_in[8] analog_switch_array_7[4]/analog_pswitch_small_3/enable
+ housekeeping_top_0/proj_sel[0] housekeeping_top_0/dbus_out[1] slot14_wrapper_0/dig_in[9]
+ housekeeping_top_0/dbus_out[17] housekeeping_top_0/dbus_out[2] sub slot14_wrapper_0/dig_out[10]
+ housekeeping_top_0/proj_dig_ena slot14_wrapper_0/dig_out[11] housekeeping_top_0/dbus_out[10]
+ vdd1v2_uq2 vdd1v2_uq2 project_control_area_8/user_project_control_0/dig_out[5] housekeeping_top_0/proj_ibias_ena[1]
+ housekeeping_top_0/dbus_out[23] slot14_wrapper_0/ibias1 project_control_area_8/user_project_control_0/dig_out[10]
+ slot14_wrapper_0/vdd_3v3 housekeeping_top_0/dbus_out[6] slot14_wrapper_0/ibias0
+ slot14_wrapper_0/dig_in[10] project_control_area_6/user_project_control_0/dig_out[2]
+ housekeeping_top_0/proj_vbias_ena slot14_wrapper_0/dig_in[11] vdd3v3 slot14_wrapper_0/enable
+ project_control_area_6/user_project_control_0/dig_out[1] project_control_area_6/user_project_control_0/dig_out[3]
+ slot14_wrapper_0/dig_in[12] slot14_wrapper_0/dig_in[13] housekeeping_top_0/proj_3v3_ena
+ project_control_area_6/user_project_control_0/dig_out[4] slot14_wrapper_0/vbias
+ slot14_wrapper_0/dig_in[14] housekeeping_top_0/analog_bus_ena[3] housekeeping_top_0/proj_ibias_ena[0]
+ project_control_area_6/user_project_control_0/dig_out[5] slot14_wrapper_0/dig_in[15]
+ housekeeping_top_0/dbus_out[20] vdd1v2_uq2 housekeeping_top_0/dbus_out[19] slot14_wrapper_0/dig_in[16]
+ project_control_area_6/user_project_control_0/dig_out[6] housekeeping_top_0/proj_sel[4]
+ project_control_area_8/user_project_control_0/dig_out[6] sub housekeeping_top_0/reset
+ housekeeping_top_0/dbus_out[12] slot14_wrapper_0/dig_in[17] housekeeping_top_0/analog_bus_ena[0]
+ housekeeping_top_0/proj_1v2_ena slot14_wrapper_0/dig_in[18] housekeeping_top_0/proj_ena
+ slot14_wrapper_0/dig_in[19] vdd1v2_uq2 project_control_area_6/user_project_control_0/dig_out[9]
+ vdd3v3 housekeeping_top_0/dbus_out[14] analog_switch_array_7[4]/analog_pswitch_small_2/enable
+ project_control_area_6/user_project_control_0/dig_out[10] housekeeping_top_0/dbus_out[16]
+ housekeeping_top_0/dbus_out[18] slot14_wrapper_0/dig_out[0] housekeeping_top_0/clk_out
+ slot14_wrapper_0/reset slot14_wrapper_0/dig_out[1] project_control_area_8/user_project_control_0/dig_out[2]
+ housekeeping_top_0/dbus_out[0] slot14_wrapper_0/dig_out[2] project_control_area_8/user_project_control_0/dig_out[7]
+ project_control_area_8/user_project_control_0/dig_out[0] slot14_wrapper_0/clk project_control_area_8/user_project_control_0/dig_out[1]
+ housekeeping_top_0/dbus_out[7] slot14_wrapper_0/dig_out[3] housekeeping_top_0/dbus_out[8]
+ housekeeping_top_0/dbus_out[11] project_control_area_6/user_project_control_0/dig_out[7]
+ slot14_wrapper_0/dig_out[4] housekeeping_top_0/dbus_out[3] analog_switch_array_7[4]/analog_switch_small_1/enable
+ housekeeping_top_0/proj_sel[3] slot14_wrapper_0/dig_out[5] project_control_area_6/user_project_control_0/dig_out[8]
+ housekeeping_top_0/dbus_out[4] slot14_wrapper_0/dig_in[0] housekeeping_top_0/dbus_out[15]
+ sub analog_switch_array_7[4]/analog_switch_med_3/enable housekeeping_top_0/dbus_out[13]
+ slot14_wrapper_0/dig_out[6] sub slot14_wrapper_0/vdd_1v2 vdd1v2_uq2 sub slot14_wrapper_0/dig_in[1]
+ project_control_area
Xsg13cmos5l_ocd_ip__biasgen2_0 housekeeping_top_0/biasgen_ena analog_switch_small_0/in
+ housekeeping_top_0/biasgen_ref_vbg analog_pswitch_small_1/out housekeeping_top_0/idac2_value[4]
+ housekeeping_top_0/idac2_value[3] housekeeping_top_0/idac2_value[2] housekeeping_top_0/idac2_value[1]
+ housekeeping_top_0/idac2_value[0] analog_pswitch_small_0/out housekeeping_top_0/idac1_value[0]
+ housekeeping_top_0/idac1_value[1] housekeeping_top_0/idac1_value[2] housekeeping_top_0/idac1_value[3]
+ housekeeping_top_0/idac1_value[4] housekeeping_top_0/voltgen_source[4] housekeeping_top_0/voltgen_source[3]
+ housekeeping_top_0/voltgen_source[2] housekeeping_top_0/voltgen_source[1] housekeeping_top_0/voltgen_source[0]
+ sg13cmos5l_ocd_ip__voltgen_v3_0/ibias1u_1 housekeeping_top_0/biasgen_coarse housekeeping_top_0/biasgen_fine
+ sg13cmos5l_ocd_ip__bandgap_v3_0/ibias1_250n housekeeping_top_0/bandgap_sink2[0]
+ housekeeping_top_0/bandgap_sink2[1] housekeeping_top_0/bandgap_sink1[0] housekeeping_top_0/bandgap_sink1[1]
+ housekeeping_top_0/bandgap_sink1[2] housekeeping_top_0/voltgen_sink1[0] housekeeping_top_0/voltgen_sink1[1]
+ housekeeping_top_0/voltgen_sink1[2] housekeeping_top_0/voltgen_sink2[0] housekeeping_top_0/voltgen_sink2[1]
+ housekeeping_top_0/voltgen_sink2[2] sg13cmos5l_ocd_ip__voltgen_v3_0/ibias1u_2 sg13cmos5l_ocd_ip__classab_buffer_0/bias
+ sg13cmos5l_ocd_ip__bandgap_v3_0/ibias2_1u vdd3v3 vdd3v3 sub sub vdd1v2_uq2 sg13cmos5l_ocd_ip__biasgen2
Xproject_control_area_9 slot5_wrapper_0/dig_in[20] analog_switch_array_7[4]/analog_switch_med_18/enable
+ analog_switch_array_7[4]/analog_switch_med_17/enable slot5_wrapper_0/dig_out[7]
+ housekeeping_top_0/proj_sel[2] project_control_area_7/user_project_control_0/dig_out[0]
+ slot5_wrapper_0/dig_in[2] slot5_wrapper_0/dig_in[21] housekeeping_top_0/dbus_out[22]
+ slot5_wrapper_0/dig_out[8] housekeeping_top_0/proj_sel[1] slot5_wrapper_0/dig_in[3]
+ slot5_wrapper_0/dig_in[22] slot5_wrapper_0/dig_out[9] housekeeping_top_0/analog_bus_ena[2]
+ slot5_wrapper_0/analog_bus3 slot5_wrapper_0/dig_in[4] analog_switch_array_7[4]/analog_switch_med_20/enable
+ slot5_wrapper_0/dig_in[23] project_control_area_9/user_project_control_0/dig_out[3]
+ project_control_area_9/user_project_control_0/dig_out[11] project_control_area_9/user_project_control_0/dig_out[4]
+ slot5_wrapper_0/analog_bus2 slot5_wrapper_0/dig_in[5] housekeeping_top_0/analog_bus_ena[1]
+ slot5_wrapper_0/analog_bus1 housekeeping_top_0/dbus_out[5] slot5_wrapper_0/dig_in[6]
+ housekeeping_top_0/dbus_out[21] housekeeping_top_0/dbus_out[9] project_control_area_9/user_project_control_0/dig_out[8]
+ slot5_wrapper_0/analog_bus0 project_control_area_9/user_project_control_0/dig_out[9]
+ slot5_wrapper_0/dig_in[7] project_control_area_7/user_project_control_0/dig_out[11]
+ slot5_wrapper_0/dig_in[8] analog_switch_array_7[4]/analog_pswitch_small_0/enable
+ housekeeping_top_0/proj_sel[0] housekeeping_top_0/dbus_out[1] slot5_wrapper_0/dig_in[9]
+ housekeeping_top_0/dbus_out[17] housekeeping_top_0/dbus_out[2] vdd1v2_uq2 slot5_wrapper_0/dig_out[10]
+ housekeeping_top_0/proj_dig_ena slot5_wrapper_0/dig_out[11] housekeeping_top_0/dbus_out[10]
+ sub sub project_control_area_9/user_project_control_0/dig_out[5] housekeeping_top_0/proj_ibias_ena[1]
+ housekeeping_top_0/dbus_out[23] slot5_wrapper_0/ibias1 project_control_area_9/user_project_control_0/dig_out[10]
+ slot5_wrapper_0/vdd_3v3 housekeeping_top_0/dbus_out[6] slot5_wrapper_0/ibias0 slot5_wrapper_0/dig_in[10]
+ project_control_area_7/user_project_control_0/dig_out[2] housekeeping_top_0/proj_vbias_ena
+ slot5_wrapper_0/dig_in[11] vdd3v3 slot5_wrapper_0/enable project_control_area_7/user_project_control_0/dig_out[1]
+ project_control_area_7/user_project_control_0/dig_out[3] slot5_wrapper_0/dig_in[12]
+ slot5_wrapper_0/dig_in[13] housekeeping_top_0/proj_3v3_ena project_control_area_7/user_project_control_0/dig_out[4]
+ slot5_wrapper_0/vbias slot5_wrapper_0/dig_in[14] housekeeping_top_0/analog_bus_ena[3]
+ housekeeping_top_0/proj_ibias_ena[0] project_control_area_7/user_project_control_0/dig_out[5]
+ slot5_wrapper_0/dig_in[15] housekeeping_top_0/dbus_out[20] vdd1v2_uq2 housekeeping_top_0/dbus_out[19]
+ slot5_wrapper_0/dig_in[16] project_control_area_7/user_project_control_0/dig_out[6]
+ housekeeping_top_0/proj_sel[4] project_control_area_9/user_project_control_0/dig_out[6]
+ sub housekeeping_top_0/reset housekeeping_top_0/dbus_out[12] slot5_wrapper_0/dig_in[17]
+ housekeeping_top_0/analog_bus_ena[0] housekeeping_top_0/proj_1v2_ena slot5_wrapper_0/dig_in[18]
+ housekeeping_top_0/proj_ena slot5_wrapper_0/dig_in[19] vdd1v2_uq2 project_control_area_7/user_project_control_0/dig_out[9]
+ vdd3v3 housekeeping_top_0/dbus_out[14] analog_switch_array_7[4]/analog_pswitch_small_1/enable
+ project_control_area_7/user_project_control_0/dig_out[10] housekeeping_top_0/dbus_out[16]
+ housekeeping_top_0/dbus_out[18] slot5_wrapper_0/dig_out[0] housekeeping_top_0/clk_out
+ slot5_wrapper_0/reset slot5_wrapper_0/dig_out[1] project_control_area_9/user_project_control_0/dig_out[2]
+ housekeeping_top_0/dbus_out[0] slot5_wrapper_0/dig_out[2] project_control_area_9/user_project_control_0/dig_out[7]
+ project_control_area_9/user_project_control_0/dig_out[0] slot5_wrapper_0/clk project_control_area_9/user_project_control_0/dig_out[1]
+ housekeeping_top_0/dbus_out[7] slot5_wrapper_0/dig_out[3] housekeeping_top_0/dbus_out[8]
+ housekeeping_top_0/dbus_out[11] project_control_area_7/user_project_control_0/dig_out[7]
+ slot5_wrapper_0/dig_out[4] housekeeping_top_0/dbus_out[3] analog_switch_array_7[4]/analog_switch_small_0/enable
+ housekeeping_top_0/proj_sel[3] slot5_wrapper_0/dig_out[5] project_control_area_7/user_project_control_0/dig_out[8]
+ housekeeping_top_0/dbus_out[4] slot5_wrapper_0/dig_in[0] housekeeping_top_0/dbus_out[15]
+ sub analog_switch_array_7[4]/analog_switch_med_22/enable housekeeping_top_0/dbus_out[13]
+ slot5_wrapper_0/dig_out[6] sub slot5_wrapper_0/vdd_1v2 vdd1v2_uq2 sub slot5_wrapper_0/dig_in[1]
+ project_control_area
Xslot2_wrapper_0 s2_an[0] s2_an[1] s2_an_0_esd s2_an_1_esd slot2_wrapper_0/vbias slot2_wrapper_0/dig_in[23]
+ slot2_wrapper_0/dig_in[22] slot2_wrapper_0/dig_in[21] slot2_wrapper_0/dig_in[20]
+ slot2_wrapper_0/dig_in[19] slot2_wrapper_0/dig_in[18] slot2_wrapper_0/dig_in[17]
+ slot2_wrapper_0/dig_in[16] slot2_wrapper_0/dig_in[15] slot2_wrapper_0/dig_in[14]
+ slot2_wrapper_0/dig_in[13] slot2_wrapper_0/dig_in[12] slot2_wrapper_0/dig_in[11]
+ slot2_wrapper_0/dig_in[10] slot2_wrapper_0/dig_in[9] slot2_wrapper_0/dig_in[8] slot2_wrapper_0/dig_in[7]
+ slot2_wrapper_0/dig_in[6] slot2_wrapper_0/dig_in[5] slot2_wrapper_0/dig_in[4] slot2_wrapper_0/dig_in[3]
+ slot2_wrapper_0/dig_in[2] slot2_wrapper_0/dig_in[1] slot2_wrapper_0/dig_in[0] slot2_wrapper_0/dig_out[11]
+ slot2_wrapper_0/dig_out[10] slot2_wrapper_0/dig_out[9] slot2_wrapper_0/dig_out[8]
+ slot2_wrapper_0/dig_out[7] slot2_wrapper_0/dig_out[6] slot2_wrapper_0/dig_out[5]
+ slot2_wrapper_0/dig_out[4] slot2_wrapper_0/dig_out[3] slot2_wrapper_0/dig_out[2]
+ slot2_wrapper_0/dig_out[1] slot2_wrapper_0/dig_out[0] slot2_wrapper_0/ibias0 slot2_wrapper_0/ibias1
+ slot2_wrapper_0/analog_bus3 slot2_wrapper_0/analog_bus2 slot2_wrapper_0/analog_bus1
+ slot2_wrapper_0/analog_bus0 sub slot2_wrapper_0/vdd_1v2 sub slot2_wrapper_0/vdd_3v3
+ slot2_wrapper_0/enable slot2_wrapper_0/clk slot2_wrapper_0/reset slot2_wrapper
Xslot6_wrapper_0 s6_an[0] s6_an[1] s6_an[0] s6_an[1] slot6_wrapper_0/vbias slot6_wrapper_0/dig_in[23]
+ slot6_wrapper_0/dig_in[22] slot6_wrapper_0/dig_in[21] slot6_wrapper_0/dig_in[20]
+ slot6_wrapper_0/dig_in[19] slot6_wrapper_0/dig_in[18] slot6_wrapper_0/dig_in[17]
+ slot6_wrapper_0/dig_in[16] slot6_wrapper_0/dig_in[15] slot6_wrapper_0/dig_in[14]
+ slot6_wrapper_0/dig_in[13] slot6_wrapper_0/dig_in[12] slot6_wrapper_0/dig_in[11]
+ slot6_wrapper_0/dig_in[10] slot6_wrapper_0/dig_in[9] slot6_wrapper_0/dig_in[8] slot6_wrapper_0/dig_in[7]
+ slot6_wrapper_0/dig_in[6] slot6_wrapper_0/dig_in[5] slot6_wrapper_0/dig_in[4] slot6_wrapper_0/dig_in[3]
+ slot6_wrapper_0/dig_in[2] slot6_wrapper_0/dig_in[1] slot6_wrapper_0/dig_in[0] slot6_wrapper_0/dig_out[11]
+ slot6_wrapper_0/dig_out[10] slot6_wrapper_0/dig_out[9] slot6_wrapper_0/dig_out[8]
+ slot6_wrapper_0/dig_out[7] slot6_wrapper_0/dig_out[6] slot6_wrapper_0/dig_out[5]
+ slot6_wrapper_0/dig_out[4] slot6_wrapper_0/dig_out[3] slot6_wrapper_0/dig_out[2]
+ slot6_wrapper_0/dig_out[1] slot6_wrapper_0/dig_out[0] slot6_wrapper_0/ibias0 slot6_wrapper_0/ibias1
+ slot6_wrapper_0/analog_bus3 slot6_wrapper_0/analog_bus2 slot6_wrapper_0/analog_bus1
+ slot6_wrapper_0/analog_bus0 sub slot6_wrapper_0/vdd_1v2 sub slot6_wrapper_0/vdd_3v3
+ slot6_wrapper_0/enable slot6_wrapper_0/clk slot6_wrapper_0/reset slot6_wrapper
Xanalog_pswitch_small_1 analog[1] analog_pswitch_small_1/out sub analog_switch_small_1/enable
+ vdd3v3 vdd1v2_uq2 sub analog_pswitch_small
Xanalog_pswitch_small_0 analog[2] analog_pswitch_small_0/out sub analog_switch_small_1/enable
+ vdd3v3 vdd1v2_uq2 sub analog_pswitch_small
Xslot10_wrapper_0 s10_an[0] s10_an[1] s10_an[2] s10_an_0_esd s10_an_1_esd s10_an_2_esd
+ slot10_wrapper_0/vbias slot10_wrapper_0/dig_in[23] slot10_wrapper_0/dig_in[22] slot10_wrapper_0/dig_in[21]
+ slot10_wrapper_0/dig_in[20] slot10_wrapper_0/dig_in[19] slot10_wrapper_0/dig_in[18]
+ slot10_wrapper_0/dig_in[17] slot10_wrapper_0/dig_in[16] slot10_wrapper_0/dig_in[15]
+ slot10_wrapper_0/dig_in[14] slot10_wrapper_0/dig_in[13] slot10_wrapper_0/dig_in[12]
+ slot10_wrapper_0/dig_in[11] slot10_wrapper_0/dig_in[10] slot10_wrapper_0/dig_in[9]
+ slot10_wrapper_0/dig_in[8] slot10_wrapper_0/dig_in[7] slot10_wrapper_0/dig_in[6]
+ slot10_wrapper_0/dig_in[5] slot10_wrapper_0/dig_in[4] slot10_wrapper_0/dig_in[3]
+ slot10_wrapper_0/dig_in[2] slot10_wrapper_0/dig_in[1] slot10_wrapper_0/dig_in[0]
+ slot10_wrapper_0/dig_out[11] slot10_wrapper_0/dig_out[10] slot10_wrapper_0/dig_out[9]
+ slot10_wrapper_0/dig_out[8] slot10_wrapper_0/dig_out[7] slot10_wrapper_0/dig_out[6]
+ slot10_wrapper_0/dig_out[5] slot10_wrapper_0/dig_out[4] slot10_wrapper_0/dig_out[3]
+ slot10_wrapper_0/dig_out[2] slot10_wrapper_0/dig_out[1] slot10_wrapper_0/dig_out[0]
+ slot10_wrapper_0/ibias0 slot10_wrapper_0/ibias1 slot10_wrapper_0/analog_bus3 slot10_wrapper_0/analog_bus2
+ slot10_wrapper_0/analog_bus1 slot10_wrapper_0/analog_bus0 sub slot10_wrapper_0/vdd_1v2
+ sub slot10_wrapper_0/vdd_3v3 slot10_wrapper_0/enable slot10_wrapper_0/clk slot10_wrapper_0/reset
+ slot10_wrapper
Xslot14_wrapper_0 s14_an[0] s14_an[1] s14_an[2] s14_an_0_esd s14_an_1_esd s14_an_2_esd
+ slot14_wrapper_0/vbias slot14_wrapper_0/dig_in[23] slot14_wrapper_0/dig_in[22] slot14_wrapper_0/dig_in[21]
+ slot14_wrapper_0/dig_in[20] slot14_wrapper_0/dig_in[19] slot14_wrapper_0/dig_in[18]
+ slot14_wrapper_0/dig_in[17] slot14_wrapper_0/dig_in[16] slot14_wrapper_0/dig_in[15]
+ slot14_wrapper_0/dig_in[14] slot14_wrapper_0/dig_in[13] slot14_wrapper_0/dig_in[12]
+ slot14_wrapper_0/dig_in[11] slot14_wrapper_0/dig_in[10] slot14_wrapper_0/dig_in[9]
+ slot14_wrapper_0/dig_in[8] slot14_wrapper_0/dig_in[7] slot14_wrapper_0/dig_in[6]
+ slot14_wrapper_0/dig_in[5] slot14_wrapper_0/dig_in[4] slot14_wrapper_0/dig_in[3]
+ slot14_wrapper_0/dig_in[2] slot14_wrapper_0/dig_in[1] slot14_wrapper_0/dig_in[0]
+ slot14_wrapper_0/dig_out[11] slot14_wrapper_0/dig_out[10] slot14_wrapper_0/dig_out[9]
+ slot14_wrapper_0/dig_out[8] slot14_wrapper_0/dig_out[7] slot14_wrapper_0/dig_out[6]
+ slot14_wrapper_0/dig_out[5] slot14_wrapper_0/dig_out[4] slot14_wrapper_0/dig_out[3]
+ slot14_wrapper_0/dig_out[2] slot14_wrapper_0/dig_out[1] slot14_wrapper_0/dig_out[0]
+ slot14_wrapper_0/ibias0 slot14_wrapper_0/ibias1 slot14_wrapper_0/analog_bus3 slot14_wrapper_0/analog_bus2
+ slot14_wrapper_0/analog_bus1 slot14_wrapper_0/analog_bus0 sub slot14_wrapper_0/vdd_1v2
+ sub slot14_wrapper_0/vdd_3v3 slot14_wrapper_0/enable slot14_wrapper_0/clk slot14_wrapper_0/reset
+ slot14_wrapper
Xslot18_wrapper_0 s18_an[0] s18_an[1] s18_an_0_esd s18_an_1_esd slot18_wrapper_0/vbias
+ slot18_wrapper_0/dig_in[23] slot18_wrapper_0/dig_in[22] slot18_wrapper_0/dig_in[21]
+ slot18_wrapper_0/dig_in[20] slot18_wrapper_0/dig_in[19] slot18_wrapper_0/dig_in[18]
+ slot18_wrapper_0/dig_in[17] slot18_wrapper_0/dig_in[16] slot18_wrapper_0/dig_in[15]
+ slot18_wrapper_0/dig_in[14] slot18_wrapper_0/dig_in[13] slot18_wrapper_0/dig_in[12]
+ slot18_wrapper_0/dig_in[11] slot18_wrapper_0/dig_in[10] slot18_wrapper_0/dig_in[9]
+ slot18_wrapper_0/dig_in[8] slot18_wrapper_0/dig_in[7] slot18_wrapper_0/dig_in[6]
+ slot18_wrapper_0/dig_in[5] slot18_wrapper_0/dig_in[4] slot18_wrapper_0/dig_in[3]
+ slot18_wrapper_0/dig_in[2] slot18_wrapper_0/dig_in[1] slot18_wrapper_0/dig_in[0]
+ slot18_wrapper_0/dig_out[11] slot18_wrapper_0/dig_out[10] slot18_wrapper_0/dig_out[9]
+ slot18_wrapper_0/dig_out[8] slot18_wrapper_0/dig_out[7] slot18_wrapper_0/dig_out[6]
+ slot18_wrapper_0/dig_out[5] slot18_wrapper_0/dig_out[4] slot18_wrapper_0/dig_out[3]
+ slot18_wrapper_0/dig_out[2] slot18_wrapper_0/dig_out[1] slot18_wrapper_0/dig_out[0]
+ slot18_wrapper_0/ibias0 slot18_wrapper_0/ibias1 slot18_wrapper_0/analog_bus3 slot18_wrapper_0/analog_bus2
+ slot18_wrapper_0/analog_bus1 slot18_wrapper_0/analog_bus0 sub slot18_wrapper_0/vdd_1v2
+ sub slot18_wrapper_0/vdd_3v3 slot18_wrapper_0/enable slot18_wrapper_0/clk slot18_wrapper_0/reset
+ slot18_wrapper
Xslot1_wrapper_0 s1_an[0] s1_an[1] s1_an_0_esd slot1_wrapper_0/vbias slot1_wrapper_0/dig_in[23]
+ slot1_wrapper_0/dig_in[22] slot1_wrapper_0/dig_in[21] slot1_wrapper_0/dig_in[20]
+ slot1_wrapper_0/dig_in[19] slot1_wrapper_0/dig_in[18] slot1_wrapper_0/dig_in[17]
+ slot1_wrapper_0/dig_in[16] slot1_wrapper_0/dig_in[15] slot1_wrapper_0/dig_in[14]
+ slot1_wrapper_0/dig_in[13] slot1_wrapper_0/dig_in[12] slot1_wrapper_0/dig_in[11]
+ slot1_wrapper_0/dig_in[10] slot1_wrapper_0/dig_in[9] slot1_wrapper_0/dig_in[8] slot1_wrapper_0/dig_in[7]
+ slot1_wrapper_0/dig_in[6] slot1_wrapper_0/dig_in[5] slot1_wrapper_0/dig_in[4] slot1_wrapper_0/dig_in[3]
+ slot1_wrapper_0/dig_in[2] slot1_wrapper_0/dig_in[1] slot1_wrapper_0/dig_in[0] slot1_wrapper_0/dig_out[11]
+ slot1_wrapper_0/dig_out[10] slot1_wrapper_0/dig_out[9] slot1_wrapper_0/dig_out[8]
+ slot1_wrapper_0/dig_out[7] slot1_wrapper_0/dig_out[6] slot1_wrapper_0/dig_out[5]
+ slot1_wrapper_0/dig_out[4] slot1_wrapper_0/dig_out[3] slot1_wrapper_0/dig_out[2]
+ slot1_wrapper_0/dig_out[1] slot1_wrapper_0/dig_out[0] slot1_wrapper_0/ibias0 slot1_wrapper_0/ibias1
+ slot1_wrapper_0/analog_bus3 slot1_wrapper_0/analog_bus2 slot1_wrapper_0/analog_bus1
+ slot1_wrapper_0/analog_bus0 sub slot1_wrapper_0/vdd_1v2 sub slot1_wrapper_0/vdd_3v3
+ slot1_wrapper_0/enable slot1_wrapper_0/clk slot1_wrapper_0/reset slot1_wrapper
Xslot5_wrapper_0 s5_an[0] s5_an[1] s5_an[2] s5_an_0_esd s5_an_1_esd slot5_wrapper_0/vbias
+ slot5_wrapper_0/dig_in[23] slot5_wrapper_0/dig_in[22] slot5_wrapper_0/dig_in[21]
+ slot5_wrapper_0/dig_in[20] slot5_wrapper_0/dig_in[19] slot5_wrapper_0/dig_in[18]
+ slot5_wrapper_0/dig_in[17] slot5_wrapper_0/dig_in[16] slot5_wrapper_0/dig_in[15]
+ slot5_wrapper_0/dig_in[14] slot5_wrapper_0/dig_in[13] slot5_wrapper_0/dig_in[12]
+ slot5_wrapper_0/dig_in[11] slot5_wrapper_0/dig_in[10] slot5_wrapper_0/dig_in[9]
+ slot5_wrapper_0/dig_in[8] slot5_wrapper_0/dig_in[7] slot5_wrapper_0/dig_in[6] slot5_wrapper_0/dig_in[5]
+ slot5_wrapper_0/dig_in[4] slot5_wrapper_0/dig_in[3] slot5_wrapper_0/dig_in[2] slot5_wrapper_0/dig_in[1]
+ slot5_wrapper_0/dig_in[0] slot5_wrapper_0/dig_out[11] slot5_wrapper_0/dig_out[10]
+ slot5_wrapper_0/dig_out[9] slot5_wrapper_0/dig_out[8] slot5_wrapper_0/dig_out[7]
+ slot5_wrapper_0/dig_out[6] slot5_wrapper_0/dig_out[5] slot5_wrapper_0/dig_out[4]
+ slot5_wrapper_0/dig_out[3] slot5_wrapper_0/dig_out[2] slot5_wrapper_0/dig_out[1]
+ slot5_wrapper_0/dig_out[0] slot5_wrapper_0/ibias0 slot5_wrapper_0/ibias1 slot5_wrapper_0/analog_bus3
+ slot5_wrapper_0/analog_bus2 slot5_wrapper_0/analog_bus1 slot5_wrapper_0/analog_bus0
+ sub slot5_wrapper_0/vdd_1v2 sub slot5_wrapper_0/vdd_3v3 slot5_wrapper_0/enable slot5_wrapper_0/clk
+ slot5_wrapper_0/reset slot5_wrapper
Xslot9_wrapper_0 s9_an[0] s9_an[1] s9_an[2] s9_an_0_esd s9_an_1_esd slot9_wrapper_0/vbias
+ slot9_wrapper_0/dig_in[23] slot9_wrapper_0/dig_in[22] slot9_wrapper_0/dig_in[21]
+ slot9_wrapper_0/dig_in[20] slot9_wrapper_0/dig_in[19] slot9_wrapper_0/dig_in[18]
+ slot9_wrapper_0/dig_in[17] slot9_wrapper_0/dig_in[16] slot9_wrapper_0/dig_in[15]
+ slot9_wrapper_0/dig_in[14] slot9_wrapper_0/dig_in[13] slot9_wrapper_0/dig_in[12]
+ slot9_wrapper_0/dig_in[11] slot9_wrapper_0/dig_in[10] slot9_wrapper_0/dig_in[9]
+ slot9_wrapper_0/dig_in[8] slot9_wrapper_0/dig_in[7] slot9_wrapper_0/dig_in[6] slot9_wrapper_0/dig_in[5]
+ slot9_wrapper_0/dig_in[4] slot9_wrapper_0/dig_in[3] slot9_wrapper_0/dig_in[2] slot9_wrapper_0/dig_in[1]
+ slot9_wrapper_0/dig_in[0] slot9_wrapper_0/dig_out[11] slot9_wrapper_0/dig_out[10]
+ slot9_wrapper_0/dig_out[9] slot9_wrapper_0/dig_out[8] slot9_wrapper_0/dig_out[7]
+ slot9_wrapper_0/dig_out[6] slot9_wrapper_0/dig_out[5] slot9_wrapper_0/dig_out[4]
+ slot9_wrapper_0/dig_out[3] slot9_wrapper_0/dig_out[2] slot9_wrapper_0/dig_out[1]
+ slot9_wrapper_0/dig_out[0] slot9_wrapper_0/ibias0 slot9_wrapper_0/ibias1 slot9_wrapper_0/analog_bus3
+ slot9_wrapper_0/analog_bus2 slot9_wrapper_0/analog_bus1 slot9_wrapper_0/analog_bus0
+ sub slot9_wrapper_0/vdd_1v2 sub slot9_wrapper_0/vdd_3v3 slot9_wrapper_0/enable slot9_wrapper_0/clk
+ slot9_wrapper_0/reset slot9_wrapper
Xsg13cmos5l_ocd_ip__voltgen_v3_0 vdd1v2_uq2 housekeeping_top_0/voltgen_value[2] housekeeping_top_0/voltgen_value[1]
+ housekeeping_top_0/voltgen_value[0] analog_switch_small_0/in sg13cmos5l_ocd_ip__voltgen_v3_0/ibias1u_1
+ housekeeping_top_0/voltgen_ena[0] housekeeping_top_0/voltgen_ena[2] housekeeping_top_0/voltgen_ena[1]
+ sg13cmos5l_ocd_ip__voltgen_v3_0/ibias1u_2 housekeeping_top_0/voltgen_high sg13cmos5l_ocd_ip__classab_buffer_0/ena
+ sg13cmos5l_ocd_ip__classab_buffer_0/inp analog_switch_small_1/in sub sub vdd3v3
+ sg13cmos5l_ocd_ip__voltgen_v3
Xproject_control_area_10 slot15_wrapper_0/dig_in[20] analog_switch_array_7[3]/analog_switch_med_1/enable
+ analog_switch_array_7[3]/analog_switch_med_0/enable slot15_wrapper_0/dig_out[7]
+ housekeeping_top_0/proj_sel[2] project_control_area_8/user_project_control_0/dig_out[0]
+ slot15_wrapper_0/dig_in[2] slot15_wrapper_0/dig_in[21] housekeeping_top_0/dbus_out[22]
+ slot15_wrapper_0/dig_out[8] housekeeping_top_0/proj_sel[1] slot15_wrapper_0/dig_in[3]
+ slot15_wrapper_0/dig_in[22] slot15_wrapper_0/dig_out[9] housekeeping_top_0/analog_bus_ena[2]
+ slot15_wrapper_0/analog_bus3 slot15_wrapper_0/dig_in[4] analog_switch_array_7[3]/analog_switch_med_2/enable
+ slot15_wrapper_0/dig_in[23] project_control_area_10/user_project_control_0/dig_out[3]
+ project_control_area_10/user_project_control_0/dig_out[11] project_control_area_10/user_project_control_0/dig_out[4]
+ slot15_wrapper_0/analog_bus2 slot15_wrapper_0/dig_in[5] housekeeping_top_0/analog_bus_ena[1]
+ slot15_wrapper_0/analog_bus1 housekeeping_top_0/dbus_out[5] slot15_wrapper_0/dig_in[6]
+ housekeeping_top_0/dbus_out[21] housekeeping_top_0/dbus_out[9] project_control_area_10/user_project_control_0/dig_out[8]
+ slot15_wrapper_0/analog_bus0 project_control_area_10/user_project_control_0/dig_out[9]
+ slot15_wrapper_0/dig_in[7] project_control_area_8/user_project_control_0/dig_out[11]
+ slot15_wrapper_0/dig_in[8] analog_switch_array_7[3]/analog_pswitch_small_3/enable
+ housekeeping_top_0/proj_sel[0] housekeeping_top_0/dbus_out[1] slot15_wrapper_0/dig_in[9]
+ housekeeping_top_0/dbus_out[17] housekeeping_top_0/dbus_out[2] vdd1v2_uq2 slot15_wrapper_0/dig_out[10]
+ housekeeping_top_0/proj_dig_ena slot15_wrapper_0/dig_out[11] housekeeping_top_0/dbus_out[10]
+ vdd1v2_uq2 vdd1v2_uq2 project_control_area_10/user_project_control_0/dig_out[5]
+ housekeeping_top_0/proj_ibias_ena[1] housekeeping_top_0/dbus_out[23] slot15_wrapper_0/ibias1
+ project_control_area_10/user_project_control_0/dig_out[10] slot15_wrapper_0/vdd_3v3
+ housekeeping_top_0/dbus_out[6] slot15_wrapper_0/ibias0 slot15_wrapper_0/dig_in[10]
+ project_control_area_8/user_project_control_0/dig_out[2] housekeeping_top_0/proj_vbias_ena
+ slot15_wrapper_0/dig_in[11] vdd3v3 slot15_wrapper_0/enable project_control_area_8/user_project_control_0/dig_out[1]
+ project_control_area_8/user_project_control_0/dig_out[3] slot15_wrapper_0/dig_in[12]
+ slot15_wrapper_0/dig_in[13] housekeeping_top_0/proj_3v3_ena project_control_area_8/user_project_control_0/dig_out[4]
+ slot15_wrapper_0/vbias slot15_wrapper_0/dig_in[14] housekeeping_top_0/analog_bus_ena[3]
+ housekeeping_top_0/proj_ibias_ena[0] project_control_area_8/user_project_control_0/dig_out[5]
+ slot15_wrapper_0/dig_in[15] housekeeping_top_0/dbus_out[20] vdd1v2_uq2 housekeeping_top_0/dbus_out[19]
+ slot15_wrapper_0/dig_in[16] project_control_area_8/user_project_control_0/dig_out[6]
+ housekeeping_top_0/proj_sel[4] project_control_area_10/user_project_control_0/dig_out[6]
+ sub housekeeping_top_0/reset housekeeping_top_0/dbus_out[12] slot15_wrapper_0/dig_in[17]
+ housekeeping_top_0/analog_bus_ena[0] housekeeping_top_0/proj_1v2_ena slot15_wrapper_0/dig_in[18]
+ housekeeping_top_0/proj_ena slot15_wrapper_0/dig_in[19] vdd1v2_uq2 project_control_area_8/user_project_control_0/dig_out[9]
+ vdd3v3 housekeeping_top_0/dbus_out[14] analog_switch_array_7[3]/analog_pswitch_small_2/enable
+ project_control_area_8/user_project_control_0/dig_out[10] housekeeping_top_0/dbus_out[16]
+ housekeeping_top_0/dbus_out[18] slot15_wrapper_0/dig_out[0] housekeeping_top_0/clk_out
+ slot15_wrapper_0/reset slot15_wrapper_0/dig_out[1] project_control_area_10/user_project_control_0/dig_out[2]
+ housekeeping_top_0/dbus_out[0] slot15_wrapper_0/dig_out[2] project_control_area_10/user_project_control_0/dig_out[7]
+ project_control_area_10/user_project_control_0/dig_out[0] slot15_wrapper_0/clk project_control_area_10/user_project_control_0/dig_out[1]
+ housekeeping_top_0/dbus_out[7] slot15_wrapper_0/dig_out[3] housekeeping_top_0/dbus_out[8]
+ housekeeping_top_0/dbus_out[11] project_control_area_8/user_project_control_0/dig_out[7]
+ slot15_wrapper_0/dig_out[4] housekeeping_top_0/dbus_out[3] analog_switch_array_7[3]/analog_switch_small_1/enable
+ housekeeping_top_0/proj_sel[3] slot15_wrapper_0/dig_out[5] project_control_area_8/user_project_control_0/dig_out[8]
+ housekeeping_top_0/dbus_out[4] slot15_wrapper_0/dig_in[0] housekeeping_top_0/dbus_out[15]
+ sub analog_switch_array_7[3]/analog_switch_med_3/enable housekeeping_top_0/dbus_out[13]
+ slot15_wrapper_0/dig_out[6] sub slot15_wrapper_0/vdd_1v2 vdd1v2_uq2 sub slot15_wrapper_0/dig_in[1]
+ project_control_area
Xslot13_wrapper_0 s13_an[0] s13_an[1] s13_an_0_esd s13_an_1_esd s13_an[0] s13_an[1]
+ slot13_wrapper_0/vbias slot13_wrapper_0/dig_in[23] slot13_wrapper_0/dig_in[22] slot13_wrapper_0/dig_in[21]
+ slot13_wrapper_0/dig_in[20] slot13_wrapper_0/dig_in[19] slot13_wrapper_0/dig_in[18]
+ slot13_wrapper_0/dig_in[17] slot13_wrapper_0/dig_in[16] slot13_wrapper_0/dig_in[15]
+ slot13_wrapper_0/dig_in[14] slot13_wrapper_0/dig_in[13] slot13_wrapper_0/dig_in[12]
+ slot13_wrapper_0/dig_in[11] slot13_wrapper_0/dig_in[10] slot13_wrapper_0/dig_in[9]
+ slot13_wrapper_0/dig_in[8] slot13_wrapper_0/dig_in[7] slot13_wrapper_0/dig_in[6]
+ slot13_wrapper_0/dig_in[5] slot13_wrapper_0/dig_in[4] slot13_wrapper_0/dig_in[3]
+ slot13_wrapper_0/dig_in[2] slot13_wrapper_0/dig_in[1] slot13_wrapper_0/dig_in[0]
+ slot13_wrapper_0/dig_out[11] slot13_wrapper_0/dig_out[10] slot13_wrapper_0/dig_out[9]
+ slot13_wrapper_0/dig_out[8] slot13_wrapper_0/dig_out[7] slot13_wrapper_0/dig_out[6]
+ slot13_wrapper_0/dig_out[5] slot13_wrapper_0/dig_out[4] slot13_wrapper_0/dig_out[3]
+ slot13_wrapper_0/dig_out[2] slot13_wrapper_0/dig_out[1] slot13_wrapper_0/dig_out[0]
+ slot13_wrapper_0/ibias0 slot13_wrapper_0/ibias1 slot13_wrapper_0/analog_bus3 slot13_wrapper_0/analog_bus2
+ slot13_wrapper_0/analog_bus1 slot13_wrapper_0/analog_bus0 sub slot13_wrapper_0/vdd_1v2
+ sub slot13_wrapper_0/vdd_3v3 slot13_wrapper_0/enable slot13_wrapper_0/clk slot13_wrapper_0/reset
+ slot13_wrapper
Xproject_control_area_11 slot4_wrapper_0/dig_in[20] analog_switch_array_7[3]/analog_switch_med_18/enable
+ analog_switch_array_7[3]/analog_switch_med_17/enable slot4_wrapper_0/dig_out[7]
+ housekeeping_top_0/proj_sel[2] project_control_area_9/user_project_control_0/dig_out[0]
+ slot4_wrapper_0/dig_in[2] slot4_wrapper_0/dig_in[21] housekeeping_top_0/dbus_out[22]
+ slot4_wrapper_0/dig_out[8] housekeeping_top_0/proj_sel[1] slot4_wrapper_0/dig_in[3]
+ slot4_wrapper_0/dig_in[22] slot4_wrapper_0/dig_out[9] housekeeping_top_0/analog_bus_ena[2]
+ slot4_wrapper_0/analog_bus3 slot4_wrapper_0/dig_in[4] analog_switch_array_7[3]/analog_switch_med_20/enable
+ slot4_wrapper_0/dig_in[23] project_control_area_11/user_project_control_0/dig_out[3]
+ project_control_area_11/user_project_control_0/dig_out[11] project_control_area_11/user_project_control_0/dig_out[4]
+ slot4_wrapper_0/analog_bus2 slot4_wrapper_0/dig_in[5] housekeeping_top_0/analog_bus_ena[1]
+ slot4_wrapper_0/analog_bus1 housekeeping_top_0/dbus_out[5] slot4_wrapper_0/dig_in[6]
+ housekeeping_top_0/dbus_out[21] housekeeping_top_0/dbus_out[9] project_control_area_11/user_project_control_0/dig_out[8]
+ slot4_wrapper_0/analog_bus0 project_control_area_11/user_project_control_0/dig_out[9]
+ slot4_wrapper_0/dig_in[7] project_control_area_9/user_project_control_0/dig_out[11]
+ slot4_wrapper_0/dig_in[8] analog_switch_array_7[3]/analog_pswitch_small_0/enable
+ housekeeping_top_0/proj_sel[0] housekeeping_top_0/dbus_out[1] slot4_wrapper_0/dig_in[9]
+ housekeeping_top_0/dbus_out[17] housekeeping_top_0/dbus_out[2] sub slot4_wrapper_0/dig_out[10]
+ housekeeping_top_0/proj_dig_ena slot4_wrapper_0/dig_out[11] housekeeping_top_0/dbus_out[10]
+ sub sub project_control_area_11/user_project_control_0/dig_out[5] housekeeping_top_0/proj_ibias_ena[1]
+ housekeeping_top_0/dbus_out[23] slot4_wrapper_0/ibias1 project_control_area_11/user_project_control_0/dig_out[10]
+ slot4_wrapper_0/vdd_3v3 housekeeping_top_0/dbus_out[6] slot4_wrapper_0/ibias0 slot4_wrapper_0/dig_in[10]
+ project_control_area_9/user_project_control_0/dig_out[2] housekeeping_top_0/proj_vbias_ena
+ slot4_wrapper_0/dig_in[11] vdd3v3 slot4_wrapper_0/enable project_control_area_9/user_project_control_0/dig_out[1]
+ project_control_area_9/user_project_control_0/dig_out[3] slot4_wrapper_0/dig_in[12]
+ slot4_wrapper_0/dig_in[13] housekeeping_top_0/proj_3v3_ena project_control_area_9/user_project_control_0/dig_out[4]
+ slot4_wrapper_0/vbias slot4_wrapper_0/dig_in[14] housekeeping_top_0/analog_bus_ena[3]
+ housekeeping_top_0/proj_ibias_ena[0] project_control_area_9/user_project_control_0/dig_out[5]
+ slot4_wrapper_0/dig_in[15] housekeeping_top_0/dbus_out[20] vdd1v2_uq2 housekeeping_top_0/dbus_out[19]
+ slot4_wrapper_0/dig_in[16] project_control_area_9/user_project_control_0/dig_out[6]
+ housekeeping_top_0/proj_sel[4] project_control_area_11/user_project_control_0/dig_out[6]
+ sub housekeeping_top_0/reset housekeeping_top_0/dbus_out[12] slot4_wrapper_0/dig_in[17]
+ housekeeping_top_0/analog_bus_ena[0] housekeeping_top_0/proj_1v2_ena slot4_wrapper_0/dig_in[18]
+ housekeeping_top_0/proj_ena slot4_wrapper_0/dig_in[19] vdd1v2_uq2 project_control_area_9/user_project_control_0/dig_out[9]
+ vdd3v3 housekeeping_top_0/dbus_out[14] analog_switch_array_7[3]/analog_pswitch_small_1/enable
+ project_control_area_9/user_project_control_0/dig_out[10] housekeeping_top_0/dbus_out[16]
+ housekeeping_top_0/dbus_out[18] slot4_wrapper_0/dig_out[0] housekeeping_top_0/clk_out
+ slot4_wrapper_0/reset slot4_wrapper_0/dig_out[1] project_control_area_11/user_project_control_0/dig_out[2]
+ housekeeping_top_0/dbus_out[0] slot4_wrapper_0/dig_out[2] project_control_area_11/user_project_control_0/dig_out[7]
+ project_control_area_11/user_project_control_0/dig_out[0] slot4_wrapper_0/clk project_control_area_11/user_project_control_0/dig_out[1]
+ housekeeping_top_0/dbus_out[7] slot4_wrapper_0/dig_out[3] housekeeping_top_0/dbus_out[8]
+ housekeeping_top_0/dbus_out[11] project_control_area_9/user_project_control_0/dig_out[7]
+ slot4_wrapper_0/dig_out[4] housekeeping_top_0/dbus_out[3] analog_switch_array_7[3]/analog_switch_small_0/enable
+ housekeeping_top_0/proj_sel[3] slot4_wrapper_0/dig_out[5] project_control_area_9/user_project_control_0/dig_out[8]
+ housekeeping_top_0/dbus_out[4] slot4_wrapper_0/dig_in[0] housekeeping_top_0/dbus_out[15]
+ sub analog_switch_array_7[3]/analog_switch_med_22/enable housekeeping_top_0/dbus_out[13]
+ slot4_wrapper_0/dig_out[6] sub slot4_wrapper_0/vdd_1v2 vdd1v2_uq2 sub slot4_wrapper_0/dig_in[1]
+ project_control_area
Xproject_control_area_12 slot16_wrapper_0/dig_in[20] analog_switch_array_7[2]/analog_switch_med_1/enable
+ analog_switch_array_7[2]/analog_switch_med_0/enable slot16_wrapper_0/dig_out[7]
+ housekeeping_top_0/proj_sel[2] project_control_area_10/user_project_control_0/dig_out[0]
+ slot16_wrapper_0/dig_in[2] slot16_wrapper_0/dig_in[21] housekeeping_top_0/dbus_out[22]
+ slot16_wrapper_0/dig_out[8] housekeeping_top_0/proj_sel[1] slot16_wrapper_0/dig_in[3]
+ slot16_wrapper_0/dig_in[22] slot16_wrapper_0/dig_out[9] housekeeping_top_0/analog_bus_ena[2]
+ slot16_wrapper_0/analog_bus3 slot16_wrapper_0/dig_in[4] analog_switch_array_7[2]/analog_switch_med_2/enable
+ slot16_wrapper_0/dig_in[23] project_control_area_12/user_project_control_0/dig_out[3]
+ project_control_area_12/user_project_control_0/dig_out[11] project_control_area_12/user_project_control_0/dig_out[4]
+ slot16_wrapper_0/analog_bus2 slot16_wrapper_0/dig_in[5] housekeeping_top_0/analog_bus_ena[1]
+ slot16_wrapper_0/analog_bus1 housekeeping_top_0/dbus_out[5] slot16_wrapper_0/dig_in[6]
+ housekeeping_top_0/dbus_out[21] housekeeping_top_0/dbus_out[9] project_control_area_12/user_project_control_0/dig_out[8]
+ slot16_wrapper_0/analog_bus0 project_control_area_12/user_project_control_0/dig_out[9]
+ slot16_wrapper_0/dig_in[7] project_control_area_10/user_project_control_0/dig_out[11]
+ slot16_wrapper_0/dig_in[8] analog_switch_array_7[2]/analog_pswitch_small_3/enable
+ housekeeping_top_0/proj_sel[0] housekeeping_top_0/dbus_out[1] slot16_wrapper_0/dig_in[9]
+ housekeeping_top_0/dbus_out[17] housekeeping_top_0/dbus_out[2] sub slot16_wrapper_0/dig_out[10]
+ housekeeping_top_0/proj_dig_ena slot16_wrapper_0/dig_out[11] housekeeping_top_0/dbus_out[10]
+ sub sub project_control_area_12/user_project_control_0/dig_out[5] housekeeping_top_0/proj_ibias_ena[1]
+ housekeeping_top_0/dbus_out[23] slot16_wrapper_0/ibias1 project_control_area_12/user_project_control_0/dig_out[10]
+ slot16_wrapper_0/vdd_3v3 housekeeping_top_0/dbus_out[6] slot16_wrapper_0/ibias0
+ slot16_wrapper_0/dig_in[10] project_control_area_10/user_project_control_0/dig_out[2]
+ housekeeping_top_0/proj_vbias_ena slot16_wrapper_0/dig_in[11] vdd3v3 slot16_wrapper_0/enable
+ project_control_area_10/user_project_control_0/dig_out[1] project_control_area_10/user_project_control_0/dig_out[3]
+ slot16_wrapper_0/dig_in[12] slot16_wrapper_0/dig_in[13] housekeeping_top_0/proj_3v3_ena
+ project_control_area_10/user_project_control_0/dig_out[4] slot16_wrapper_0/vbias
+ slot16_wrapper_0/dig_in[14] housekeeping_top_0/analog_bus_ena[3] housekeeping_top_0/proj_ibias_ena[0]
+ project_control_area_10/user_project_control_0/dig_out[5] slot16_wrapper_0/dig_in[15]
+ housekeeping_top_0/dbus_out[20] vdd1v2_uq2 housekeeping_top_0/dbus_out[19] slot16_wrapper_0/dig_in[16]
+ project_control_area_10/user_project_control_0/dig_out[6] housekeeping_top_0/proj_sel[4]
+ project_control_area_12/user_project_control_0/dig_out[6] sub housekeeping_top_0/reset
+ housekeeping_top_0/dbus_out[12] slot16_wrapper_0/dig_in[17] housekeeping_top_0/analog_bus_ena[0]
+ housekeeping_top_0/proj_1v2_ena slot16_wrapper_0/dig_in[18] housekeeping_top_0/proj_ena
+ slot16_wrapper_0/dig_in[19] vdd1v2_uq2 project_control_area_10/user_project_control_0/dig_out[9]
+ vdd3v3 housekeeping_top_0/dbus_out[14] analog_switch_array_7[2]/analog_pswitch_small_2/enable
+ project_control_area_10/user_project_control_0/dig_out[10] housekeeping_top_0/dbus_out[16]
+ housekeeping_top_0/dbus_out[18] slot16_wrapper_0/dig_out[0] housekeeping_top_0/clk_out
+ slot16_wrapper_0/reset slot16_wrapper_0/dig_out[1] project_control_area_12/user_project_control_0/dig_out[2]
+ housekeeping_top_0/dbus_out[0] slot16_wrapper_0/dig_out[2] project_control_area_12/user_project_control_0/dig_out[7]
+ project_control_area_12/user_project_control_0/dig_out[0] slot16_wrapper_0/clk project_control_area_12/user_project_control_0/dig_out[1]
+ housekeeping_top_0/dbus_out[7] slot16_wrapper_0/dig_out[3] housekeeping_top_0/dbus_out[8]
+ housekeeping_top_0/dbus_out[11] project_control_area_10/user_project_control_0/dig_out[7]
+ slot16_wrapper_0/dig_out[4] housekeeping_top_0/dbus_out[3] analog_switch_array_7[2]/analog_switch_small_1/enable
+ housekeeping_top_0/proj_sel[3] slot16_wrapper_0/dig_out[5] project_control_area_10/user_project_control_0/dig_out[8]
+ housekeeping_top_0/dbus_out[4] slot16_wrapper_0/dig_in[0] housekeeping_top_0/dbus_out[15]
+ vdd1v2_uq2 analog_switch_array_7[2]/analog_switch_med_3/enable housekeeping_top_0/dbus_out[13]
+ slot16_wrapper_0/dig_out[6] sub slot16_wrapper_0/vdd_1v2 sub sub slot16_wrapper_0/dig_in[1]
+ project_control_area
Xslot17_wrapper_0 s17_an[0] s17_an[1] s17_an_0_esd s17_an_1_esd s17_an[0] s17_an[1]
+ slot17_wrapper_0/vbias slot17_wrapper_0/dig_in[23] slot17_wrapper_0/dig_in[22] slot17_wrapper_0/dig_in[21]
+ slot17_wrapper_0/dig_in[20] slot17_wrapper_0/dig_in[19] slot17_wrapper_0/dig_in[18]
+ slot17_wrapper_0/dig_in[17] slot17_wrapper_0/dig_in[16] slot17_wrapper_0/dig_in[15]
+ slot17_wrapper_0/dig_in[14] slot17_wrapper_0/dig_in[13] slot17_wrapper_0/dig_in[12]
+ slot17_wrapper_0/dig_in[11] slot17_wrapper_0/dig_in[10] slot17_wrapper_0/dig_in[9]
+ slot17_wrapper_0/dig_in[8] slot17_wrapper_0/dig_in[7] slot17_wrapper_0/dig_in[6]
+ slot17_wrapper_0/dig_in[5] slot17_wrapper_0/dig_in[4] slot17_wrapper_0/dig_in[3]
+ slot17_wrapper_0/dig_in[2] slot17_wrapper_0/dig_in[1] slot17_wrapper_0/dig_in[0]
+ slot17_wrapper_0/dig_out[11] slot17_wrapper_0/dig_out[10] slot17_wrapper_0/dig_out[9]
+ slot17_wrapper_0/dig_out[8] slot17_wrapper_0/dig_out[7] slot17_wrapper_0/dig_out[6]
+ slot17_wrapper_0/dig_out[5] slot17_wrapper_0/dig_out[4] slot17_wrapper_0/dig_out[3]
+ slot17_wrapper_0/dig_out[2] slot17_wrapper_0/dig_out[1] slot17_wrapper_0/dig_out[0]
+ slot17_wrapper_0/ibias0 slot17_wrapper_0/ibias1 slot17_wrapper_0/analog_bus3 slot17_wrapper_0/analog_bus2
+ slot17_wrapper_0/analog_bus1 slot17_wrapper_0/analog_bus0 sub slot17_wrapper_0/vdd_1v2
+ sub slot17_wrapper_0/vdd_3v3 slot17_wrapper_0/enable slot17_wrapper_0/clk slot17_wrapper_0/reset
+ slot17_wrapper
Xanalog_switch_small_0 analog_switch_small_0/in analog[3] sub analog_switch_small_1/enable
+ vdd3v3 vdd1v2_uq2 sub analog_switch_small
Xproject_control_area_13 slot3_wrapper_0/dig_in[20] analog_switch_array_7[2]/analog_switch_med_18/enable
+ analog_switch_array_7[2]/analog_switch_med_17/enable slot3_wrapper_0/dig_out[7]
+ housekeeping_top_0/proj_sel[2] project_control_area_11/user_project_control_0/dig_out[0]
+ slot3_wrapper_0/dig_in[2] slot3_wrapper_0/dig_in[21] housekeeping_top_0/dbus_out[22]
+ slot3_wrapper_0/dig_out[8] housekeeping_top_0/proj_sel[1] slot3_wrapper_0/dig_in[3]
+ slot3_wrapper_0/dig_in[22] slot3_wrapper_0/dig_out[9] housekeeping_top_0/analog_bus_ena[2]
+ slot3_wrapper_0/analog_bus3 slot3_wrapper_0/dig_in[4] analog_switch_array_7[2]/analog_switch_med_20/enable
+ slot3_wrapper_0/dig_in[23] project_control_area_13/user_project_control_0/dig_out[3]
+ project_control_area_13/user_project_control_0/dig_out[11] project_control_area_13/user_project_control_0/dig_out[4]
+ slot3_wrapper_0/analog_bus2 slot3_wrapper_0/dig_in[5] housekeeping_top_0/analog_bus_ena[1]
+ slot3_wrapper_0/analog_bus1 housekeeping_top_0/dbus_out[5] slot3_wrapper_0/dig_in[6]
+ housekeeping_top_0/dbus_out[21] housekeeping_top_0/dbus_out[9] project_control_area_13/user_project_control_0/dig_out[8]
+ slot3_wrapper_0/analog_bus0 project_control_area_13/user_project_control_0/dig_out[9]
+ slot3_wrapper_0/dig_in[7] project_control_area_11/user_project_control_0/dig_out[11]
+ slot3_wrapper_0/dig_in[8] analog_switch_array_7[2]/analog_pswitch_small_0/enable
+ housekeeping_top_0/proj_sel[0] housekeeping_top_0/dbus_out[1] slot3_wrapper_0/dig_in[9]
+ housekeeping_top_0/dbus_out[17] housekeeping_top_0/dbus_out[2] vdd1v2_uq2 slot3_wrapper_0/dig_out[10]
+ housekeeping_top_0/proj_dig_ena slot3_wrapper_0/dig_out[11] housekeeping_top_0/dbus_out[10]
+ vdd1v2_uq2 sub project_control_area_13/user_project_control_0/dig_out[5] housekeeping_top_0/proj_ibias_ena[1]
+ housekeeping_top_0/dbus_out[23] slot3_wrapper_0/ibias1 project_control_area_13/user_project_control_0/dig_out[10]
+ slot3_wrapper_0/vdd_3v3 housekeeping_top_0/dbus_out[6] slot3_wrapper_0/ibias0 slot3_wrapper_0/dig_in[10]
+ project_control_area_11/user_project_control_0/dig_out[2] housekeeping_top_0/proj_vbias_ena
+ slot3_wrapper_0/dig_in[11] vdd3v3 slot3_wrapper_0/enable project_control_area_11/user_project_control_0/dig_out[1]
+ project_control_area_11/user_project_control_0/dig_out[3] slot3_wrapper_0/dig_in[12]
+ slot3_wrapper_0/dig_in[13] housekeeping_top_0/proj_3v3_ena project_control_area_11/user_project_control_0/dig_out[4]
+ slot3_wrapper_0/vbias slot3_wrapper_0/dig_in[14] housekeeping_top_0/analog_bus_ena[3]
+ housekeeping_top_0/proj_ibias_ena[0] project_control_area_11/user_project_control_0/dig_out[5]
+ slot3_wrapper_0/dig_in[15] housekeeping_top_0/dbus_out[20] vdd1v2_uq2 housekeeping_top_0/dbus_out[19]
+ slot3_wrapper_0/dig_in[16] project_control_area_11/user_project_control_0/dig_out[6]
+ housekeeping_top_0/proj_sel[4] project_control_area_13/user_project_control_0/dig_out[6]
+ sub housekeeping_top_0/reset housekeeping_top_0/dbus_out[12] slot3_wrapper_0/dig_in[17]
+ housekeeping_top_0/analog_bus_ena[0] housekeeping_top_0/proj_1v2_ena slot3_wrapper_0/dig_in[18]
+ housekeeping_top_0/proj_ena slot3_wrapper_0/dig_in[19] vdd1v2_uq2 project_control_area_11/user_project_control_0/dig_out[9]
+ vdd3v3 housekeeping_top_0/dbus_out[14] analog_switch_array_7[2]/analog_pswitch_small_1/enable
+ project_control_area_11/user_project_control_0/dig_out[10] housekeeping_top_0/dbus_out[16]
+ housekeeping_top_0/dbus_out[18] slot3_wrapper_0/dig_out[0] housekeeping_top_0/clk_out
+ slot3_wrapper_0/reset slot3_wrapper_0/dig_out[1] project_control_area_13/user_project_control_0/dig_out[2]
+ housekeeping_top_0/dbus_out[0] slot3_wrapper_0/dig_out[2] project_control_area_13/user_project_control_0/dig_out[7]
+ project_control_area_13/user_project_control_0/dig_out[0] slot3_wrapper_0/clk project_control_area_13/user_project_control_0/dig_out[1]
+ housekeeping_top_0/dbus_out[7] slot3_wrapper_0/dig_out[3] housekeeping_top_0/dbus_out[8]
+ housekeeping_top_0/dbus_out[11] project_control_area_11/user_project_control_0/dig_out[7]
+ slot3_wrapper_0/dig_out[4] housekeeping_top_0/dbus_out[3] analog_switch_array_7[2]/analog_switch_small_0/enable
+ housekeeping_top_0/proj_sel[3] slot3_wrapper_0/dig_out[5] project_control_area_11/user_project_control_0/dig_out[8]
+ housekeeping_top_0/dbus_out[4] slot3_wrapper_0/dig_in[0] housekeeping_top_0/dbus_out[15]
+ sub analog_switch_array_7[2]/analog_switch_med_22/enable housekeeping_top_0/dbus_out[13]
+ slot3_wrapper_0/dig_out[6] sub slot3_wrapper_0/vdd_1v2 sub sub slot3_wrapper_0/dig_in[1]
+ project_control_area
Xanalog_switch_small_1 analog_switch_small_1/in analog[0] sub analog_switch_small_1/enable
+ vdd3v3 vdd1v2_uq2 sub analog_switch_small
Xslot4_wrapper_0 s4_an[0] sub s4_an_0_esd slot4_wrapper_0/vbias slot4_wrapper_0/dig_in[23]
+ slot4_wrapper_0/dig_in[22] slot4_wrapper_0/dig_in[21] slot4_wrapper_0/dig_in[20]
+ slot4_wrapper_0/dig_in[19] slot4_wrapper_0/dig_in[18] slot4_wrapper_0/dig_in[17]
+ slot4_wrapper_0/dig_in[16] slot4_wrapper_0/dig_in[15] slot4_wrapper_0/dig_in[14]
+ slot4_wrapper_0/dig_in[13] slot4_wrapper_0/dig_in[12] slot4_wrapper_0/dig_in[11]
+ slot4_wrapper_0/dig_in[10] slot4_wrapper_0/dig_in[9] slot4_wrapper_0/dig_in[8] slot4_wrapper_0/dig_in[7]
+ slot4_wrapper_0/dig_in[6] slot4_wrapper_0/dig_in[5] slot4_wrapper_0/dig_in[4] slot4_wrapper_0/dig_in[3]
+ slot4_wrapper_0/dig_in[2] slot4_wrapper_0/dig_in[1] slot4_wrapper_0/dig_in[0] slot4_wrapper_0/dig_out[11]
+ slot4_wrapper_0/dig_out[10] slot4_wrapper_0/dig_out[9] slot4_wrapper_0/dig_out[8]
+ slot4_wrapper_0/dig_out[7] slot4_wrapper_0/dig_out[6] slot4_wrapper_0/dig_out[5]
+ slot4_wrapper_0/dig_out[4] slot4_wrapper_0/dig_out[3] slot4_wrapper_0/dig_out[2]
+ slot4_wrapper_0/dig_out[1] slot4_wrapper_0/dig_out[0] slot4_wrapper_0/ibias0 slot4_wrapper_0/ibias1
+ slot4_wrapper_0/analog_bus3 slot4_wrapper_0/analog_bus2 slot4_wrapper_0/analog_bus1
+ slot4_wrapper_0/analog_bus0 slot4_wrapper_0/vdd_1v2 sub slot4_wrapper_0/vdd_3v3
+ slot4_wrapper_0/enable slot4_wrapper_0/clk slot4_wrapper_0/reset slot4_wrapper
Xproject_control_area_14 slot17_wrapper_0/dig_in[20] analog_switch_array_7[1]/analog_switch_med_1/enable
+ analog_switch_array_7[1]/analog_switch_med_0/enable slot17_wrapper_0/dig_out[7]
+ housekeeping_top_0/proj_sel[2] project_control_area_12/user_project_control_0/dig_out[0]
+ slot17_wrapper_0/dig_in[2] slot17_wrapper_0/dig_in[21] housekeeping_top_0/dbus_out[22]
+ slot17_wrapper_0/dig_out[8] housekeeping_top_0/proj_sel[1] slot17_wrapper_0/dig_in[3]
+ slot17_wrapper_0/dig_in[22] slot17_wrapper_0/dig_out[9] housekeeping_top_0/analog_bus_ena[2]
+ slot17_wrapper_0/analog_bus3 slot17_wrapper_0/dig_in[4] analog_switch_array_7[1]/analog_switch_med_2/enable
+ slot17_wrapper_0/dig_in[23] project_control_area_14/user_project_control_0/dig_out[3]
+ project_control_area_14/user_project_control_0/dig_out[11] project_control_area_14/user_project_control_0/dig_out[4]
+ slot17_wrapper_0/analog_bus2 slot17_wrapper_0/dig_in[5] housekeeping_top_0/analog_bus_ena[1]
+ slot17_wrapper_0/analog_bus1 housekeeping_top_0/dbus_out[5] slot17_wrapper_0/dig_in[6]
+ housekeeping_top_0/dbus_out[21] housekeeping_top_0/dbus_out[9] project_control_area_14/user_project_control_0/dig_out[8]
+ slot17_wrapper_0/analog_bus0 project_control_area_14/user_project_control_0/dig_out[9]
+ slot17_wrapper_0/dig_in[7] project_control_area_12/user_project_control_0/dig_out[11]
+ slot17_wrapper_0/dig_in[8] analog_switch_array_7[1]/analog_pswitch_small_3/enable
+ housekeeping_top_0/proj_sel[0] housekeeping_top_0/dbus_out[1] slot17_wrapper_0/dig_in[9]
+ housekeeping_top_0/dbus_out[17] housekeeping_top_0/dbus_out[2] vdd1v2_uq2 slot17_wrapper_0/dig_out[10]
+ housekeeping_top_0/proj_dig_ena slot17_wrapper_0/dig_out[11] housekeeping_top_0/dbus_out[10]
+ sub sub project_control_area_14/user_project_control_0/dig_out[5] housekeeping_top_0/proj_ibias_ena[1]
+ housekeeping_top_0/dbus_out[23] slot17_wrapper_0/ibias1 project_control_area_14/user_project_control_0/dig_out[10]
+ slot17_wrapper_0/vdd_3v3 housekeeping_top_0/dbus_out[6] slot17_wrapper_0/ibias0
+ slot17_wrapper_0/dig_in[10] project_control_area_12/user_project_control_0/dig_out[2]
+ housekeeping_top_0/proj_vbias_ena slot17_wrapper_0/dig_in[11] vdd3v3 slot17_wrapper_0/enable
+ project_control_area_12/user_project_control_0/dig_out[1] project_control_area_12/user_project_control_0/dig_out[3]
+ slot17_wrapper_0/dig_in[12] slot17_wrapper_0/dig_in[13] housekeeping_top_0/proj_3v3_ena
+ project_control_area_12/user_project_control_0/dig_out[4] slot17_wrapper_0/vbias
+ slot17_wrapper_0/dig_in[14] housekeeping_top_0/analog_bus_ena[3] housekeeping_top_0/proj_ibias_ena[0]
+ project_control_area_12/user_project_control_0/dig_out[5] slot17_wrapper_0/dig_in[15]
+ housekeeping_top_0/dbus_out[20] vdd1v2_uq2 housekeeping_top_0/dbus_out[19] slot17_wrapper_0/dig_in[16]
+ project_control_area_12/user_project_control_0/dig_out[6] housekeeping_top_0/proj_sel[4]
+ project_control_area_14/user_project_control_0/dig_out[6] sub housekeeping_top_0/reset
+ housekeeping_top_0/dbus_out[12] slot17_wrapper_0/dig_in[17] housekeeping_top_0/analog_bus_ena[0]
+ housekeeping_top_0/proj_1v2_ena slot17_wrapper_0/dig_in[18] housekeeping_top_0/proj_ena
+ slot17_wrapper_0/dig_in[19] vdd1v2_uq2 project_control_area_12/user_project_control_0/dig_out[9]
+ vdd3v3 housekeeping_top_0/dbus_out[14] analog_switch_array_7[1]/analog_pswitch_small_2/enable
+ project_control_area_12/user_project_control_0/dig_out[10] housekeeping_top_0/dbus_out[16]
+ housekeeping_top_0/dbus_out[18] slot17_wrapper_0/dig_out[0] housekeeping_top_0/clk_out
+ slot17_wrapper_0/reset slot17_wrapper_0/dig_out[1] project_control_area_14/user_project_control_0/dig_out[2]
+ housekeeping_top_0/dbus_out[0] slot17_wrapper_0/dig_out[2] project_control_area_14/user_project_control_0/dig_out[7]
+ project_control_area_14/user_project_control_0/dig_out[0] slot17_wrapper_0/clk project_control_area_14/user_project_control_0/dig_out[1]
+ housekeeping_top_0/dbus_out[7] slot17_wrapper_0/dig_out[3] housekeeping_top_0/dbus_out[8]
+ housekeeping_top_0/dbus_out[11] project_control_area_12/user_project_control_0/dig_out[7]
+ slot17_wrapper_0/dig_out[4] housekeeping_top_0/dbus_out[3] analog_switch_array_7[1]/analog_switch_small_1/enable
+ housekeeping_top_0/proj_sel[3] slot17_wrapper_0/dig_out[5] project_control_area_12/user_project_control_0/dig_out[8]
+ housekeeping_top_0/dbus_out[4] slot17_wrapper_0/dig_in[0] housekeeping_top_0/dbus_out[15]
+ vdd1v2_uq2 analog_switch_array_7[1]/analog_switch_med_3/enable housekeeping_top_0/dbus_out[13]
+ slot17_wrapper_0/dig_out[6] sub slot17_wrapper_0/vdd_1v2 sub sub slot17_wrapper_0/dig_in[1]
+ project_control_area
Xproject_control_area_15 slot2_wrapper_0/dig_in[20] analog_switch_array_7[1]/analog_switch_med_18/enable
+ analog_switch_array_7[1]/analog_switch_med_17/enable slot2_wrapper_0/dig_out[7]
+ housekeeping_top_0/proj_sel[2] project_control_area_13/user_project_control_0/dig_out[0]
+ slot2_wrapper_0/dig_in[2] slot2_wrapper_0/dig_in[21] housekeeping_top_0/dbus_out[22]
+ slot2_wrapper_0/dig_out[8] housekeeping_top_0/proj_sel[1] slot2_wrapper_0/dig_in[3]
+ slot2_wrapper_0/dig_in[22] slot2_wrapper_0/dig_out[9] housekeeping_top_0/analog_bus_ena[2]
+ slot2_wrapper_0/analog_bus3 slot2_wrapper_0/dig_in[4] analog_switch_array_7[1]/analog_switch_med_20/enable
+ slot2_wrapper_0/dig_in[23] project_control_area_15/user_project_control_0/dig_out[3]
+ project_control_area_15/user_project_control_0/dig_out[11] project_control_area_15/user_project_control_0/dig_out[4]
+ slot2_wrapper_0/analog_bus2 slot2_wrapper_0/dig_in[5] housekeeping_top_0/analog_bus_ena[1]
+ slot2_wrapper_0/analog_bus1 housekeeping_top_0/dbus_out[5] slot2_wrapper_0/dig_in[6]
+ housekeeping_top_0/dbus_out[21] housekeeping_top_0/dbus_out[9] project_control_area_15/user_project_control_0/dig_out[8]
+ slot2_wrapper_0/analog_bus0 project_control_area_15/user_project_control_0/dig_out[9]
+ slot2_wrapper_0/dig_in[7] project_control_area_13/user_project_control_0/dig_out[11]
+ slot2_wrapper_0/dig_in[8] analog_switch_array_7[1]/analog_pswitch_small_0/enable
+ housekeeping_top_0/proj_sel[0] housekeeping_top_0/dbus_out[1] slot2_wrapper_0/dig_in[9]
+ housekeeping_top_0/dbus_out[17] housekeeping_top_0/dbus_out[2] sub slot2_wrapper_0/dig_out[10]
+ housekeeping_top_0/proj_dig_ena slot2_wrapper_0/dig_out[11] housekeeping_top_0/dbus_out[10]
+ vdd1v2_uq2 sub project_control_area_15/user_project_control_0/dig_out[5] housekeeping_top_0/proj_ibias_ena[1]
+ housekeeping_top_0/dbus_out[23] slot2_wrapper_0/ibias1 project_control_area_15/user_project_control_0/dig_out[10]
+ slot2_wrapper_0/vdd_3v3 housekeeping_top_0/dbus_out[6] slot2_wrapper_0/ibias0 slot2_wrapper_0/dig_in[10]
+ project_control_area_13/user_project_control_0/dig_out[2] housekeeping_top_0/proj_vbias_ena
+ slot2_wrapper_0/dig_in[11] vdd3v3 slot2_wrapper_0/enable project_control_area_13/user_project_control_0/dig_out[1]
+ project_control_area_13/user_project_control_0/dig_out[3] slot2_wrapper_0/dig_in[12]
+ slot2_wrapper_0/dig_in[13] housekeeping_top_0/proj_3v3_ena project_control_area_13/user_project_control_0/dig_out[4]
+ slot2_wrapper_0/vbias slot2_wrapper_0/dig_in[14] housekeeping_top_0/analog_bus_ena[3]
+ housekeeping_top_0/proj_ibias_ena[0] project_control_area_13/user_project_control_0/dig_out[5]
+ slot2_wrapper_0/dig_in[15] housekeeping_top_0/dbus_out[20] vdd1v2_uq2 housekeeping_top_0/dbus_out[19]
+ slot2_wrapper_0/dig_in[16] project_control_area_13/user_project_control_0/dig_out[6]
+ housekeeping_top_0/proj_sel[4] project_control_area_15/user_project_control_0/dig_out[6]
+ sub housekeeping_top_0/reset housekeeping_top_0/dbus_out[12] slot2_wrapper_0/dig_in[17]
+ housekeeping_top_0/analog_bus_ena[0] housekeeping_top_0/proj_1v2_ena slot2_wrapper_0/dig_in[18]
+ housekeeping_top_0/proj_ena slot2_wrapper_0/dig_in[19] vdd1v2_uq2 project_control_area_13/user_project_control_0/dig_out[9]
+ vdd3v3 housekeeping_top_0/dbus_out[14] analog_switch_array_7[1]/analog_pswitch_small_1/enable
+ project_control_area_13/user_project_control_0/dig_out[10] housekeeping_top_0/dbus_out[16]
+ housekeeping_top_0/dbus_out[18] slot2_wrapper_0/dig_out[0] housekeeping_top_0/clk_out
+ slot2_wrapper_0/reset slot2_wrapper_0/dig_out[1] project_control_area_15/user_project_control_0/dig_out[2]
+ housekeeping_top_0/dbus_out[0] slot2_wrapper_0/dig_out[2] project_control_area_15/user_project_control_0/dig_out[7]
+ project_control_area_15/user_project_control_0/dig_out[0] slot2_wrapper_0/clk project_control_area_15/user_project_control_0/dig_out[1]
+ housekeeping_top_0/dbus_out[7] slot2_wrapper_0/dig_out[3] housekeeping_top_0/dbus_out[8]
+ housekeeping_top_0/dbus_out[11] project_control_area_13/user_project_control_0/dig_out[7]
+ slot2_wrapper_0/dig_out[4] housekeeping_top_0/dbus_out[3] analog_switch_array_7[1]/analog_switch_small_0/enable
+ housekeeping_top_0/proj_sel[3] slot2_wrapper_0/dig_out[5] project_control_area_13/user_project_control_0/dig_out[8]
+ housekeeping_top_0/dbus_out[4] slot2_wrapper_0/dig_in[0] housekeeping_top_0/dbus_out[15]
+ sub analog_switch_array_7[1]/analog_switch_med_22/enable housekeeping_top_0/dbus_out[13]
+ slot2_wrapper_0/dig_out[6] sub slot2_wrapper_0/vdd_1v2 sub sub slot2_wrapper_0/dig_in[1]
+ project_control_area
Xslot8_wrapper_0 sub s8_an[0] s8_an_0_esd slot8_wrapper_0/vbias slot8_wrapper_0/dig_in[23]
+ slot8_wrapper_0/dig_in[22] slot8_wrapper_0/dig_in[21] slot8_wrapper_0/dig_in[20]
+ slot8_wrapper_0/dig_in[19] slot8_wrapper_0/dig_in[18] slot8_wrapper_0/dig_in[17]
+ slot8_wrapper_0/dig_in[16] slot8_wrapper_0/dig_in[15] slot8_wrapper_0/dig_in[14]
+ slot8_wrapper_0/dig_in[13] slot8_wrapper_0/dig_in[12] slot8_wrapper_0/dig_in[11]
+ slot8_wrapper_0/dig_in[10] slot8_wrapper_0/dig_in[9] slot8_wrapper_0/dig_in[8] slot8_wrapper_0/dig_in[7]
+ slot8_wrapper_0/dig_in[6] slot8_wrapper_0/dig_in[5] slot8_wrapper_0/dig_in[4] slot8_wrapper_0/dig_in[3]
+ slot8_wrapper_0/dig_in[2] slot8_wrapper_0/dig_in[1] slot8_wrapper_0/dig_in[0] slot8_wrapper_0/dig_out[11]
+ slot8_wrapper_0/dig_out[10] slot8_wrapper_0/dig_out[9] slot8_wrapper_0/dig_out[8]
+ slot8_wrapper_0/dig_out[7] slot8_wrapper_0/dig_out[6] slot8_wrapper_0/dig_out[5]
+ slot8_wrapper_0/dig_out[4] slot8_wrapper_0/dig_out[3] slot8_wrapper_0/dig_out[2]
+ slot8_wrapper_0/dig_out[1] slot8_wrapper_0/dig_out[0] slot8_wrapper_0/ibias0 slot8_wrapper_0/ibias1
+ slot8_wrapper_0/analog_bus3 slot8_wrapper_0/analog_bus2 slot8_wrapper_0/analog_bus1
+ slot8_wrapper_0/analog_bus0 sub slot8_wrapper_0/vdd_1v2 slot8_wrapper_0/vdd_3v3
+ slot8_wrapper_0/enable slot8_wrapper_0/clk slot8_wrapper_0/reset slot8_wrapper
Xproject_control_area_16 slot18_wrapper_0/dig_in[20] analog_switch_array_7[0]/analog_switch_med_1/enable
+ analog_switch_array_7[0]/analog_switch_med_0/enable slot18_wrapper_0/dig_out[7]
+ housekeeping_top_0/proj_sel[2] project_control_area_14/user_project_control_0/dig_out[0]
+ slot18_wrapper_0/dig_in[2] slot18_wrapper_0/dig_in[21] housekeeping_top_0/dbus_out[22]
+ slot18_wrapper_0/dig_out[8] housekeeping_top_0/proj_sel[1] slot18_wrapper_0/dig_in[3]
+ slot18_wrapper_0/dig_in[22] slot18_wrapper_0/dig_out[9] housekeeping_top_0/analog_bus_ena[2]
+ slot18_wrapper_0/analog_bus3 slot18_wrapper_0/dig_in[4] analog_switch_array_7[0]/analog_switch_med_2/enable
+ slot18_wrapper_0/dig_in[23] housekeeping_top_0/dbus_in_left[3] housekeeping_top_0/dbus_in_left[11]
+ housekeeping_top_0/dbus_in_left[4] slot18_wrapper_0/analog_bus2 slot18_wrapper_0/dig_in[5]
+ housekeeping_top_0/analog_bus_ena[1] slot18_wrapper_0/analog_bus1 housekeeping_top_0/dbus_out[5]
+ slot18_wrapper_0/dig_in[6] housekeeping_top_0/dbus_out[21] housekeeping_top_0/dbus_out[9]
+ housekeeping_top_0/dbus_in_left[8] slot18_wrapper_0/analog_bus0 housekeeping_top_0/dbus_in_left[9]
+ slot18_wrapper_0/dig_in[7] project_control_area_14/user_project_control_0/dig_out[11]
+ slot18_wrapper_0/dig_in[8] analog_switch_array_7[0]/analog_pswitch_small_3/enable
+ housekeeping_top_0/proj_sel[0] housekeeping_top_0/dbus_out[1] slot18_wrapper_0/dig_in[9]
+ housekeeping_top_0/dbus_out[17] housekeeping_top_0/dbus_out[2] sub slot18_wrapper_0/dig_out[10]
+ housekeeping_top_0/proj_dig_ena slot18_wrapper_0/dig_out[11] housekeeping_top_0/dbus_out[10]
+ vdd1v2_uq2 sub housekeeping_top_0/dbus_in_left[5] housekeeping_top_0/proj_ibias_ena[1]
+ housekeeping_top_0/dbus_out[23] slot18_wrapper_0/ibias1 housekeeping_top_0/dbus_in_left[10]
+ slot18_wrapper_0/vdd_3v3 housekeeping_top_0/dbus_out[6] slot18_wrapper_0/ibias0
+ slot18_wrapper_0/dig_in[10] project_control_area_14/user_project_control_0/dig_out[2]
+ housekeeping_top_0/proj_vbias_ena slot18_wrapper_0/dig_in[11] vdd3v3 slot18_wrapper_0/enable
+ project_control_area_14/user_project_control_0/dig_out[1] project_control_area_14/user_project_control_0/dig_out[3]
+ slot18_wrapper_0/dig_in[12] slot18_wrapper_0/dig_in[13] housekeeping_top_0/proj_3v3_ena
+ project_control_area_14/user_project_control_0/dig_out[4] slot18_wrapper_0/vbias
+ slot18_wrapper_0/dig_in[14] housekeeping_top_0/analog_bus_ena[3] housekeeping_top_0/proj_ibias_ena[0]
+ project_control_area_14/user_project_control_0/dig_out[5] slot18_wrapper_0/dig_in[15]
+ housekeeping_top_0/dbus_out[20] vdd1v2_uq2 housekeeping_top_0/dbus_out[19] slot18_wrapper_0/dig_in[16]
+ project_control_area_14/user_project_control_0/dig_out[6] housekeeping_top_0/proj_sel[4]
+ housekeeping_top_0/dbus_in_left[6] sub housekeeping_top_0/reset housekeeping_top_0/dbus_out[12]
+ slot18_wrapper_0/dig_in[17] housekeeping_top_0/analog_bus_ena[0] housekeeping_top_0/proj_1v2_ena
+ slot18_wrapper_0/dig_in[18] housekeeping_top_0/proj_ena slot18_wrapper_0/dig_in[19]
+ vdd1v2_uq2 project_control_area_14/user_project_control_0/dig_out[9] vdd3v3 housekeeping_top_0/dbus_out[14]
+ analog_switch_array_7[0]/analog_pswitch_small_2/enable project_control_area_14/user_project_control_0/dig_out[10]
+ housekeeping_top_0/dbus_out[16] housekeeping_top_0/dbus_out[18] slot18_wrapper_0/dig_out[0]
+ housekeeping_top_0/clk_out slot18_wrapper_0/reset slot18_wrapper_0/dig_out[1] housekeeping_top_0/dbus_in_left[2]
+ housekeeping_top_0/dbus_out[0] slot18_wrapper_0/dig_out[2] housekeeping_top_0/dbus_in_left[7]
+ housekeeping_top_0/dbus_in_left[0] slot18_wrapper_0/clk housekeeping_top_0/dbus_in_left[1]
+ housekeeping_top_0/dbus_out[7] slot18_wrapper_0/dig_out[3] housekeeping_top_0/dbus_out[8]
+ housekeeping_top_0/dbus_out[11] project_control_area_14/user_project_control_0/dig_out[7]
+ slot18_wrapper_0/dig_out[4] housekeeping_top_0/dbus_out[3] analog_switch_array_7[0]/analog_switch_small_1/enable
+ housekeeping_top_0/proj_sel[3] slot18_wrapper_0/dig_out[5] project_control_area_14/user_project_control_0/dig_out[8]
+ housekeeping_top_0/dbus_out[4] slot18_wrapper_0/dig_in[0] housekeeping_top_0/dbus_out[15]
+ vdd1v2_uq2 analog_switch_array_7[0]/analog_switch_med_3/enable housekeeping_top_0/dbus_out[13]
+ slot18_wrapper_0/dig_out[6] sub slot18_wrapper_0/vdd_1v2 sub sub slot18_wrapper_0/dig_in[1]
+ project_control_area
Xproject_control_area_17 slot1_wrapper_0/dig_in[20] analog_switch_array_7[0]/analog_switch_med_18/enable
+ analog_switch_array_7[0]/analog_switch_med_17/enable slot1_wrapper_0/dig_out[7]
+ housekeeping_top_0/proj_sel[2] project_control_area_15/user_project_control_0/dig_out[0]
+ slot1_wrapper_0/dig_in[2] slot1_wrapper_0/dig_in[21] housekeeping_top_0/dbus_out[22]
+ slot1_wrapper_0/dig_out[8] housekeeping_top_0/proj_sel[1] slot1_wrapper_0/dig_in[3]
+ slot1_wrapper_0/dig_in[22] slot1_wrapper_0/dig_out[9] housekeeping_top_0/analog_bus_ena[2]
+ slot1_wrapper_0/analog_bus3 slot1_wrapper_0/dig_in[4] analog_switch_array_7[0]/analog_switch_med_20/enable
+ slot1_wrapper_0/dig_in[23] housekeeping_top_0/dbus_in_right[3] housekeeping_top_0/dbus_in_right[11]
+ housekeeping_top_0/dbus_in_right[4] slot1_wrapper_0/analog_bus2 slot1_wrapper_0/dig_in[5]
+ housekeeping_top_0/analog_bus_ena[1] slot1_wrapper_0/analog_bus1 housekeeping_top_0/dbus_out[5]
+ slot1_wrapper_0/dig_in[6] housekeeping_top_0/dbus_out[21] housekeeping_top_0/dbus_out[9]
+ housekeeping_top_0/dbus_in_right[8] slot1_wrapper_0/analog_bus0 housekeeping_top_0/dbus_in_right[9]
+ slot1_wrapper_0/dig_in[7] project_control_area_15/user_project_control_0/dig_out[11]
+ slot1_wrapper_0/dig_in[8] analog_switch_array_7[0]/analog_pswitch_small_0/enable
+ housekeeping_top_0/proj_sel[0] housekeeping_top_0/dbus_out[1] slot1_wrapper_0/dig_in[9]
+ housekeeping_top_0/dbus_out[17] housekeeping_top_0/dbus_out[2] vdd1v2_uq2 slot1_wrapper_0/dig_out[10]
+ housekeeping_top_0/proj_dig_ena slot1_wrapper_0/dig_out[11] housekeeping_top_0/dbus_out[10]
+ sub sub housekeeping_top_0/dbus_in_right[5] housekeeping_top_0/proj_ibias_ena[1]
+ housekeeping_top_0/dbus_out[23] slot1_wrapper_0/ibias1 housekeeping_top_0/dbus_in_right[10]
+ slot1_wrapper_0/vdd_3v3 housekeeping_top_0/dbus_out[6] slot1_wrapper_0/ibias0 slot1_wrapper_0/dig_in[10]
+ project_control_area_15/user_project_control_0/dig_out[2] housekeeping_top_0/proj_vbias_ena
+ slot1_wrapper_0/dig_in[11] vdd3v3 slot1_wrapper_0/enable project_control_area_15/user_project_control_0/dig_out[1]
+ project_control_area_15/user_project_control_0/dig_out[3] slot1_wrapper_0/dig_in[12]
+ slot1_wrapper_0/dig_in[13] housekeeping_top_0/proj_3v3_ena project_control_area_15/user_project_control_0/dig_out[4]
+ slot1_wrapper_0/vbias slot1_wrapper_0/dig_in[14] housekeeping_top_0/analog_bus_ena[3]
+ housekeeping_top_0/proj_ibias_ena[0] project_control_area_15/user_project_control_0/dig_out[5]
+ slot1_wrapper_0/dig_in[15] housekeeping_top_0/dbus_out[20] vdd1v2_uq2 housekeeping_top_0/dbus_out[19]
+ slot1_wrapper_0/dig_in[16] project_control_area_15/user_project_control_0/dig_out[6]
+ housekeeping_top_0/proj_sel[4] housekeeping_top_0/dbus_in_right[6] sub housekeeping_top_0/reset
+ housekeeping_top_0/dbus_out[12] slot1_wrapper_0/dig_in[17] housekeeping_top_0/analog_bus_ena[0]
+ housekeeping_top_0/proj_1v2_ena slot1_wrapper_0/dig_in[18] housekeeping_top_0/proj_ena
+ slot1_wrapper_0/dig_in[19] vdd1v2_uq2 project_control_area_15/user_project_control_0/dig_out[9]
+ vdd3v3 housekeeping_top_0/dbus_out[14] analog_switch_array_7[0]/analog_pswitch_small_1/enable
+ project_control_area_15/user_project_control_0/dig_out[10] housekeeping_top_0/dbus_out[16]
+ housekeeping_top_0/dbus_out[18] slot1_wrapper_0/dig_out[0] housekeeping_top_0/clk_out
+ slot1_wrapper_0/reset slot1_wrapper_0/dig_out[1] housekeeping_top_0/dbus_in_right[2]
+ housekeeping_top_0/dbus_out[0] slot1_wrapper_0/dig_out[2] housekeeping_top_0/dbus_in_right[7]
+ housekeeping_top_0/dbus_in_right[0] slot1_wrapper_0/clk housekeeping_top_0/dbus_in_right[1]
+ housekeeping_top_0/dbus_out[7] slot1_wrapper_0/dig_out[3] housekeeping_top_0/dbus_out[8]
+ housekeeping_top_0/dbus_out[11] project_control_area_15/user_project_control_0/dig_out[7]
+ slot1_wrapper_0/dig_out[4] housekeeping_top_0/dbus_out[3] analog_switch_array_7[0]/analog_switch_small_0/enable
+ housekeeping_top_0/proj_sel[3] slot1_wrapper_0/dig_out[5] project_control_area_15/user_project_control_0/dig_out[8]
+ housekeeping_top_0/dbus_out[4] slot1_wrapper_0/dig_in[0] housekeeping_top_0/dbus_out[15]
+ sub analog_switch_array_7[0]/analog_switch_med_22/enable housekeeping_top_0/dbus_out[13]
+ slot1_wrapper_0/dig_out[6] sub slot1_wrapper_0/vdd_1v2 sub sub slot1_wrapper_0/dig_in[1]
+ project_control_area
Xsg13cmos5l_ocd_ip__classab_buffer_0 sg13cmos5l_ocd_ip__classab_buffer_0/inp sg13cmos5l_ocd_ip__classab_buffer_0/ena
+ sg13cmos5l_ocd_ip__classab_buffer_0/bias analog_switch_small_1/in sub vdd3v3 sg13cmos5l_ocd_ip__classab_buffer
Xsg13cmos5l_ocd_ip__bandgap_v3_0 analog_switch_small_0/in sg13cmos5l_ocd_ip__bandgap_v3_0/ibias1_250n
+ housekeeping_top_0/bandgap_trim[15] housekeeping_top_0/bandgap_trim[14] housekeeping_top_0/bandgap_trim[13]
+ housekeeping_top_0/bandgap_trim[12] housekeeping_top_0/bandgap_trim[11] housekeeping_top_0/bandgap_trim[10]
+ housekeeping_top_0/bandgap_trim[9] housekeeping_top_0/bandgap_trim[8] housekeeping_top_0/bandgap_trim[7]
+ housekeeping_top_0/bandgap_trim[6] housekeeping_top_0/bandgap_trim[5] housekeeping_top_0/bandgap_trim[4]
+ housekeeping_top_0/bandgap_trim[3] housekeeping_top_0/bandgap_trim[2] housekeeping_top_0/bandgap_trim[1]
+ housekeeping_top_0/bandgap_trim[0] housekeeping_top_0/bandgap_ena sg13cmos5l_ocd_ip__bandgap_v3_0/ibias2_1u
+ vdd1v2_uq2 vdd3v3 sub sub sg13cmos5l_ocd_ip__bandgap_v3
Xslot12_wrapper_0 sub s12_an[0] s12_an[1] s12_an_0_esd s12_an_1_esd slot12_wrapper_0/vbias
+ slot12_wrapper_0/dig_in[23] slot12_wrapper_0/dig_in[22] slot12_wrapper_0/dig_in[21]
+ slot12_wrapper_0/dig_in[20] slot12_wrapper_0/dig_in[19] slot12_wrapper_0/dig_in[18]
+ slot12_wrapper_0/dig_in[17] slot12_wrapper_0/dig_in[16] slot12_wrapper_0/dig_in[15]
+ slot12_wrapper_0/dig_in[14] slot12_wrapper_0/dig_in[13] slot12_wrapper_0/dig_in[12]
+ slot12_wrapper_0/dig_in[11] slot12_wrapper_0/dig_in[10] slot12_wrapper_0/dig_in[9]
+ slot12_wrapper_0/dig_in[8] slot12_wrapper_0/dig_in[7] slot12_wrapper_0/dig_in[6]
+ slot12_wrapper_0/dig_in[5] slot12_wrapper_0/dig_in[4] slot12_wrapper_0/dig_in[3]
+ slot12_wrapper_0/dig_in[2] slot12_wrapper_0/dig_in[1] slot12_wrapper_0/dig_in[0]
+ slot12_wrapper_0/dig_out[11] slot12_wrapper_0/dig_out[10] slot12_wrapper_0/dig_out[9]
+ slot12_wrapper_0/dig_out[8] slot12_wrapper_0/dig_out[7] slot12_wrapper_0/dig_out[6]
+ slot12_wrapper_0/dig_out[5] slot12_wrapper_0/dig_out[4] slot12_wrapper_0/dig_out[3]
+ slot12_wrapper_0/dig_out[2] slot12_wrapper_0/dig_out[1] slot12_wrapper_0/dig_out[0]
+ slot12_wrapper_0/ibias0 slot12_wrapper_0/ibias1 slot12_wrapper_0/analog_bus3 slot12_wrapper_0/analog_bus2
+ slot12_wrapper_0/analog_bus1 slot12_wrapper_0/analog_bus0 sub slot12_wrapper_0/vdd_1v2
+ slot12_wrapper_0/vdd_3v3 slot12_wrapper_0/enable slot12_wrapper_0/clk slot12_wrapper_0/reset
+ slot12_wrapper
Xhousekeeping_top_0 CSB_in SCK_in SDI_in SDO_out housekeeping_top_0/analog_bus_ena[0]
+ housekeeping_top_0/analog_bus_ena[1] housekeeping_top_0/analog_bus_ena[2] housekeeping_top_0/analog_bus_ena[3]
+ housekeeping_top_0/bandgap_ena housekeeping_top_0/bandgap_sink1[0] housekeeping_top_0/bandgap_sink1[1]
+ housekeeping_top_0/bandgap_sink1[2] housekeeping_top_0/bandgap_sink2[0] housekeeping_top_0/bandgap_sink2[1]
+ housekeeping_top_0/bandgap_trim[0] housekeeping_top_0/bandgap_trim[10] housekeeping_top_0/bandgap_trim[11]
+ housekeeping_top_0/bandgap_trim[12] housekeeping_top_0/bandgap_trim[13] housekeeping_top_0/bandgap_trim[14]
+ housekeeping_top_0/bandgap_trim[15] housekeeping_top_0/bandgap_trim[1] housekeeping_top_0/bandgap_trim[2]
+ housekeeping_top_0/bandgap_trim[3] housekeeping_top_0/bandgap_trim[4] housekeeping_top_0/bandgap_trim[5]
+ housekeeping_top_0/bandgap_trim[6] housekeeping_top_0/bandgap_trim[7] housekeeping_top_0/bandgap_trim[8]
+ housekeeping_top_0/bandgap_trim[9] housekeeping_top_0/biasgen_coarse housekeeping_top_0/biasgen_ena
+ housekeeping_top_0/biasgen_fine housekeeping_top_0/biasgen_ref_vbg clk_in housekeeping_top_0/clk_out
+ housekeeping_top_0/dbus_in_left[0] housekeeping_top_0/dbus_in_left[10] housekeeping_top_0/dbus_in_left[11]
+ housekeeping_top_0/dbus_in_left[1] housekeeping_top_0/dbus_in_left[2] housekeeping_top_0/dbus_in_left[3]
+ housekeeping_top_0/dbus_in_left[4] housekeeping_top_0/dbus_in_left[5] housekeeping_top_0/dbus_in_left[6]
+ housekeeping_top_0/dbus_in_left[7] housekeeping_top_0/dbus_in_left[8] housekeeping_top_0/dbus_in_left[9]
+ housekeeping_top_0/dbus_in_right[0] housekeeping_top_0/dbus_in_right[10] housekeeping_top_0/dbus_in_right[11]
+ housekeeping_top_0/dbus_in_right[1] housekeeping_top_0/dbus_in_right[2] housekeeping_top_0/dbus_in_right[3]
+ housekeeping_top_0/dbus_in_right[4] housekeeping_top_0/dbus_in_right[5] housekeeping_top_0/dbus_in_right[6]
+ housekeeping_top_0/dbus_in_right[7] housekeeping_top_0/dbus_in_right[8] housekeeping_top_0/dbus_in_right[9]
+ housekeeping_top_0/dbus_out[0] housekeeping_top_0/dbus_out[10] housekeeping_top_0/dbus_out[11]
+ housekeeping_top_0/dbus_out[12] housekeeping_top_0/dbus_out[13] housekeeping_top_0/dbus_out[14]
+ housekeeping_top_0/dbus_out[15] housekeeping_top_0/dbus_out[16] housekeeping_top_0/dbus_out[17]
+ housekeeping_top_0/dbus_out[18] housekeeping_top_0/dbus_out[19] housekeeping_top_0/dbus_out[1]
+ housekeeping_top_0/dbus_out[20] housekeeping_top_0/dbus_out[21] housekeeping_top_0/dbus_out[22]
+ housekeeping_top_0/dbus_out[23] housekeeping_top_0/dbus_out[2] housekeeping_top_0/dbus_out[3]
+ housekeeping_top_0/dbus_out[4] housekeeping_top_0/dbus_out[5] housekeeping_top_0/dbus_out[6]
+ housekeeping_top_0/dbus_out[7] housekeeping_top_0/dbus_out[8] housekeeping_top_0/dbus_out[9]
+ housekeeping_top_0/idac1_value[0] housekeeping_top_0/idac1_value[1] housekeeping_top_0/idac1_value[2]
+ housekeeping_top_0/idac1_value[3] housekeeping_top_0/idac1_value[4] housekeeping_top_0/idac2_value[0]
+ housekeeping_top_0/idac2_value[1] housekeeping_top_0/idac2_value[2] housekeeping_top_0/idac2_value[3]
+ housekeeping_top_0/idac2_value[4] gpio_in[0] gpio_in[10] gpio_in[11] gpio_in[1]
+ gpio_in[2] gpio_in[3] gpio_in[4] gpio_in[5] gpio_in[6] gpio_in[7] gpio_in[8] gpio_in[9]
+ gpio_oe[0] gpio_oe[10] gpio_oe[11] gpio_oe[1] gpio_oe[2] gpio_oe[3] gpio_oe[4] gpio_oe[5]
+ gpio_oe[6] gpio_oe[7] gpio_oe[8] gpio_oe[9] gpio_out[0] gpio_out[10] gpio_out[11]
+ gpio_out[1] gpio_out[2] gpio_out[3] gpio_out[4] gpio_out[5] gpio_out[6] gpio_out[7]
+ gpio_out[8] gpio_out[9] mask_rev[0] mask_rev[10] mask_rev[11] mask_rev[12] mask_rev[13]
+ mask_rev[14] mask_rev[15] mask_rev[16] mask_rev[17] mask_rev[18] mask_rev[19] mask_rev[1]
+ mask_rev[20] mask_rev[21] mask_rev[22] mask_rev[23] mask_rev[24] mask_rev[25] mask_rev[26]
+ mask_rev[27] mask_rev[28] mask_rev[29] mask_rev[2] mask_rev[30] mask_rev[31] mask_rev[3]
+ mask_rev[4] mask_rev[5] mask_rev[6] mask_rev[7] mask_rev[8] mask_rev[9] housekeeping_top_0/porb
+ housekeeping_top_0/proj_1v2_ena housekeeping_top_0/proj_3v3_ena housekeeping_top_0/proj_dig_ena
+ housekeeping_top_0/proj_ena housekeeping_top_0/proj_ibias_ena[0] housekeeping_top_0/proj_ibias_ena[1]
+ housekeeping_top_0/proj_sel[0] housekeeping_top_0/proj_sel[1] housekeeping_top_0/proj_sel[2]
+ housekeeping_top_0/proj_sel[3] housekeeping_top_0/proj_sel[4] housekeeping_top_0/proj_vbias_ena
+ analog_switch_small_1/enable housekeeping_top_0/reset SDO_ena housekeeping_top_0/sram_addr[0]
+ housekeeping_top_0/sram_addr[1] housekeeping_top_0/sram_addr[2] housekeeping_top_0/sram_addr[3]
+ housekeeping_top_0/sram_addr[4] housekeeping_top_0/sram_addr[5] housekeeping_top_0/sram_addr[6]
+ housekeeping_top_0/sram_addr[7] housekeeping_top_0/sram_addr[8] housekeeping_top_0/sram_addr[9]
+ housekeeping_top_0/sram_clk housekeeping_top_0/sram_idata[0] housekeeping_top_0/sram_idata[1]
+ housekeeping_top_0/sram_idata[2] housekeeping_top_0/sram_idata[3] housekeeping_top_0/sram_idata[4]
+ housekeeping_top_0/sram_idata[5] housekeeping_top_0/sram_idata[6] housekeeping_top_0/sram_idata[7]
+ housekeeping_top_0/sram_odata[0] housekeeping_top_0/sram_odata[1] housekeeping_top_0/sram_odata[2]
+ housekeeping_top_0/sram_odata[3] housekeeping_top_0/sram_odata[4] housekeeping_top_0/sram_odata[5]
+ housekeeping_top_0/sram_odata[6] housekeeping_top_0/sram_odata[7] housekeeping_top_0/sram_read
+ housekeeping_top_0/sram_write housekeeping_top_0/voltgen_ena[0] housekeeping_top_0/voltgen_ena[1]
+ housekeeping_top_0/voltgen_ena[2] housekeeping_top_0/voltgen_high housekeeping_top_0/voltgen_sink1[0]
+ housekeeping_top_0/voltgen_sink1[1] housekeeping_top_0/voltgen_sink1[2] housekeeping_top_0/voltgen_sink2[0]
+ housekeeping_top_0/voltgen_sink2[1] housekeeping_top_0/voltgen_sink2[2] housekeeping_top_0/voltgen_source[0]
+ housekeeping_top_0/voltgen_source[1] housekeeping_top_0/voltgen_source[2] housekeeping_top_0/voltgen_source[3]
+ housekeeping_top_0/voltgen_source[4] housekeeping_top_0/voltgen_value[0] housekeeping_top_0/voltgen_value[1]
+ housekeeping_top_0/voltgen_value[2] vddd sub housekeeping_top
.ends

.subckt sg13cmos5l_ocd_chipalooza SDO SDI CSB SCK clk vddd gpio[0] gpio[1] gpio[2]
+ gpio[3] gpio[4] gpio[5] gpio[6] gpio[7] vdd3v3 s1_an[0] s1_an[1] s2_an[0] s2_an[1]
+ s3_an[0] s3_an[1] s4_an[0] s5_an[0] s5_an[1] s5_an[2] s6_an[0] s6_an[1] s7_an[0]
+ s7_an[1] s8_an[0] s9_an[0] s9_an[1] s9_an[2] gpio[8] gpio[9] gpio[10] gpio[11] analog[0]
+ analog[1] analog[2] analog[3] s10_an[0] s10_an[1] s10_an[2] s11_an[0] s12_an[0]
+ s12_an[1] s13_an[0] s13_an[1] s14_an[0] s14_an[1] s14_an[2] s15_an[0] s16_an[0]
+ s16_an[1] s17_an[0] s17_an[1] s18_an[0] s18_an[1] vdd1v2 vss3v3
Xsg13cmos5l_padframe_0 CSB SCK gpio[11] s13_an[1] s14_an[0] s15_an[0] s17_an[0] s17_an[1]
+ s18_an[0] s18_an[1] sg13cmos5l_padframe_0/SCK_in sg13cmos5l_padframe_0/clk_in sg13cmos5l_padframe_0/gpio_0_out
+ sg13cmos5l_padframe_0/gpio_1_in sg13cmos5l_padframe_0/gpio_1_oe sg13cmos5l_padframe_0/gpio_2_out
+ sg13cmos5l_padframe_0/gpio_4_in sg13cmos5l_padframe_0/gpio_5_out sg13cmos5l_padframe_0/gpio_5_oe
+ sg13cmos5l_padframe_0/gpio_6_out sg13cmos5l_padframe_0/gpio_7_in sg13cmos5l_padframe_0/gpio_7_oe
+ sg13cmos5l_padframe_0/gpio_9_in sg13cmos5l_padframe_0/gpio_9_out sg13cmos5l_padframe_0/gpio_11_in
+ sg13cmos5l_padframe_0/analog_0_esd sg13cmos5l_padframe_0/analog_2_esd sg13cmos5l_padframe_0/s1_an_0_esd
+ sg13cmos5l_padframe_0/s1_an_1_esd sg13cmos5l_padframe_0/s2_an_0_esd sg13cmos5l_padframe_0/s2_an_1_esd
+ sg13cmos5l_padframe_0/s3_an_1_esd sg13cmos5l_padframe_0/s4_an_0_esd sg13cmos5l_padframe_0/s5_an_0_esd
+ sg13cmos5l_padframe_0/s5_an_2_esd sg13cmos5l_padframe_0/s6_an_1 sg13cmos5l_padframe_0/s7_an_0_vref
+ sg13cmos5l_padframe_0/s7_an_0_outp sg13cmos5l_padframe_0/s7_an_0_outn sg13cmos5l_padframe_0/s7_an_0_vcm
+ sg13cmos5l_padframe_0/s7_an_0_en_3v3 sg13cmos5l_padframe_0/s7_an_0_en_3v3_b sg13cmos5l_padframe_0/s7_an_0_iref
+ sg13cmos5l_padframe_0/s7_an_1_vinp sg13cmos5l_padframe_0/s7_an_1_vinn sg13cmos5l_padframe_0/s7_an_1_vref
+ sg13cmos5l_padframe_0/s7_an_1_iref sg13cmos5l_padframe_0/s7_an_1_en_3v3_b sg13cmos5l_padframe_0/s7_an_1_en_3v3
+ sg13cmos5l_padframe_0/s8_an_0_esd sg13cmos5l_padframe_0/s10_an_0_esd sg13cmos5l_padframe_0/s10_an_2_esd
+ sg13cmos5l_padframe_0/s12_an_1_esd sg13cmos5l_padframe_0/s14_an_2_esd sg13cmos5l_padframe_0/s16_an_1_esd
+ sg13cmos5l_padframe_0/s17_an_0 sg13cmos5l_padframe_0/mask_rev[7] sg13cmos5l_padframe_0/mask_rev[8]
+ sg13cmos5l_padframe_0/mask_rev[9] sg13cmos5l_padframe_0/mask_rev[10] sg13cmos5l_padframe_0/mask_rev[11]
+ sg13cmos5l_padframe_0/mask_rev[12] sg13cmos5l_padframe_0/mask_rev[14] sg13cmos5l_padframe_0/mask_rev[15]
+ sg13cmos5l_padframe_0/mask_rev[16] sg13cmos5l_padframe_0/mask_rev[17] sg13cmos5l_padframe_0/mask_rev[18]
+ sg13cmos5l_padframe_0/mask_rev[19] sg13cmos5l_padframe_0/mask_rev[20] sg13cmos5l_padframe_0/mask_rev[21]
+ sg13cmos5l_padframe_0/mask_rev[22] sg13cmos5l_padframe_0/mask_rev[23] sg13cmos5l_padframe_0/mask_rev[24]
+ sg13cmos5l_padframe_0/mask_rev[25] sg13cmos5l_padframe_0/mask_rev[26] sg13cmos5l_padframe_0/mask_rev[30]
+ sg13cmos5l_padframe_0/mask_rev[31] vdd3v3 s16_an[1] s12_an[1] s12_an[0] s8_an[0]
+ s9_an[0] s10_an[2] s10_an[1] analog[0] analog[3] chipalooza_frame_wrapper_0/s9_an_2_esd
+ SDI sg13cmos5l_padframe_0/s6_an_0 sg13cmos5l_padframe_0/s5_an_1_esd chipalooza_frame_wrapper_0/s9_an_1_esd
+ s1_an[1] sg13cmos5l_padframe_0/s10_an_1_esd gpio[7] sg13cmos5l_padframe_0/s3_an_0_esd
+ sg13cmos5l_padframe_0/gpio_8_in sg13cmos5l_padframe_0/s14_an_1_esd sg13cmos5l_padframe_0/s13_an_1
+ sg13cmos5l_padframe_0/gpio_5_in s6_an[0] s5_an[1] gpio[1] chipalooza_frame_wrapper_0/s9_an_0_esd
+ sg13cmos5l_padframe_0/analog_3_esd sg13cmos5l_padframe_0/s18_an_1_esd sg13cmos5l_padframe_0/gpio_2_in
+ sg13cmos5l_padframe_0/mask_rev[13] sg13cmos5l_padframe_0/s11_an_0_esd sg13cmos5l_padframe_0/gpio_10_out
+ gpio[4] sg13cmos5l_padframe_0/s13_an_0 sg13cmos5l_padframe_0/s12_an_0_esd s9_an[2]
+ s2_an[0] s7_an[1] s3_an[0] s2_an[1] gpio[10] sg13cmos5l_padframe_0/s14_an_0_esd
+ sg13cmos5l_padframe_0/s17_an_1 sg13cmos5l_padframe_0/gpio_2_oe sg13cmos5l_padframe_0/s15_an_0_esd
+ s14_an[1] gpio[8] sg13cmos5l_padframe_0/s16_an_0_esd analog[1] sg13cmos5l_padframe_0/SDO_ena
+ sg13cmos5l_padframe_0/s18_an_0_esd sg13cmos5l_padframe_0/gpio_4_out sg13cmos5l_padframe_0/gpio_8_oe
+ gpio[5] s16_an[0] sg13cmos5l_padframe_0/CSB_in s14_an[2] gpio[6] gpio[0] sg13cmos5l_padframe_0/mask_rev[27]
+ s5_an[0] sg13cmos5l_padframe_0/gpio_6_in vddd sg13cmos5l_padframe_0/gpio_10_oe sg13cmos5l_padframe_0/gpio_3_oe
+ sg13cmos5l_padframe_0/mask_rev[28] sg13cmos5l_padframe_0/gpio_1_out s6_an[1] sg13cmos5l_padframe_0/mask_rev[0]
+ s11_an[0] sg13cmos5l_padframe_0/mask_rev[29] sg13cmos5l_padframe_0/gpio_3_out sg13cmos5l_padframe_0/SDI_in
+ sg13cmos5l_padframe_0/mask_rev[1] sg13cmos5l_padframe_0/gpio_3_in s13_an[0] vdd1v2
+ sg13cmos5l_padframe_0/mask_rev[2] sg13cmos5l_padframe_0/analog_1_esd s4_an[0] sg13cmos5l_padframe_0/mask_rev[3]
+ sg13cmos5l_padframe_0/gpio_11_out sg13cmos5l_padframe_0/gpio_9_oe sg13cmos5l_padframe_0/gpio_6_oe
+ sg13cmos5l_padframe_0/mask_rev[4] sg13cmos5l_padframe_0/gpio_0_in s10_an[0] sg13cmos5l_padframe_0/gpio_8_out
+ gpio[2] sg13cmos5l_padframe_0/mask_rev[5] SDO s5_an[2] gpio[9] gpio[3] sg13cmos5l_padframe_0/gpio_11_oe
+ clk s3_an[1] sg13cmos5l_padframe_0/gpio_4_oe s9_an[1] sg13cmos5l_padframe_0/mask_rev[6]
+ analog[2] sg13cmos5l_padframe_0/SDO_out sg13cmos5l_padframe_0/gpio_10_in sg13cmos5l_padframe_0/gpio_7_out
+ sg13cmos5l_padframe_0/gpio_0_oe vss3v3 s7_an[0] s1_an[0] sg13cmos5l_padframe
Xchipalooza_frame_wrapper_0 vddd vdd3v3 vdd1v2 s1_an[0] s1_an[1] s2_an[0] s2_an[1]
+ s3_an[0] s3_an[1] s4_an[0] s5_an[0] s5_an[1] s5_an[2] sg13cmos5l_padframe_0/s6_an_0
+ sg13cmos5l_padframe_0/s6_an_1 s8_an[0] s9_an[0] s9_an[1] s9_an[2] analog[0] analog[1]
+ analog[2] analog[3] s10_an[0] s10_an[1] s10_an[2] s11_an[0] s12_an[0] s12_an[1]
+ sg13cmos5l_padframe_0/s13_an_0 sg13cmos5l_padframe_0/s13_an_1 s14_an[0] s14_an[1]
+ s14_an[2] s15_an[0] s16_an[0] s16_an[1] sg13cmos5l_padframe_0/s17_an_0 sg13cmos5l_padframe_0/s17_an_1
+ s18_an[0] s18_an[1] sg13cmos5l_padframe_0/SDO_out sg13cmos5l_padframe_0/SDO_ena
+ sg13cmos5l_padframe_0/SDI_in sg13cmos5l_padframe_0/CSB_in sg13cmos5l_padframe_0/SCK_in
+ sg13cmos5l_padframe_0/clk_in sg13cmos5l_padframe_0/gpio_0_in sg13cmos5l_padframe_0/gpio_0_out
+ sg13cmos5l_padframe_0/gpio_0_oe sg13cmos5l_padframe_0/gpio_1_in sg13cmos5l_padframe_0/gpio_1_out
+ sg13cmos5l_padframe_0/gpio_1_oe sg13cmos5l_padframe_0/gpio_2_in sg13cmos5l_padframe_0/gpio_2_out
+ sg13cmos5l_padframe_0/gpio_2_oe sg13cmos5l_padframe_0/gpio_3_in sg13cmos5l_padframe_0/gpio_3_out
+ sg13cmos5l_padframe_0/gpio_3_oe sg13cmos5l_padframe_0/gpio_4_in sg13cmos5l_padframe_0/gpio_4_out
+ sg13cmos5l_padframe_0/gpio_4_oe sg13cmos5l_padframe_0/gpio_5_in sg13cmos5l_padframe_0/gpio_5_out
+ sg13cmos5l_padframe_0/gpio_5_oe sg13cmos5l_padframe_0/gpio_6_in sg13cmos5l_padframe_0/gpio_6_out
+ sg13cmos5l_padframe_0/gpio_6_oe sg13cmos5l_padframe_0/gpio_7_in sg13cmos5l_padframe_0/gpio_7_out
+ sg13cmos5l_padframe_0/gpio_7_oe sg13cmos5l_padframe_0/gpio_8_in sg13cmos5l_padframe_0/gpio_8_out
+ sg13cmos5l_padframe_0/gpio_8_oe sg13cmos5l_padframe_0/gpio_9_in sg13cmos5l_padframe_0/gpio_9_out
+ sg13cmos5l_padframe_0/gpio_9_oe sg13cmos5l_padframe_0/gpio_10_in sg13cmos5l_padframe_0/gpio_10_out
+ sg13cmos5l_padframe_0/gpio_10_oe sg13cmos5l_padframe_0/gpio_11_in sg13cmos5l_padframe_0/gpio_11_out
+ sg13cmos5l_padframe_0/gpio_11_oe sg13cmos5l_padframe_0/analog_0_esd sg13cmos5l_padframe_0/analog_1_esd
+ sg13cmos5l_padframe_0/analog_2_esd sg13cmos5l_padframe_0/analog_3_esd sg13cmos5l_padframe_0/s1_an_0_esd
+ sg13cmos5l_padframe_0/s1_an_1_esd sg13cmos5l_padframe_0/s2_an_0_esd sg13cmos5l_padframe_0/s2_an_1_esd
+ sg13cmos5l_padframe_0/s3_an_0_esd sg13cmos5l_padframe_0/s3_an_1_esd sg13cmos5l_padframe_0/s4_an_0_esd
+ sg13cmos5l_padframe_0/s5_an_0_esd sg13cmos5l_padframe_0/s5_an_1_esd sg13cmos5l_padframe_0/s5_an_2_esd
+ chipalooza_frame_wrapper_0/s6_an_0_esd chipalooza_frame_wrapper_0/s6_an_1_esd sg13cmos5l_padframe_0/s8_an_0_esd
+ chipalooza_frame_wrapper_0/s9_an_0_esd chipalooza_frame_wrapper_0/s9_an_1_esd chipalooza_frame_wrapper_0/s9_an_2_esd
+ sg13cmos5l_padframe_0/s10_an_0_esd sg13cmos5l_padframe_0/s10_an_1_esd sg13cmos5l_padframe_0/s10_an_2_esd
+ sg13cmos5l_padframe_0/s11_an_0_esd sg13cmos5l_padframe_0/s12_an_0_esd sg13cmos5l_padframe_0/s12_an_1_esd
+ chipalooza_frame_wrapper_0/s13_an_0_esd chipalooza_frame_wrapper_0/s13_an_1_esd
+ sg13cmos5l_padframe_0/s14_an_0_esd sg13cmos5l_padframe_0/s14_an_1_esd sg13cmos5l_padframe_0/s14_an_2_esd
+ sg13cmos5l_padframe_0/s15_an_0_esd sg13cmos5l_padframe_0/s16_an_0_esd sg13cmos5l_padframe_0/s16_an_1_esd
+ chipalooza_frame_wrapper_0/s17_an_0_esd chipalooza_frame_wrapper_0/s17_an_1_esd
+ sg13cmos5l_padframe_0/s18_an_0_esd sg13cmos5l_padframe_0/s18_an_1_esd sg13cmos5l_padframe_0/mask_rev[0]
+ sg13cmos5l_padframe_0/mask_rev[1] sg13cmos5l_padframe_0/mask_rev[2] sg13cmos5l_padframe_0/mask_rev[3]
+ sg13cmos5l_padframe_0/mask_rev[4] sg13cmos5l_padframe_0/mask_rev[5] sg13cmos5l_padframe_0/mask_rev[6]
+ sg13cmos5l_padframe_0/mask_rev[7] sg13cmos5l_padframe_0/mask_rev[8] sg13cmos5l_padframe_0/mask_rev[9]
+ sg13cmos5l_padframe_0/mask_rev[20] sg13cmos5l_padframe_0/mask_rev[21] sg13cmos5l_padframe_0/mask_rev[22]
+ sg13cmos5l_padframe_0/mask_rev[23] sg13cmos5l_padframe_0/mask_rev[24] sg13cmos5l_padframe_0/mask_rev[25]
+ sg13cmos5l_padframe_0/mask_rev[26] vdd1v2 vdd1v2 sg13cmos5l_padframe_0/s7_an_0_vcm
+ sg13cmos5l_padframe_0/s7_an_0_vref sg13cmos5l_padframe_0/mask_rev[27] sg13cmos5l_padframe_0/s7_an_0_en_3v3_b
+ sg13cmos5l_padframe_0/mask_rev[28] sg13cmos5l_padframe_0/mask_rev[29] sg13cmos5l_padframe_0/s7_an_0_outp
+ sg13cmos5l_padframe_0/s7_an_0_outn sg13cmos5l_padframe_0/mask_rev[10] sg13cmos5l_padframe_0/s7_an_1_vref
+ sg13cmos5l_padframe_0/mask_rev[11] sg13cmos5l_padframe_0/s7_an_1_en_3v3_b sg13cmos5l_padframe_0/mask_rev[13]
+ sg13cmos5l_padframe_0/mask_rev[12] sg13cmos5l_padframe_0/s7_an_1_en_3v3 sg13cmos5l_padframe_0/mask_rev[13]
+ sg13cmos5l_padframe_0/s7_an_1_vinp sg13cmos5l_padframe_0/mask_rev[30] sg13cmos5l_padframe_0/mask_rev[14]
+ sg13cmos5l_padframe_0/mask_rev[31] sg13cmos5l_padframe_0/s7_an_0_iref sg13cmos5l_padframe_0/mask_rev[15]
+ sg13cmos5l_padframe_0/s7_an_1_vinn sg13cmos5l_padframe_0/mask_rev[16] sg13cmos5l_padframe_0/mask_rev[17]
+ sg13cmos5l_padframe_0/mask_rev[18] sg13cmos5l_padframe_0/s7_an_0_en_3v3 sg13cmos5l_padframe_0/mask_rev[19]
+ sg13cmos5l_padframe_0/s7_an_1_iref vss3v3 chipalooza_frame
.ends
