* Housekeeping top level black-box schematic
.subckt housekeeping_top SDI mask_rev_in[31] mask_rev_in[30] mask_rev_in[29] mask_rev_in[28] mask_rev_in[27] mask_rev_in[26] mask_rev_in[25] mask_rev_in[24]
+ mask_rev_in[23] mask_rev_in[22] mask_rev_in[21] mask_rev_in[20] mask_rev_in[19] mask_rev_in[18] mask_rev_in[17] mask_rev_in[16] mask_rev_in[15] mask_rev_in[14] mask_rev_in[13]
+ mask_rev_in[12] mask_rev_in[11] mask_rev_in[10] mask_rev_in[9] mask_rev_in[8] mask_rev_in[7] mask_rev_in[6] mask_rev_in[5] mask_rev_in[4] mask_rev_in[3] mask_rev_in[2]
+ mask_rev_in[1] mask_rev_in[0] CSB status[127] status[126] status[125] status[124] status[123] status[122] status[121] status[120]
+ status[119] status[118] status[117] status[116] status[115] status[114] status[113] status[112] status[111] status[110] status[109]
+ status[108] status[107] status[106] status[105] status[104] status[103] status[102] status[101] status[100] status[99] status[98] status[97]
+ status[96] status[95] status[94] status[93] status[92] status[91] status[90] status[89] status[88] status[87] status[86] status[85]
+ status[84] status[83] status[82] status[81] status[80] status[79] status[78] status[77] status[76] status[75] status[74] status[73]
+ status[72] status[71] status[70] status[69] status[68] status[67] status[66] status[65] status[64] status[63] status[62] status[61]
+ status[60] status[59] status[58] status[57] status[56] status[55] status[54] status[53] status[52] status[51] status[50] status[49]
+ status[48] status[47] status[46] status[45] status[44] status[43] status[42] status[41] status[40] status[39] status[38] status[37]
+ status[36] status[35] status[34] status[33] status[32] status[31] status[30] status[29] status[28] status[27] status[26] status[25]
+ status[24] status[23] status[22] status[21] status[20] status[19] status[18] status[17] status[16] status[15] status[14] status[13]
+ status[12] status[11] status[10] status[9] status[8] status[7] status[6] status[5] status[4] status[3] status[2] status[1] status[0]
+ SDO sdo_ena vccd vssd RSTB reset SCK control[127] control[126] control[125] control[124] control[123] control[122]
+ control[121] control[120] control[119] control[118] control[117] control[116] control[115] control[114] control[113] control[112] control[111]
+ control[110] control[109] control[108] control[107] control[106] control[105] control[104] control[103] control[102] control[101] control[100]
+ control[99] control[98] control[97] control[96] control[95] control[94] control[93] control[92] control[91] control[90] control[89]
+ control[88] control[87] control[86] control[85] control[84] control[83] control[82] control[81] control[80] control[79] control[78]
+ control[77] control[76] control[75] control[74] control[73] control[72] control[71] control[70] control[69] control[68] control[67]
+ control[66] control[65] control[64] control[63] control[62] control[61] control[60] control[59] control[58] control[57] control[56]
+ control[55] control[54] control[53] control[52] control[51] control[50] control[49] control[48] control[47] control[46] control[45]
+ control[44] control[43] control[42] control[41] control[40] control[39] control[38] control[37] control[36] control[35] control[34]
+ control[33] control[32] control[31] control[30] control[29] control[28] control[27] control[26] control[25] control[24] control[23]
+ control[22] control[21] control[20] control[19] control[18] control[17] control[16] control[15] control[14] control[13] control[12]
+ control[11] control[10] control[9] control[8] control[7] control[6] control[5] control[4] control[3] control[2] control[1] control[0]
* NO CONTENT
.ends
